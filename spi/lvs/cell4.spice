* NGSPICE file created from cell4.ext - technology: sky130A

* Black-box entry subcircuit for sky130_fd_sc_hd__a221o_1 abstract view
.subckt sky130_fd_sc_hd__a221o_1 A1 A2 B1 B2 C1 VGND VNB VPB VPWR X
.ends

* Black-box entry subcircuit for sky130_fd_sc_hd__tapvpwrvgnd_1 abstract view
.subckt sky130_fd_sc_hd__tapvpwrvgnd_1 VGND VPWR
.ends

* Black-box entry subcircuit for sky130_fd_sc_hd__o31a_1 abstract view
.subckt sky130_fd_sc_hd__o31a_1 A1 A2 A3 B1 VGND VNB VPB VPWR X
.ends

* Black-box entry subcircuit for sky130_fd_sc_hd__fill_2 abstract view
.subckt sky130_fd_sc_hd__fill_2 VGND VNB VPB VPWR
.ends

* Black-box entry subcircuit for sky130_fd_sc_hd__mux2_1 abstract view
.subckt sky130_fd_sc_hd__mux2_1 A0 A1 S VGND VNB VPB VPWR X
.ends

* Black-box entry subcircuit for sky130_fd_sc_hd__a21oi_1 abstract view
.subckt sky130_fd_sc_hd__a21oi_1 A1 A2 B1 VGND VNB VPB VPWR Y
.ends

* Black-box entry subcircuit for sky130_fd_sc_hd__a31o_1 abstract view
.subckt sky130_fd_sc_hd__a31o_1 A1 A2 A3 B1 VGND VNB VPB VPWR X
.ends

* Black-box entry subcircuit for sky130_fd_sc_hd__diode_2 abstract view
.subckt sky130_fd_sc_hd__diode_2 DIODE VGND VNB VPB VPWR
.ends

* Black-box entry subcircuit for sky130_fd_sc_hd__a311o_4 abstract view
.subckt sky130_fd_sc_hd__a311o_4 A1 A2 A3 B1 C1 VGND VNB VPB VPWR X
.ends

* Black-box entry subcircuit for sky130_fd_sc_hd__o21ba_1 abstract view
.subckt sky130_fd_sc_hd__o21ba_1 A1 A2 B1_N VGND VNB VPB VPWR X
.ends

* Black-box entry subcircuit for sky130_fd_sc_hd__a211o_1 abstract view
.subckt sky130_fd_sc_hd__a211o_1 A1 A2 B1 C1 VGND VNB VPB VPWR X
.ends

* Black-box entry subcircuit for sky130_fd_sc_hd__o22a_1 abstract view
.subckt sky130_fd_sc_hd__o22a_1 A1 A2 B1 B2 VGND VNB VPB VPWR X
.ends

* Black-box entry subcircuit for sky130_fd_sc_hd__dlygate4sd3_1 abstract view
.subckt sky130_fd_sc_hd__dlygate4sd3_1 A VGND VNB VPB VPWR X
.ends

* Black-box entry subcircuit for sky130_fd_sc_hd__fill_1 abstract view
.subckt sky130_fd_sc_hd__fill_1 VGND VNB VPB VPWR
.ends

* Black-box entry subcircuit for sky130_fd_sc_hd__fill_4 abstract view
.subckt sky130_fd_sc_hd__fill_4 VGND VNB VPB VPWR
.ends

* Black-box entry subcircuit for sky130_fd_sc_hd__buf_2 abstract view
.subckt sky130_fd_sc_hd__buf_2 A VGND VNB VPB VPWR X
.ends

* Black-box entry subcircuit for sky130_fd_sc_hd__clkbuf_4 abstract view
.subckt sky130_fd_sc_hd__clkbuf_4 A VGND VNB VPB VPWR X
.ends

* Black-box entry subcircuit for sky130_fd_sc_hd__clkbuf_2 abstract view
.subckt sky130_fd_sc_hd__clkbuf_2 A VGND VNB VPB VPWR X
.ends

* Black-box entry subcircuit for sky130_fd_sc_hd__and2b_1 abstract view
.subckt sky130_fd_sc_hd__and2b_1 A_N B VGND VNB VPB VPWR X
.ends

* Black-box entry subcircuit for sky130_ef_sc_hd__decap_40_12 abstract view
.subckt sky130_ef_sc_hd__decap_40_12 VPWR VGND VPB VNB
.ends

* Black-box entry subcircuit for sky130_fd_sc_hd__dfstp_1 abstract view
.subckt sky130_fd_sc_hd__dfstp_1 CLK D SET_B VGND VNB VPB VPWR Q
.ends

* Black-box entry subcircuit for sky130_fd_sc_hd__mux4_1 abstract view
.subckt sky130_fd_sc_hd__mux4_1 A0 A1 A2 A3 S0 S1 VGND VNB VPB VPWR X
.ends

* Black-box entry subcircuit for sky130_fd_sc_hd__dfrtp_1 abstract view
.subckt sky130_fd_sc_hd__dfrtp_1 CLK D RESET_B VGND VNB VPB VPWR Q
.ends

* Black-box entry subcircuit for sky130_fd_sc_hd__nor2_1 abstract view
.subckt sky130_fd_sc_hd__nor2_1 A B VGND VNB VPB VPWR Y
.ends

* Black-box entry subcircuit for sky130_fd_sc_hd__a221oi_1 abstract view
.subckt sky130_fd_sc_hd__a221oi_1 A1 A2 B1 B2 C1 VGND VNB VPB VPWR Y
.ends

* Black-box entry subcircuit for sky130_fd_sc_hd__or2_1 abstract view
.subckt sky130_fd_sc_hd__or2_1 A B VGND VNB VPB VPWR X
.ends

* Black-box entry subcircuit for sky130_fd_sc_hd__a21bo_1 abstract view
.subckt sky130_fd_sc_hd__a21bo_1 A1 A2 B1_N VGND VNB VPB VPWR X
.ends

* Black-box entry subcircuit for sky130_fd_sc_hd__nand2_1 abstract view
.subckt sky130_fd_sc_hd__nand2_1 A B VGND VNB VPB VPWR Y
.ends

* Black-box entry subcircuit for sky130_fd_sc_hd__or3b_2 abstract view
.subckt sky130_fd_sc_hd__or3b_2 A B C_N VGND VNB VPB VPWR X
.ends

* Black-box entry subcircuit for sky130_fd_sc_hd__o211a_1 abstract view
.subckt sky130_fd_sc_hd__o211a_1 A1 A2 B1 C1 VGND VNB VPB VPWR X
.ends

* Black-box entry subcircuit for sky130_fd_sc_hd__a32o_1 abstract view
.subckt sky130_fd_sc_hd__a32o_1 A1 A2 A3 B1 B2 VGND VNB VPB VPWR X
.ends

* Black-box entry subcircuit for sky130_fd_sc_hd__a21o_1 abstract view
.subckt sky130_fd_sc_hd__a21o_1 A1 A2 B1 VGND VNB VPB VPWR X
.ends

* Black-box entry subcircuit for sky130_fd_sc_hd__o221a_1 abstract view
.subckt sky130_fd_sc_hd__o221a_1 A1 A2 B1 B2 C1 VGND VNB VPB VPWR X
.ends

* Black-box entry subcircuit for sky130_fd_sc_hd__and2_1 abstract view
.subckt sky130_fd_sc_hd__and2_1 A B VGND VNB VPB VPWR X
.ends

* Black-box entry subcircuit for sky130_fd_sc_hd__nand2b_1 abstract view
.subckt sky130_fd_sc_hd__nand2b_1 A_N B VGND VNB VPB VPWR Y
.ends

* Black-box entry subcircuit for sky130_fd_sc_hd__fill_8 abstract view
.subckt sky130_fd_sc_hd__fill_8 VGND VNB VPB VPWR
.ends

* Black-box entry subcircuit for sky130_fd_sc_hd__dfstp_2 abstract view
.subckt sky130_fd_sc_hd__dfstp_2 CLK D SET_B VGND VNB VPB VPWR Q
.ends

* Black-box entry subcircuit for sky130_fd_sc_hd__a211oi_2 abstract view
.subckt sky130_fd_sc_hd__a211oi_2 A1 A2 B1 C1 VGND VNB VPB VPWR Y
.ends

* Black-box entry subcircuit for sky130_fd_sc_hd__inv_2 abstract view
.subckt sky130_fd_sc_hd__inv_2 A VGND VNB VPB VPWR Y
.ends

* Black-box entry subcircuit for sky130_fd_sc_hd__a22o_1 abstract view
.subckt sky130_fd_sc_hd__a22o_1 A1 A2 B1 B2 VGND VNB VPB VPWR X
.ends

* Black-box entry subcircuit for sky130_fd_sc_hd__clkbuf_8 abstract view
.subckt sky130_fd_sc_hd__clkbuf_8 A VGND VNB VPB VPWR X
.ends

* Black-box entry subcircuit for sky130_fd_sc_hd__a221o_2 abstract view
.subckt sky130_fd_sc_hd__a221o_2 A1 A2 B1 B2 C1 VGND VNB VPB VPWR X
.ends

* Black-box entry subcircuit for sky130_fd_sc_hd__o41a_1 abstract view
.subckt sky130_fd_sc_hd__o41a_1 A1 A2 A3 A4 B1 VGND VNB VPB VPWR X
.ends

* Black-box entry subcircuit for sky130_fd_sc_hd__a41o_1 abstract view
.subckt sky130_fd_sc_hd__a41o_1 A1 A2 A3 A4 B1 VGND VNB VPB VPWR X
.ends

* Black-box entry subcircuit for sky130_fd_sc_hd__and3_1 abstract view
.subckt sky130_fd_sc_hd__and3_1 A B C VGND VNB VPB VPWR X
.ends

* Black-box entry subcircuit for sky130_fd_sc_hd__decap_3 abstract view
.subckt sky130_fd_sc_hd__decap_3 VGND VNB VPB VPWR
.ends

* Black-box entry subcircuit for sky130_fd_sc_hd__and4b_1 abstract view
.subckt sky130_fd_sc_hd__and4b_1 A_N B C D VGND VNB VPB VPWR X
.ends

* Black-box entry subcircuit for sky130_fd_sc_hd__buf_1 abstract view
.subckt sky130_fd_sc_hd__buf_1 A VGND VNB VPB VPWR X
.ends

* Black-box entry subcircuit for sky130_fd_sc_hd__a311o_2 abstract view
.subckt sky130_fd_sc_hd__a311o_2 A1 A2 A3 B1 C1 VGND VNB VPB VPWR X
.ends

* Black-box entry subcircuit for sky130_fd_sc_hd__nand2_2 abstract view
.subckt sky130_fd_sc_hd__nand2_2 A B VGND VNB VPB VPWR Y
.ends

* Black-box entry subcircuit for sky130_fd_sc_hd__o32a_1 abstract view
.subckt sky130_fd_sc_hd__o32a_1 A1 A2 A3 B1 B2 VGND VNB VPB VPWR X
.ends

* Black-box entry subcircuit for sky130_fd_sc_hd__o311a_1 abstract view
.subckt sky130_fd_sc_hd__o311a_1 A1 A2 A3 B1 C1 VGND VNB VPB VPWR X
.ends

* Black-box entry subcircuit for sky130_fd_sc_hd__or2_4 abstract view
.subckt sky130_fd_sc_hd__or2_4 A B VGND VNB VPB VPWR X
.ends

* Black-box entry subcircuit for sky130_fd_sc_hd__or3_1 abstract view
.subckt sky130_fd_sc_hd__or3_1 A B C VGND VNB VPB VPWR X
.ends

* Black-box entry subcircuit for sky130_fd_sc_hd__o211ai_2 abstract view
.subckt sky130_fd_sc_hd__o211ai_2 A1 A2 B1 C1 VGND VNB VPB VPWR Y
.ends

* Black-box entry subcircuit for sky130_fd_sc_hd__mux2_2 abstract view
.subckt sky130_fd_sc_hd__mux2_2 A0 A1 S VGND VNB VPB VPWR X
.ends

* Black-box entry subcircuit for sky130_fd_sc_hd__a2bb2o_1 abstract view
.subckt sky130_fd_sc_hd__a2bb2o_1 A1_N A2_N B1 B2 VGND VNB VPB VPWR X
.ends

* Black-box entry subcircuit for sky130_fd_sc_hd__xnor2_2 abstract view
.subckt sky130_fd_sc_hd__xnor2_2 A B VGND VNB VPB VPWR Y
.ends

* Black-box entry subcircuit for sky130_fd_sc_hd__and2b_2 abstract view
.subckt sky130_fd_sc_hd__and2b_2 A_N B VGND VNB VPB VPWR X
.ends

* Black-box entry subcircuit for sky130_fd_sc_hd__o21ai_1 abstract view
.subckt sky130_fd_sc_hd__o21ai_1 A1 A2 B1 VGND VNB VPB VPWR Y
.ends

* Black-box entry subcircuit for sky130_fd_sc_hd__a311oi_4 abstract view
.subckt sky130_fd_sc_hd__a311oi_4 A1 A2 A3 B1 C1 VGND VNB VPB VPWR Y
.ends

* Black-box entry subcircuit for sky130_fd_sc_hd__o31ai_2 abstract view
.subckt sky130_fd_sc_hd__o31ai_2 A1 A2 A3 B1 VGND VNB VPB VPWR Y
.ends

* Black-box entry subcircuit for sky130_fd_sc_hd__dlymetal6s2s_1 abstract view
.subckt sky130_fd_sc_hd__dlymetal6s2s_1 A VGND VNB VPB VPWR X
.ends

* Black-box entry subcircuit for sky130_fd_sc_hd__nor3_1 abstract view
.subckt sky130_fd_sc_hd__nor3_1 A B C VGND VNB VPB VPWR Y
.ends

* Black-box entry subcircuit for sky130_fd_sc_hd__a311oi_2 abstract view
.subckt sky130_fd_sc_hd__a311oi_2 A1 A2 A3 B1 C1 VGND VNB VPB VPWR Y
.ends

* Black-box entry subcircuit for sky130_fd_sc_hd__o211ai_1 abstract view
.subckt sky130_fd_sc_hd__o211ai_1 A1 A2 B1 C1 VGND VNB VPB VPWR Y
.ends

* Black-box entry subcircuit for sky130_fd_sc_hd__nand3_1 abstract view
.subckt sky130_fd_sc_hd__nand3_1 A B C VGND VNB VPB VPWR Y
.ends

* Black-box entry subcircuit for sky130_fd_sc_hd__nand3b_4 abstract view
.subckt sky130_fd_sc_hd__nand3b_4 A_N B C VGND VNB VPB VPWR Y
.ends

* Black-box entry subcircuit for sky130_fd_sc_hd__nor3b_1 abstract view
.subckt sky130_fd_sc_hd__nor3b_1 A B C_N VGND VNB VPB VPWR Y
.ends

* Black-box entry subcircuit for sky130_fd_sc_hd__clkbuf_16 abstract view
.subckt sky130_fd_sc_hd__clkbuf_16 A VGND VNB VPB VPWR X
.ends

* Black-box entry subcircuit for sky130_fd_sc_hd__a2111o_1 abstract view
.subckt sky130_fd_sc_hd__a2111o_1 A1 A2 B1 C1 D1 VGND VNB VPB VPWR X
.ends

* Black-box entry subcircuit for sky130_fd_sc_hd__a211oi_1 abstract view
.subckt sky130_fd_sc_hd__a211oi_1 A1 A2 B1 C1 VGND VNB VPB VPWR Y
.ends

* Black-box entry subcircuit for sky130_fd_sc_hd__clkinvlp_4 abstract view
.subckt sky130_fd_sc_hd__clkinvlp_4 A VGND VNB VPB VPWR Y
.ends

* Black-box entry subcircuit for sky130_fd_sc_hd__inv_6 abstract view
.subckt sky130_fd_sc_hd__inv_6 A VGND VNB VPB VPWR Y
.ends

* Black-box entry subcircuit for sky130_fd_sc_hd__o21a_1 abstract view
.subckt sky130_fd_sc_hd__o21a_1 A1 A2 B1 VGND VNB VPB VPWR X
.ends

* Black-box entry subcircuit for sky130_fd_sc_hd__nor2_4 abstract view
.subckt sky130_fd_sc_hd__nor2_4 A B VGND VNB VPB VPWR Y
.ends

* Black-box entry subcircuit for sky130_fd_sc_hd__a311o_1 abstract view
.subckt sky130_fd_sc_hd__a311o_1 A1 A2 A3 B1 C1 VGND VNB VPB VPWR X
.ends

* Black-box entry subcircuit for sky130_fd_sc_hd__xor2_2 abstract view
.subckt sky130_fd_sc_hd__xor2_2 A B VGND VNB VPB VPWR X
.ends

* Black-box entry subcircuit for sky130_fd_sc_hd__o21ba_2 abstract view
.subckt sky130_fd_sc_hd__o21ba_2 A1 A2 B1_N VGND VNB VPB VPWR X
.ends

* Black-box entry subcircuit for sky130_fd_sc_hd__a22oi_1 abstract view
.subckt sky130_fd_sc_hd__a22oi_1 A1 A2 B1 B2 VGND VNB VPB VPWR Y
.ends

* Black-box entry subcircuit for sky130_fd_sc_hd__o21ai_4 abstract view
.subckt sky130_fd_sc_hd__o21ai_4 A1 A2 B1 VGND VNB VPB VPWR Y
.ends

* Black-box entry subcircuit for sky130_fd_sc_hd__and2_2 abstract view
.subckt sky130_fd_sc_hd__and2_2 A B VGND VNB VPB VPWR X
.ends

* Black-box entry subcircuit for sky130_fd_sc_hd__a211o_4 abstract view
.subckt sky130_fd_sc_hd__a211o_4 A1 A2 B1 C1 VGND VNB VPB VPWR X
.ends

* Black-box entry subcircuit for sky130_fd_sc_hd__and3b_2 abstract view
.subckt sky130_fd_sc_hd__and3b_2 A_N B C VGND VNB VPB VPWR X
.ends

* Black-box entry subcircuit for sky130_fd_sc_hd__and3b_1 abstract view
.subckt sky130_fd_sc_hd__and3b_1 A_N B C VGND VNB VPB VPWR X
.ends

* Black-box entry subcircuit for sky130_fd_sc_hd__or4b_1 abstract view
.subckt sky130_fd_sc_hd__or4b_1 A B C D_N VGND VNB VPB VPWR X
.ends

* Black-box entry subcircuit for sky130_fd_sc_hd__or4bb_1 abstract view
.subckt sky130_fd_sc_hd__or4bb_1 A B C_N D_N VGND VNB VPB VPWR X
.ends

* Black-box entry subcircuit for sky130_fd_sc_hd__a21boi_1 abstract view
.subckt sky130_fd_sc_hd__a21boi_1 A1 A2 B1_N VGND VNB VPB VPWR Y
.ends

* Black-box entry subcircuit for sky130_fd_sc_hd__clkinv_1 abstract view
.subckt sky130_fd_sc_hd__clkinv_1 A VGND VNB VPB VPWR Y
.ends

* Black-box entry subcircuit for sky130_fd_sc_hd__clkinv_8 abstract view
.subckt sky130_fd_sc_hd__clkinv_8 A VGND VNB VPB VPWR Y
.ends

* Black-box entry subcircuit for sky130_fd_sc_hd__inv_12 abstract view
.subckt sky130_fd_sc_hd__inv_12 A VGND VNB VPB VPWR Y
.ends

* Black-box entry subcircuit for sky130_fd_sc_hd__or3b_1 abstract view
.subckt sky130_fd_sc_hd__or3b_1 A B C_N VGND VNB VPB VPWR X
.ends

* Black-box entry subcircuit for sky130_fd_sc_hd__nand2_4 abstract view
.subckt sky130_fd_sc_hd__nand2_4 A B VGND VNB VPB VPWR Y
.ends

* Black-box entry subcircuit for sky130_fd_sc_hd__or3_2 abstract view
.subckt sky130_fd_sc_hd__or3_2 A B C VGND VNB VPB VPWR X
.ends

* Black-box entry subcircuit for sky130_fd_sc_hd__o21bai_1 abstract view
.subckt sky130_fd_sc_hd__o21bai_1 A1 A2 B1_N VGND VNB VPB VPWR Y
.ends

* Black-box entry subcircuit for sky130_fd_sc_hd__dfrtp_2 abstract view
.subckt sky130_fd_sc_hd__dfrtp_2 CLK D RESET_B VGND VNB VPB VPWR Q
.ends

* Black-box entry subcircuit for sky130_fd_sc_hd__o32a_2 abstract view
.subckt sky130_fd_sc_hd__o32a_2 A1 A2 A3 B1 B2 VGND VNB VPB VPWR X
.ends

* Black-box entry subcircuit for sky130_fd_sc_hd__a31o_4 abstract view
.subckt sky130_fd_sc_hd__a31o_4 A1 A2 A3 B1 VGND VNB VPB VPWR X
.ends

* Black-box entry subcircuit for sky130_fd_sc_hd__o31ai_1 abstract view
.subckt sky130_fd_sc_hd__o31ai_1 A1 A2 A3 B1 VGND VNB VPB VPWR Y
.ends

* Black-box entry subcircuit for sky130_fd_sc_hd__a22oi_2 abstract view
.subckt sky130_fd_sc_hd__a22oi_2 A1 A2 B1 B2 VGND VNB VPB VPWR Y
.ends

* Black-box entry subcircuit for sky130_fd_sc_hd__o211a_4 abstract view
.subckt sky130_fd_sc_hd__o211a_4 A1 A2 B1 C1 VGND VNB VPB VPWR X
.ends

* Black-box entry subcircuit for sky130_fd_sc_hd__nor2_2 abstract view
.subckt sky130_fd_sc_hd__nor2_2 A B VGND VNB VPB VPWR Y
.ends

* Black-box entry subcircuit for sky130_fd_sc_hd__or2_2 abstract view
.subckt sky130_fd_sc_hd__or2_2 A B VGND VNB VPB VPWR X
.ends

* Black-box entry subcircuit for sky130_fd_sc_hd__clkbuf_1 abstract view
.subckt sky130_fd_sc_hd__clkbuf_1 A VGND VNB VPB VPWR X
.ends

* Black-box entry subcircuit for sky130_fd_sc_hd__o2bb2a_1 abstract view
.subckt sky130_fd_sc_hd__o2bb2a_1 A1_N A2_N B1 B2 VGND VNB VPB VPWR X
.ends

* Black-box entry subcircuit for sky130_fd_sc_hd__o21ai_2 abstract view
.subckt sky130_fd_sc_hd__o21ai_2 A1 A2 B1 VGND VNB VPB VPWR Y
.ends

* Black-box entry subcircuit for sky130_fd_sc_hd__o2111a_1 abstract view
.subckt sky130_fd_sc_hd__o2111a_1 A1 A2 B1 C1 D1 VGND VNB VPB VPWR X
.ends

* Black-box entry subcircuit for sky130_fd_sc_hd__nand2b_2 abstract view
.subckt sky130_fd_sc_hd__nand2b_2 A_N B VGND VNB VPB VPWR Y
.ends

* Black-box entry subcircuit for sky130_fd_sc_hd__a31o_2 abstract view
.subckt sky130_fd_sc_hd__a31o_2 A1 A2 A3 B1 VGND VNB VPB VPWR X
.ends

* Black-box entry subcircuit for sky130_fd_sc_hd__buf_4 abstract view
.subckt sky130_fd_sc_hd__buf_4 A VGND VNB VPB VPWR X
.ends

* Black-box entry subcircuit for sky130_fd_sc_hd__a21boi_4 abstract view
.subckt sky130_fd_sc_hd__a21boi_4 A1 A2 B1_N VGND VNB VPB VPWR Y
.ends

* Black-box entry subcircuit for sky130_fd_sc_hd__inv_16 abstract view
.subckt sky130_fd_sc_hd__inv_16 A VGND VNB VPB VPWR Y
.ends

* Black-box entry subcircuit for sky130_fd_sc_hd__inv_8 abstract view
.subckt sky130_fd_sc_hd__inv_8 A VGND VNB VPB VPWR Y
.ends

* Black-box entry subcircuit for sky130_fd_sc_hd__and4_1 abstract view
.subckt sky130_fd_sc_hd__and4_1 A B C D VGND VNB VPB VPWR X
.ends

* Black-box entry subcircuit for sky130_fd_sc_hd__a21oi_2 abstract view
.subckt sky130_fd_sc_hd__a21oi_2 A1 A2 B1 VGND VNB VPB VPWR Y
.ends

* Black-box entry subcircuit for sky130_fd_sc_hd__clkinv_4 abstract view
.subckt sky130_fd_sc_hd__clkinv_4 A VGND VNB VPB VPWR Y
.ends

* Black-box entry subcircuit for sky130_fd_sc_hd__nand3b_1 abstract view
.subckt sky130_fd_sc_hd__nand3b_1 A_N B C VGND VNB VPB VPWR Y
.ends

* Black-box entry subcircuit for sky130_fd_sc_hd__a22o_2 abstract view
.subckt sky130_fd_sc_hd__a22o_2 A1 A2 B1 B2 VGND VNB VPB VPWR X
.ends

* Black-box entry subcircuit for sky130_fd_sc_hd__o31ai_4 abstract view
.subckt sky130_fd_sc_hd__o31ai_4 A1 A2 A3 B1 VGND VNB VPB VPWR Y
.ends

* Black-box entry subcircuit for sky130_fd_sc_hd__bufinv_16 abstract view
.subckt sky130_fd_sc_hd__bufinv_16 A VGND VNB VPB VPWR Y
.ends

* Black-box entry subcircuit for sky130_fd_sc_hd__o221a_2 abstract view
.subckt sky130_fd_sc_hd__o221a_2 A1 A2 B1 B2 C1 VGND VNB VPB VPWR X
.ends

* Black-box entry subcircuit for sky130_fd_sc_hd__a31oi_1 abstract view
.subckt sky130_fd_sc_hd__a31oi_1 A1 A2 A3 B1 VGND VNB VPB VPWR Y
.ends

* Black-box entry subcircuit for sky130_fd_sc_hd__o311a_4 abstract view
.subckt sky130_fd_sc_hd__o311a_4 A1 A2 A3 B1 C1 VGND VNB VPB VPWR X
.ends

* Black-box entry subcircuit for sky130_fd_sc_hd__inv_4 abstract view
.subckt sky130_fd_sc_hd__inv_4 A VGND VNB VPB VPWR Y
.ends

* Black-box entry subcircuit for sky130_fd_sc_hd__o211a_2 abstract view
.subckt sky130_fd_sc_hd__o211a_2 A1 A2 B1 C1 VGND VNB VPB VPWR X
.ends

* Black-box entry subcircuit for sky130_fd_sc_hd__a211o_2 abstract view
.subckt sky130_fd_sc_hd__a211o_2 A1 A2 B1 C1 VGND VNB VPB VPWR X
.ends

* Black-box entry subcircuit for sky130_fd_sc_hd__and2b_4 abstract view
.subckt sky130_fd_sc_hd__and2b_4 A_N B VGND VNB VPB VPWR X
.ends

* Black-box entry subcircuit for sky130_fd_sc_hd__nand3_2 abstract view
.subckt sky130_fd_sc_hd__nand3_2 A B C VGND VNB VPB VPWR Y
.ends

* Black-box entry subcircuit for sky130_fd_sc_hd__and4bb_1 abstract view
.subckt sky130_fd_sc_hd__and4bb_1 A_N B_N C D VGND VNB VPB VPWR X
.ends

* Black-box entry subcircuit for sky130_fd_sc_hd__or3b_4 abstract view
.subckt sky130_fd_sc_hd__or3b_4 A B C_N VGND VNB VPB VPWR X
.ends

* Black-box entry subcircuit for sky130_fd_sc_hd__a21oi_4 abstract view
.subckt sky130_fd_sc_hd__a21oi_4 A1 A2 B1 VGND VNB VPB VPWR Y
.ends

* Black-box entry subcircuit for sky130_fd_sc_hd__clkinv_2 abstract view
.subckt sky130_fd_sc_hd__clkinv_2 A VGND VNB VPB VPWR Y
.ends

* Black-box entry subcircuit for sky130_fd_sc_hd__mux4_2 abstract view
.subckt sky130_fd_sc_hd__mux4_2 A0 A1 A2 A3 S0 S1 VGND VNB VPB VPWR X
.ends

* Black-box entry subcircuit for sky130_fd_sc_hd__o221ai_4 abstract view
.subckt sky130_fd_sc_hd__o221ai_4 A1 A2 B1 B2 C1 VGND VNB VPB VPWR Y
.ends

* Black-box entry subcircuit for sky130_fd_sc_hd__dfrtp_4 abstract view
.subckt sky130_fd_sc_hd__dfrtp_4 CLK D RESET_B VGND VNB VPB VPWR Q
.ends

* Black-box entry subcircuit for sky130_fd_sc_hd__a31oi_2 abstract view
.subckt sky130_fd_sc_hd__a31oi_2 A1 A2 A3 B1 VGND VNB VPB VPWR Y
.ends

* Black-box entry subcircuit for sky130_fd_sc_hd__a31oi_4 abstract view
.subckt sky130_fd_sc_hd__a31oi_4 A1 A2 A3 B1 VGND VNB VPB VPWR Y
.ends

* Black-box entry subcircuit for sky130_fd_sc_hd__and3_2 abstract view
.subckt sky130_fd_sc_hd__and3_2 A B C VGND VNB VPB VPWR X
.ends

* Black-box entry subcircuit for sky130_fd_sc_hd__nand3b_2 abstract view
.subckt sky130_fd_sc_hd__nand3b_2 A_N B C VGND VNB VPB VPWR Y
.ends

* Black-box entry subcircuit for sky130_fd_sc_hd__clkinv_16 abstract view
.subckt sky130_fd_sc_hd__clkinv_16 A VGND VNB VPB VPWR Y
.ends

* Black-box entry subcircuit for sky130_fd_sc_hd__a21boi_2 abstract view
.subckt sky130_fd_sc_hd__a21boi_2 A1 A2 B1_N VGND VNB VPB VPWR Y
.ends

* Black-box entry subcircuit for sky130_fd_sc_hd__a221oi_2 abstract view
.subckt sky130_fd_sc_hd__a221oi_2 A1 A2 B1 B2 C1 VGND VNB VPB VPWR Y
.ends

* Black-box entry subcircuit for sky130_fd_sc_hd__o31a_2 abstract view
.subckt sky130_fd_sc_hd__o31a_2 A1 A2 A3 B1 VGND VNB VPB VPWR X
.ends

* Black-box entry subcircuit for sky130_fd_sc_hd__a2111oi_1 abstract view
.subckt sky130_fd_sc_hd__a2111oi_1 A1 A2 B1 C1 D1 VGND VNB VPB VPWR Y
.ends

* Black-box entry subcircuit for sky130_fd_sc_hd__a311oi_1 abstract view
.subckt sky130_fd_sc_hd__a311oi_1 A1 A2 A3 B1 C1 VGND VNB VPB VPWR Y
.ends

* Black-box entry subcircuit for sky130_fd_sc_hd__a32oi_1 abstract view
.subckt sky130_fd_sc_hd__a32oi_1 A1 A2 A3 B1 B2 VGND VNB VPB VPWR Y
.ends

* Black-box entry subcircuit for sky130_fd_sc_hd__or3_4 abstract view
.subckt sky130_fd_sc_hd__or3_4 A B C VGND VNB VPB VPWR X
.ends

* Black-box entry subcircuit for sky130_fd_sc_hd__a21o_2 abstract view
.subckt sky130_fd_sc_hd__a21o_2 A1 A2 B1 VGND VNB VPB VPWR X
.ends

* Black-box entry subcircuit for sky130_fd_sc_hd__nand2b_4 abstract view
.subckt sky130_fd_sc_hd__nand2b_4 A_N B VGND VNB VPB VPWR Y
.ends

* Black-box entry subcircuit for sky130_fd_sc_hd__dfstp_4 abstract view
.subckt sky130_fd_sc_hd__dfstp_4 CLK D SET_B VGND VNB VPB VPWR Q
.ends

* Black-box entry subcircuit for sky130_fd_sc_hd__o311a_2 abstract view
.subckt sky130_fd_sc_hd__o311a_2 A1 A2 A3 B1 C1 VGND VNB VPB VPWR X
.ends

* Black-box entry subcircuit for sky130_fd_sc_hd__o32ai_4 abstract view
.subckt sky130_fd_sc_hd__o32ai_4 A1 A2 A3 B1 B2 VGND VNB VPB VPWR Y
.ends

* Black-box entry subcircuit for sky130_fd_sc_hd__or4b_2 abstract view
.subckt sky130_fd_sc_hd__or4b_2 A B C D_N VGND VNB VPB VPWR X
.ends

* Black-box entry subcircuit for sky130_fd_sc_hd__o221ai_2 abstract view
.subckt sky130_fd_sc_hd__o221ai_2 A1 A2 B1 B2 C1 VGND VNB VPB VPWR Y
.ends

* Black-box entry subcircuit for sky130_fd_sc_hd__nor3b_2 abstract view
.subckt sky130_fd_sc_hd__nor3b_2 A B C_N VGND VNB VPB VPWR Y
.ends

* Black-box entry subcircuit for sky130_fd_sc_hd__and2_4 abstract view
.subckt sky130_fd_sc_hd__and2_4 A B VGND VNB VPB VPWR X
.ends

* Black-box entry subcircuit for sky130_fd_sc_hd__a21bo_4 abstract view
.subckt sky130_fd_sc_hd__a21bo_4 A1 A2 B1_N VGND VNB VPB VPWR X
.ends

* Black-box entry subcircuit for sky130_fd_sc_hd__a211oi_4 abstract view
.subckt sky130_fd_sc_hd__a211oi_4 A1 A2 B1 C1 VGND VNB VPB VPWR Y
.ends

* Black-box entry subcircuit for sky130_fd_sc_hd__o32ai_2 abstract view
.subckt sky130_fd_sc_hd__o32ai_2 A1 A2 A3 B1 B2 VGND VNB VPB VPWR Y
.ends

* Black-box entry subcircuit for sky130_fd_sc_hd__o221a_4 abstract view
.subckt sky130_fd_sc_hd__o221a_4 A1 A2 B1 B2 C1 VGND VNB VPB VPWR X
.ends

* Black-box entry subcircuit for sky130_fd_sc_hd__nor3_2 abstract view
.subckt sky130_fd_sc_hd__nor3_2 A B C VGND VNB VPB VPWR Y
.ends

.subckt cell4 CBeast_in[0] CBeast_in[10] CBeast_in[11] CBeast_in[12] CBeast_in[13]
+ CBeast_in[14] CBeast_in[15] CBeast_in[16] CBeast_in[17] CBeast_in[18] CBeast_in[19]
+ CBeast_in[1] CBeast_in[20] CBeast_in[21] CBeast_in[22] CBeast_in[23] CBeast_in[24]
+ CBeast_in[25] CBeast_in[26] CBeast_in[27] CBeast_in[28] CBeast_in[29] CBeast_in[2]
+ CBeast_in[30] CBeast_in[31] CBeast_in[3] CBeast_in[4] CBeast_in[5] CBeast_in[6]
+ CBeast_in[7] CBeast_in[8] CBeast_in[9] CBeast_out[0] CBeast_out[10] CBeast_out[11]
+ CBeast_out[12] CBeast_out[13] CBeast_out[14] CBeast_out[15] CBeast_out[16] CBeast_out[17]
+ CBeast_out[18] CBeast_out[19] CBeast_out[1] CBeast_out[20] CBeast_out[21] CBeast_out[22]
+ CBeast_out[23] CBeast_out[24] CBeast_out[25] CBeast_out[26] CBeast_out[27] CBeast_out[28]
+ CBeast_out[29] CBeast_out[2] CBeast_out[30] CBeast_out[31] CBeast_out[3] CBeast_out[4]
+ CBeast_out[5] CBeast_out[6] CBeast_out[7] CBeast_out[8] CBeast_out[9] CBnorth_in[0]
+ CBnorth_in[10] CBnorth_in[11] CBnorth_in[12] CBnorth_in[13] CBnorth_in[14] CBnorth_in[15]
+ CBnorth_in[16] CBnorth_in[17] CBnorth_in[18] CBnorth_in[19] CBnorth_in[1] CBnorth_in[20]
+ CBnorth_in[21] CBnorth_in[22] CBnorth_in[23] CBnorth_in[24] CBnorth_in[25] CBnorth_in[26]
+ CBnorth_in[27] CBnorth_in[28] CBnorth_in[29] CBnorth_in[2] CBnorth_in[30] CBnorth_in[31]
+ CBnorth_in[3] CBnorth_in[4] CBnorth_in[5] CBnorth_in[6] CBnorth_in[7] CBnorth_in[8]
+ CBnorth_in[9] CBnorth_out[0] CBnorth_out[10] CBnorth_out[11] CBnorth_out[12] CBnorth_out[13]
+ CBnorth_out[14] CBnorth_out[15] CBnorth_out[16] CBnorth_out[17] CBnorth_out[18]
+ CBnorth_out[19] CBnorth_out[1] CBnorth_out[20] CBnorth_out[21] CBnorth_out[22] CBnorth_out[23]
+ CBnorth_out[24] CBnorth_out[25] CBnorth_out[26] CBnorth_out[27] CBnorth_out[28]
+ CBnorth_out[29] CBnorth_out[2] CBnorth_out[30] CBnorth_out[31] CBnorth_out[3] CBnorth_out[4]
+ CBnorth_out[5] CBnorth_out[6] CBnorth_out[7] CBnorth_out[8] CBnorth_out[9] SBsouth_in[0]
+ SBsouth_in[10] SBsouth_in[11] SBsouth_in[12] SBsouth_in[13] SBsouth_in[14] SBsouth_in[15]
+ SBsouth_in[16] SBsouth_in[17] SBsouth_in[18] SBsouth_in[19] SBsouth_in[1] SBsouth_in[20]
+ SBsouth_in[21] SBsouth_in[22] SBsouth_in[23] SBsouth_in[24] SBsouth_in[25] SBsouth_in[26]
+ SBsouth_in[27] SBsouth_in[28] SBsouth_in[29] SBsouth_in[2] SBsouth_in[30] SBsouth_in[31]
+ SBsouth_in[3] SBsouth_in[4] SBsouth_in[5] SBsouth_in[6] SBsouth_in[7] SBsouth_in[8]
+ SBsouth_in[9] SBsouth_out[0] SBsouth_out[10] SBsouth_out[11] SBsouth_out[12] SBsouth_out[13]
+ SBsouth_out[14] SBsouth_out[15] SBsouth_out[16] SBsouth_out[17] SBsouth_out[18]
+ SBsouth_out[19] SBsouth_out[1] SBsouth_out[20] SBsouth_out[21] SBsouth_out[22] SBsouth_out[23]
+ SBsouth_out[24] SBsouth_out[25] SBsouth_out[26] SBsouth_out[27] SBsouth_out[28]
+ SBsouth_out[29] SBsouth_out[2] SBsouth_out[30] SBsouth_out[31] SBsouth_out[3] SBsouth_out[4]
+ SBsouth_out[5] SBsouth_out[6] SBsouth_out[7] SBsouth_out[8] SBsouth_out[9] SBwest_in[0]
+ SBwest_in[10] SBwest_in[11] SBwest_in[12] SBwest_in[13] SBwest_in[14] SBwest_in[15]
+ SBwest_in[16] SBwest_in[17] SBwest_in[18] SBwest_in[19] SBwest_in[1] SBwest_in[20]
+ SBwest_in[21] SBwest_in[22] SBwest_in[23] SBwest_in[24] SBwest_in[25] SBwest_in[26]
+ SBwest_in[27] SBwest_in[28] SBwest_in[29] SBwest_in[2] SBwest_in[30] SBwest_in[31]
+ SBwest_in[3] SBwest_in[4] SBwest_in[5] SBwest_in[6] SBwest_in[7] SBwest_in[8] SBwest_in[9]
+ SBwest_out[0] SBwest_out[10] SBwest_out[11] SBwest_out[12] SBwest_out[13] SBwest_out[14]
+ SBwest_out[15] SBwest_out[16] SBwest_out[17] SBwest_out[18] SBwest_out[19] SBwest_out[1]
+ SBwest_out[20] SBwest_out[21] SBwest_out[22] SBwest_out[23] SBwest_out[24] SBwest_out[25]
+ SBwest_out[26] SBwest_out[27] SBwest_out[28] SBwest_out[29] SBwest_out[2] SBwest_out[30]
+ SBwest_out[31] SBwest_out[3] SBwest_out[4] SBwest_out[5] SBwest_out[6] SBwest_out[7]
+ SBwest_out[8] SBwest_out[9] clk config_data_in config_data_out config_en le_en le_nrst
+ nrst vccd1 vssd1
X_09671_ net283 _04684_ _04685_ _04683_ _04677_ vssd1 vssd1 vccd1 vccd1 _04686_ sky130_fd_sc_hd__a221o_1
XTAP_TAPCELL_ROW_87_1616 vssd1 vccd1 sky130_fd_sc_hd__tapvpwrvgnd_1
X_06883_ _01944_ _01949_ _01950_ _01945_ vssd1 vssd1 vccd1 vccd1 _01951_ sky130_fd_sc_hd__o31a_1
XFILLER_82_545 vssd1 vssd1 vccd1 vccd1 sky130_fd_sc_hd__fill_2
X_08622_ cell1.LE_1A.config_data\[7\] cell1.LE_1A.config_data\[6\] _03546_ vssd1 vssd1
+ vccd1 vccd1 _03658_ sky130_fd_sc_hd__mux2_1
X_08553_ _03540_ _03587_ _03588_ _03537_ _01665_ vssd1 vssd1 vccd1 vccd1 _03589_ sky130_fd_sc_hd__a221o_1
X_07504_ cell0.SB0.route_sel\[120\] cell0.SB0.route_sel\[121\] _02555_ vssd1 vssd1
+ vccd1 vccd1 _02556_ sky130_fd_sc_hd__a21oi_1
X_08484_ net496 _03506_ _03511_ _03519_ vssd1 vssd1 vccd1 vccd1 _03520_ sky130_fd_sc_hd__a31o_1
X_07435_ _02484_ _02487_ _02488_ _02485_ vssd1 vssd1 vccd1 vccd1 _02489_ sky130_fd_sc_hd__o31a_1
XFILLER_22_133 vssd1 vssd1 vccd1 vccd1 sky130_fd_sc_hd__fill_2
XANTENNA__09039__A1 _03826_ vssd1 vssd1 vccd1 vccd1 sky130_fd_sc_hd__diode_2
XANTENNA__09039__B2 _03830_ vssd1 vssd1 vccd1 vccd1 sky130_fd_sc_hd__diode_2
XANTENNA__11422__X _06282_ vssd1 vssd1 vccd1 vccd1 sky130_fd_sc_hd__diode_2
X_07366_ cell0.SB0.route_sel\[104\] cell0.SB0.route_sel\[105\] _02414_ _02420_ net774
+ vssd1 vssd1 vccd1 vccd1 _02422_ sky130_fd_sc_hd__a311o_4
X_09105_ _04133_ _04134_ _04131_ vssd1 vssd1 vccd1 vccd1 _04135_ sky130_fd_sc_hd__o21ba_1
X_07297_ net85 _02352_ _01540_ _01541_ vssd1 vssd1 vccd1 vccd1 _02355_ sky130_fd_sc_hd__a211o_1
XTAP_TAPCELL_ROW_98_1778 vssd1 vccd1 sky130_fd_sc_hd__tapvpwrvgnd_1
X_09036_ _04053_ _04056_ _04064_ _04065_ vssd1 vssd1 vccd1 vccd1 _04066_ sky130_fd_sc_hd__o22a_1
Xhold351 cell2.LEI0.config_data\[19\] vssd1 vssd1 vccd1 vccd1 net1310 sky130_fd_sc_hd__dlygate4sd3_1
Xhold362 cell2.LEI0.config_data\[10\] vssd1 vssd1 vccd1 vccd1 net1321 sky130_fd_sc_hd__dlygate4sd3_1
XFILLER_89_111 vssd1 vssd1 vccd1 vccd1 sky130_fd_sc_hd__fill_1
Xhold340 cell0.LE_1A.config_data\[1\] vssd1 vssd1 vccd1 vccd1 net1299 sky130_fd_sc_hd__dlygate4sd3_1
Xhold384 cell2.LE_1B.config_data\[5\] vssd1 vssd1 vccd1 vccd1 net1343 sky130_fd_sc_hd__dlygate4sd3_1
XFILLER_117_55 vssd1 vssd1 vccd1 vccd1 sky130_fd_sc_hd__fill_1
XFILLER_104_444 vssd1 vssd1 vccd1 vccd1 sky130_fd_sc_hd__fill_4
XFILLER_89_133 vssd1 vssd1 vccd1 vccd1 sky130_fd_sc_hd__fill_2
Xhold373 cell0.LE_1B.config_data\[14\] vssd1 vssd1 vccd1 vccd1 net1332 sky130_fd_sc_hd__dlygate4sd3_1
Xhold395 cell1.LEI0.config_data\[7\] vssd1 vssd1 vccd1 vccd1 net1354 sky130_fd_sc_hd__dlygate4sd3_1
Xfanout842 net845 vssd1 vssd1 vccd1 vccd1 net842 sky130_fd_sc_hd__buf_2
Xfanout820 net821 vssd1 vssd1 vccd1 vccd1 net820 sky130_fd_sc_hd__clkbuf_4
X_09938_ _04671_ _04924_ _04940_ _04941_ vssd1 vssd1 vccd1 vccd1 _04942_ sky130_fd_sc_hd__a211o_1
Xfanout831 net837 vssd1 vssd1 vccd1 vccd1 net831 sky130_fd_sc_hd__buf_2
XANTENNA_fanout584_X net584 vssd1 vssd1 vccd1 vccd1 sky130_fd_sc_hd__diode_2
Xfanout853 net854 vssd1 vssd1 vccd1 vccd1 net853 sky130_fd_sc_hd__clkbuf_2
XTAP_TAPCELL_ROW_129_2244 vssd1 vccd1 sky130_fd_sc_hd__tapvpwrvgnd_1
XFILLER_58_531 vssd1 vssd1 vccd1 vccd1 sky130_fd_sc_hd__fill_1
Xfanout875 net884 vssd1 vssd1 vccd1 vccd1 net875 sky130_fd_sc_hd__clkbuf_2
Xfanout864 net867 vssd1 vssd1 vccd1 vccd1 net864 sky130_fd_sc_hd__clkbuf_4
X_09869_ net437 net439 vssd1 vssd1 vccd1 vccd1 _04875_ sky130_fd_sc_hd__and2b_1
Xfanout897 net898 vssd1 vssd1 vccd1 vccd1 net897 sky130_fd_sc_hd__clkbuf_4
XANTENNA_fanout751_X net751 vssd1 vssd1 vccd1 vccd1 sky130_fd_sc_hd__diode_2
XTAP_TAPCELL_ROW_51_1074 vssd1 vccd1 sky130_fd_sc_hd__tapvpwrvgnd_1
XTAP_TAPCELL_ROW_5_387 vssd1 vccd1 sky130_fd_sc_hd__tapvpwrvgnd_1
XTAP_TAPCELL_ROW_5_376 vssd1 vccd1 sky130_fd_sc_hd__tapvpwrvgnd_1
XANTENNA__08722__A0 net4 vssd1 vssd1 vccd1 vccd1 sky130_fd_sc_hd__diode_2
Xfanout886 net887 vssd1 vssd1 vccd1 vccd1 net886 sky130_fd_sc_hd__buf_2
XTAP_TAPCELL_ROW_142_2444 vssd1 vccd1 sky130_fd_sc_hd__tapvpwrvgnd_1
XTAP_TAPCELL_ROW_142_2433 vssd1 vccd1 sky130_fd_sc_hd__tapvpwrvgnd_1
X_12880_ cell2.SB0.route_sel\[122\] cell2.SB0.route_sel\[121\] net820 vssd1 vssd1
+ vccd1 vccd1 _01309_ sky130_fd_sc_hd__mux2_1
X_11900_ cell0.SB0.route_sel\[6\] cell0.SB0.route_sel\[5\] net781 vssd1 vssd1 vccd1
+ vccd1 _00337_ sky130_fd_sc_hd__mux2_1
XANTENNA_input127_A SBwest_in[8] vssd1 vssd1 vccd1 vccd1 sky130_fd_sc_hd__diode_2
XTAP_TAPCELL_ROW_142_2455 vssd1 vccd1 sky130_fd_sc_hd__tapvpwrvgnd_1
XFILLER_93_69 vssd1 vssd1 vccd1 vccd1 sky130_fd_sc_hd__fill_4
XANTENNA__07523__A bus3_1\[15\] vssd1 vssd1 vccd1 vccd1 sky130_fd_sc_hd__diode_2
X_11831_ cell1.CB_1.config_dataA\[12\] cell1.CB_1.config_dataA\[11\] net887 vssd1
+ vssd1 vccd1 vccd1 _00268_ sky130_fd_sc_hd__mux2_1
XFILLER_26_41 vccd1 vssd1 vccd1 vssd1 sky130_ef_sc_hd__decap_40_12
X_11762_ net1545 cell0.LEI0.config_data\[11\] net775 vssd1 vssd1 vccd1 vccd1 _00199_
+ sky130_fd_sc_hd__mux2_1
XFILLER_14_645 vssd1 vssd1 vccd1 vccd1 sky130_fd_sc_hd__fill_1
XFILLER_26_85 vssd1 vssd1 vccd1 vccd1 sky130_fd_sc_hd__fill_4
X_13501_ clknet_leaf_98_clk _00473_ net683 vssd1 vssd1 vccd1 vccd1 cell1.CB_1.config_dataB\[14\]
+ sky130_fd_sc_hd__dfstp_1
X_10713_ net286 net280 net297 net290 cell3.LEI0.config_data\[42\] cell3.LEI0.config_data\[43\]
+ vssd1 vssd1 vccd1 vccd1 _05671_ sky130_fd_sc_hd__mux4_1
X_14481_ clknet_leaf_66_clk _01453_ net737 vssd1 vssd1 vccd1 vccd1 cell3.LEI0.config_data\[46\]
+ sky130_fd_sc_hd__dfrtp_1
XANTENNA__11332__X net175 vssd1 vssd1 vccd1 vccd1 sky130_fd_sc_hd__diode_2
X_11693_ net1187 net1022 net873 vssd1 vssd1 vccd1 vccd1 _00133_ sky130_fd_sc_hd__mux2_1
XTAP_TAPCELL_ROW_24_662 vssd1 vccd1 sky130_fd_sc_hd__tapvpwrvgnd_1
X_10644_ _01791_ net392 vssd1 vssd1 vccd1 vccd1 _05602_ sky130_fd_sc_hd__nor2_1
XANTENNA_input92_A SBsouth_in[5] vssd1 vssd1 vccd1 vccd1 sky130_fd_sc_hd__diode_2
XTAP_TAPCELL_ROW_24_673 vssd1 vccd1 sky130_fd_sc_hd__tapvpwrvgnd_1
X_13432_ clknet_leaf_130_clk _00404_ net562 vssd1 vssd1 vccd1 vccd1 cell0.SB0.route_sel\[73\]
+ sky130_fd_sc_hd__dfstp_1
X_10575_ _05490_ _05528_ _05531_ _05485_ _01787_ vssd1 vssd1 vccd1 vccd1 _05533_ sky130_fd_sc_hd__a221oi_1
X_13363_ clknet_leaf_127_clk _00335_ net576 vssd1 vssd1 vccd1 vccd1 cell0.SB0.route_sel\[4\]
+ sky130_fd_sc_hd__dfstp_1
XANTENNA__10060__A2 net315 vssd1 vssd1 vccd1 vccd1 sky130_fd_sc_hd__diode_2
X_12314_ cell1.SB0.route_sel\[52\] cell1.SB0.route_sel\[51\] net857 vssd1 vssd1 vccd1
+ vccd1 _00747_ sky130_fd_sc_hd__mux2_1
XANTENNA_output179_A net179 vssd1 vssd1 vccd1 vccd1 sky130_fd_sc_hd__diode_2
X_13294_ clknet_leaf_101_clk _00266_ net679 vssd1 vssd1 vccd1 vccd1 cell1.CB_1.config_dataA\[10\]
+ sky130_fd_sc_hd__dfstp_1
XFILLER_123_731 vssd1 vssd1 vccd1 vccd1 sky130_fd_sc_hd__fill_4
X_12245_ cell2.CB_0.config_dataA\[8\] cell2.CB_0.config_dataA\[7\] net822 vssd1 vssd1
+ vccd1 vccd1 _00678_ sky130_fd_sc_hd__mux2_1
X_12176_ net1230 net1289 net852 vssd1 vssd1 vccd1 vccd1 _00609_ sky130_fd_sc_hd__mux2_1
X_11127_ net386 net387 vssd1 vssd1 vccd1 vccd1 _06079_ sky130_fd_sc_hd__or2_1
X_11058_ net372 _06010_ _06011_ vssd1 vssd1 vccd1 vccd1 _06012_ sky130_fd_sc_hd__a21bo_1
XFILLER_76_361 vssd1 vssd1 vccd1 vccd1 sky130_fd_sc_hd__fill_2
XANTENNA__11654__S net790 vssd1 vssd1 vccd1 vccd1 sky130_fd_sc_hd__diode_2
X_10009_ bus3_2\[6\] bus3_2\[7\] net403 vssd1 vssd1 vccd1 vccd1 _05013_ sky130_fd_sc_hd__mux2_1
XANTENNA__11507__X net244 vssd1 vssd1 vccd1 vccd1 sky130_fd_sc_hd__diode_2
XTAP_TAPCELL_ROW_69_1346 vssd1 vccd1 sky130_fd_sc_hd__tapvpwrvgnd_1
XANTENNA__06975__C _02039_ vssd1 vssd1 vccd1 vccd1 sky130_fd_sc_hd__diode_2
XANTENNA__14389__SET_B net753 vssd1 vssd1 vccd1 vccd1 sky130_fd_sc_hd__diode_2
XANTENNA__10130__Y _05131_ vssd1 vssd1 vccd1 vccd1 sky130_fd_sc_hd__diode_2
XTAP_TAPCELL_ROW_82_1535 vssd1 vccd1 sky130_fd_sc_hd__tapvpwrvgnd_1
XTAP_TAPCELL_ROW_43_960 vssd1 vccd1 sky130_fd_sc_hd__tapvpwrvgnd_1
XANTENNA__11242__X cell3.CB_0.le_outB vssd1 vssd1 vccd1 vccd1 sky130_fd_sc_hd__diode_2
X_07220_ cell1.SB0.route_sel\[95\] cell1.SB0.route_sel\[94\] _02260_ _02279_ vssd1
+ vssd1 vccd1 vccd1 _02280_ sky130_fd_sc_hd__a211o_1
XANTENNA__11402__B _06268_ vssd1 vssd1 vccd1 vccd1 sky130_fd_sc_hd__diode_2
XFILLER_9_671 vssd1 vssd1 vccd1 vccd1 sky130_fd_sc_hd__fill_1
X_07151_ cell1.SB0.route_sel\[85\] cell1.SB0.route_sel\[84\] vssd1 vssd1 vccd1 vccd1
+ _02213_ sky130_fd_sc_hd__nand2_1
XTAP_TAPCELL_ROW_113_2001 vssd1 vccd1 sky130_fd_sc_hd__tapvpwrvgnd_1
X_07082_ cell1.CB_1.config_dataA\[24\] cell1.CB_1.config_dataA\[21\] cell1.CB_1.config_dataA\[20\]
+ vssd1 vssd1 vccd1 vccd1 _02146_ sky130_fd_sc_hd__or3b_2
XANTENNA__10339__A0 net36 vssd1 vssd1 vccd1 vccd1 sky130_fd_sc_hd__diode_2
XTAP_TAPCELL_ROW_93_1697 vssd1 vccd1 sky130_fd_sc_hd__tapvpwrvgnd_1
XFILLER_87_615 vssd1 vssd1 vccd1 vccd1 sky130_fd_sc_hd__fill_1
X_07984_ cell0.LE_0A.config_data\[16\] _03024_ net351 _03026_ vssd1 vssd1 vccd1 vccd1
+ cell0.CB_0.le_outA sky130_fd_sc_hd__o211a_1
X_06935_ _01920_ _02001_ vssd1 vssd1 vccd1 vccd1 _02002_ sky130_fd_sc_hd__or2_1
X_09723_ net57 net277 _04734_ vssd1 vssd1 vccd1 vccd1 _04736_ sky130_fd_sc_hd__mux2_1
X_09654_ cell2.SB0.route_sel\[110\] _01643_ vssd1 vssd1 vccd1 vccd1 _04669_ sky130_fd_sc_hd__nand2_1
XTAP_TAPCELL_ROW_2_335 vssd1 vccd1 sky130_fd_sc_hd__tapvpwrvgnd_1
XANTENNA__11417__X net201 vssd1 vssd1 vccd1 vccd1 sky130_fd_sc_hd__diode_2
X_06866_ cell0.CB_1.le_outB _01851_ _01932_ _01931_ _01848_ vssd1 vssd1 vccd1 vccd1
+ _01934_ sky130_fd_sc_hd__a32o_1
XTAP_TAPCELL_ROW_124_2163 vssd1 vccd1 sky130_fd_sc_hd__tapvpwrvgnd_1
XFILLER_103_57 vssd1 vssd1 vccd1 vccd1 sky130_fd_sc_hd__fill_4
XANTENNA__08180__A1 bus1_0\[9\] vssd1 vssd1 vccd1 vccd1 sky130_fd_sc_hd__diode_2
X_08605_ net489 _03489_ _03640_ vssd1 vssd1 vccd1 vccd1 _03641_ sky130_fd_sc_hd__a21o_1
XANTENNA__11067__A1 _05921_ vssd1 vssd1 vccd1 vccd1 sky130_fd_sc_hd__diode_2
XTAP_TAPCELL_ROW_124_2174 vssd1 vccd1 sky130_fd_sc_hd__tapvpwrvgnd_1
X_09585_ cell3.SB0.route_sel\[80\] _01728_ vssd1 vssd1 vccd1 vccd1 _04603_ sky130_fd_sc_hd__nand2_1
XANTENNA__07062__B net354 vssd1 vssd1 vccd1 vccd1 sky130_fd_sc_hd__diode_2
X_06797_ cell0.CB_0.config_dataB\[24\] cell0.CB_0.config_dataB\[20\] cell0.CB_0.config_dataB\[21\]
+ vssd1 vssd1 vccd1 vccd1 _01867_ sky130_fd_sc_hd__or3b_2
XANTENNA__07630__X _02679_ vssd1 vssd1 vccd1 vccd1 sky130_fd_sc_hd__diode_2
X_08536_ net495 _03465_ _03571_ net493 vssd1 vssd1 vccd1 vccd1 _03572_ sky130_fd_sc_hd__o211a_1
XANTENNA__10814__A1 net9 vssd1 vssd1 vccd1 vccd1 sky130_fd_sc_hd__diode_2
XFILLER_51_762 vssd1 vssd1 vccd1 vccd1 sky130_fd_sc_hd__fill_1
XTAP_TAPCELL_ROW_41_919 vssd1 vccd1 sky130_fd_sc_hd__tapvpwrvgnd_1
XFILLER_11_615 vssd1 vssd1 vccd1 vccd1 sky130_fd_sc_hd__fill_1
X_08467_ cell1.SB0.route_sel\[21\] cell1.SB0.route_sel\[20\] _01508_ cell1.SB0.route_sel\[23\]
+ _03502_ vssd1 vssd1 vccd1 vccd1 _03503_ sky130_fd_sc_hd__o221a_1
XANTENNA__08483__A2 _03514_ vssd1 vssd1 vccd1 vccd1 sky130_fd_sc_hd__diode_2
XTAP_TAPCELL_ROW_21_621 vssd1 vccd1 sky130_fd_sc_hd__tapvpwrvgnd_1
X_08398_ bus1_0\[0\] bus1_0\[1\] bus1_0\[2\] bus1_0\[3\] net501 cell0.CB_1.config_dataB\[16\]
+ vssd1 vssd1 vccd1 vccd1 _03436_ sky130_fd_sc_hd__mux4_1
X_07418_ _01847_ _02324_ vssd1 vssd1 vccd1 vccd1 _02472_ sky130_fd_sc_hd__or2_1
XFILLER_12_10 vccd1 vssd1 vccd1 vssd1 sky130_ef_sc_hd__decap_40_12
XANTENNA_clkbuf_leaf_93_clk_A clknet_4_11_0_clk vssd1 vssd1 vccd1 vccd1 sky130_fd_sc_hd__diode_2
X_07349_ _02109_ _02324_ vssd1 vssd1 vccd1 vccd1 _02405_ sky130_fd_sc_hd__or2_1
XFILLER_128_21 vssd1 vssd1 vccd1 vccd1 sky130_fd_sc_hd__fill_4
X_10360_ net426 _05357_ _05358_ vssd1 vssd1 vccd1 vccd1 _05359_ sky130_fd_sc_hd__a21oi_1
XFILLER_12_65 vccd1 vssd1 vccd1 vssd1 sky130_ef_sc_hd__decap_40_12
X_10291_ net430 _05289_ vssd1 vssd1 vccd1 vccd1 _05290_ sky130_fd_sc_hd__and2_1
XFILLER_128_65 vssd1 vssd1 vccd1 vccd1 sky130_fd_sc_hd__fill_1
XFILLER_88_25 vssd1 vssd1 vccd1 vccd1 sky130_fd_sc_hd__fill_2
XANTENNA__07994__A1 bus2_0\[13\] vssd1 vssd1 vccd1 vccd1 sky130_fd_sc_hd__diode_2
X_09019_ cell1.LEI0.config_data\[17\] _04048_ vssd1 vssd1 vccd1 vccd1 _04049_ sky130_fd_sc_hd__nand2b_1
XFILLER_3_847 vssd1 vssd1 vccd1 vccd1 sky130_fd_sc_hd__fill_1
Xhold170 cell1.LEI0.config_data\[5\] vssd1 vssd1 vccd1 vccd1 net1129 sky130_fd_sc_hd__dlygate4sd3_1
XTAP_TAPCELL_ROW_53_1103 vssd1 vccd1 sky130_fd_sc_hd__tapvpwrvgnd_1
X_12030_ cell1.CB_1.config_dataB\[8\] cell1.CB_1.config_dataB\[7\] net899 vssd1 vssd1
+ vccd1 vccd1 _00467_ sky130_fd_sc_hd__mux2_1
XFILLER_2_357 vssd1 vssd1 vccd1 vccd1 sky130_fd_sc_hd__fill_4
Xhold192 cell2.LE_0A.config_data\[9\] vssd1 vssd1 vccd1 vccd1 net1151 sky130_fd_sc_hd__dlygate4sd3_1
Xhold181 cell1.LEI0.config_data\[16\] vssd1 vssd1 vccd1 vccd1 net1140 sky130_fd_sc_hd__dlygate4sd3_1
XANTENNA__07746__A1 net360 vssd1 vssd1 vccd1 vccd1 sky130_fd_sc_hd__diode_2
XANTENNA__06422__A cell0.CB_0.config_data_inA vssd1 vssd1 vccd1 vccd1 sky130_fd_sc_hd__diode_2
XANTENNA_clkbuf_leaf_31_clk_A clknet_4_7_0_clk vssd1 vssd1 vccd1 vccd1 sky130_fd_sc_hd__diode_2
Xfanout650 net133 vssd1 vssd1 vccd1 vccd1 net650 sky130_fd_sc_hd__clkbuf_4
XANTENNA__09292__X _04318_ vssd1 vssd1 vccd1 vccd1 sky130_fd_sc_hd__diode_2
X_13981_ clknet_leaf_42_clk net1350 net634 vssd1 vssd1 vccd1 vccd1 cell2.LEI0.config_data\[38\]
+ sky130_fd_sc_hd__dfrtp_1
Xfanout672 net675 vssd1 vssd1 vccd1 vccd1 net672 sky130_fd_sc_hd__clkbuf_2
Xfanout694 net695 vssd1 vssd1 vccd1 vccd1 net694 sky130_fd_sc_hd__buf_2
Xfanout683 net684 vssd1 vssd1 vccd1 vccd1 net683 sky130_fd_sc_hd__buf_2
Xfanout661 net663 vssd1 vssd1 vccd1 vccd1 net661 sky130_fd_sc_hd__clkbuf_4
X_12932_ cell3.LE_1B.dff1_out _05843_ net756 vssd1 vssd1 vccd1 vccd1 _01361_ sky130_fd_sc_hd__mux2_1
XTAP_TAPCELL_ROW_109_1947 vssd1 vccd1 sky130_fd_sc_hd__tapvpwrvgnd_1
XTAP_TAPCELL_ROW_109_1936 vssd1 vccd1 sky130_fd_sc_hd__tapvpwrvgnd_1
XFILLER_92_117 vssd1 vssd1 vccd1 vccd1 sky130_fd_sc_hd__fill_8
XFILLER_37_51 vssd1 vssd1 vccd1 vccd1 sky130_fd_sc_hd__fill_4
XTAP_TAPCELL_ROW_29_743 vssd1 vccd1 sky130_fd_sc_hd__tapvpwrvgnd_1
X_12863_ cell2.SB0.route_sel\[105\] cell2.SB0.route_sel\[104\] net817 vssd1 vssd1
+ vccd1 vccd1 _01292_ sky130_fd_sc_hd__mux2_1
XANTENNA_clkbuf_leaf_46_clk_A clknet_4_12_0_clk vssd1 vssd1 vccd1 vccd1 sky130_fd_sc_hd__diode_2
XFILLER_73_375 vssd1 vssd1 vccd1 vccd1 sky130_fd_sc_hd__fill_1
XFILLER_33_217 vssd1 vssd1 vccd1 vccd1 sky130_fd_sc_hd__fill_1
X_12794_ cell2.SB0.route_sel\[36\] cell2.SB0.route_sel\[35\] net820 vssd1 vssd1 vccd1
+ vccd1 _01223_ sky130_fd_sc_hd__mux2_1
X_11814_ net1514 cell1.LE_1B.config_data\[14\] net905 vssd1 vssd1 vccd1 vccd1 _00251_
+ sky130_fd_sc_hd__mux2_1
X_11745_ net1489 cell0.LE_0A.edge_mode net795 vssd1 vssd1 vccd1 vccd1 _00183_ sky130_fd_sc_hd__mux2_1
XTAP_TAPCELL_ROW_64_1265 vssd1 vccd1 sky130_fd_sc_hd__tapvpwrvgnd_1
XFILLER_14_453 vssd1 vssd1 vccd1 vccd1 sky130_fd_sc_hd__fill_1
X_14464_ clknet_leaf_62_clk net1373 net741 vssd1 vssd1 vccd1 vccd1 cell3.LEI0.config_data\[29\]
+ sky130_fd_sc_hd__dfrtp_1
XANTENNA_input95_X net95 vssd1 vssd1 vccd1 vccd1 sky130_fd_sc_hd__diode_2
XFILLER_14_475 vssd1 vssd1 vccd1 vccd1 sky130_fd_sc_hd__fill_1
X_13415_ clknet_leaf_133_clk _00387_ net556 vssd1 vssd1 vccd1 vccd1 cell0.SB0.route_sel\[56\]
+ sky130_fd_sc_hd__dfstp_2
X_11676_ cell0.CB_1.config_dataB\[22\] cell0.CB_1.config_dataB\[21\] net786 vssd1
+ vssd1 vccd1 vccd1 _00117_ sky130_fd_sc_hd__mux2_1
X_14395_ clknet_leaf_57_clk net1014 net721 vssd1 vssd1 vccd1 vccd1 cell3.LE_0B.config_data\[4\]
+ sky130_fd_sc_hd__dfrtp_1
X_10627_ cell3.CB_1.config_dataA\[3\] cell3.CB_1.config_dataA\[2\] vssd1 vssd1 vccd1
+ vccd1 _05585_ sky130_fd_sc_hd__or2_1
XFILLER_10_681 vccd1 vssd1 vccd1 vssd1 sky130_ef_sc_hd__decap_40_12
XANTENNA_clkbuf_leaf_104_clk_A clknet_4_8_0_clk vssd1 vssd1 vccd1 vccd1 sky130_fd_sc_hd__diode_2
X_10558_ _05480_ _05492_ _05498_ _05515_ vssd1 vssd1 vccd1 vccd1 _05516_ sky130_fd_sc_hd__a211oi_2
XANTENNA__09974__A2 bus3_2\[10\] vssd1 vssd1 vccd1 vccd1 sky130_fd_sc_hd__diode_2
X_13346_ clknet_leaf_85_clk _00318_ net673 vssd1 vssd1 vccd1 vccd1 cell1.CB_0.config_dataA\[12\]
+ sky130_fd_sc_hd__dfstp_1
XANTENNA__11649__S net773 vssd1 vssd1 vccd1 vccd1 sky130_fd_sc_hd__diode_2
X_13277_ clknet_leaf_91_clk _00249_ net698 vssd1 vssd1 vccd1 vccd1 cell1.LE_1B.config_data\[13\]
+ sky130_fd_sc_hd__dfrtp_1
XFILLER_142_369 vssd1 vssd1 vccd1 vccd1 sky130_fd_sc_hd__fill_1
X_12228_ net423 net424 net824 vssd1 vssd1 vccd1 vccd1 _00661_ sky130_fd_sc_hd__mux2_1
XFILLER_45_5 vssd1 vssd1 vccd1 vccd1 sky130_fd_sc_hd__fill_1
X_10489_ net320 _03509_ _02767_ vssd1 vssd1 vccd1 vccd1 _05460_ sky130_fd_sc_hd__mux2_1
XANTENNA_clkbuf_leaf_119_clk_A clknet_4_3_0_clk vssd1 vssd1 vccd1 vccd1 sky130_fd_sc_hd__diode_2
X_12159_ net1271 net1302 net893 vssd1 vssd1 vccd1 vccd1 _00592_ sky130_fd_sc_hd__mux2_1
X_06720_ cell3.CB_1.config_dataA\[12\] vssd1 vssd1 vccd1 vccd1 _01790_ sky130_fd_sc_hd__inv_2
XANTENNA__11297__A1 _05501_ vssd1 vssd1 vccd1 vccd1 sky130_fd_sc_hd__diode_2
X_06651_ cell3.SB0.route_sel\[69\] vssd1 vssd1 vccd1 vccd1 _01721_ sky130_fd_sc_hd__inv_2
XFILLER_25_729 vssd1 vssd1 vccd1 vccd1 sky130_fd_sc_hd__fill_1
XANTENNA__11049__A1 net50 vssd1 vssd1 vccd1 vccd1 sky130_fd_sc_hd__diode_2
X_09370_ cell2.SB0.route_sel\[32\] cell2.SB0.route_sel\[33\] net311 _04392_ vssd1
+ vssd1 vccd1 vccd1 _04394_ sky130_fd_sc_hd__a22o_1
X_06582_ cell2.SB0.config_data_out vssd1 vssd1 vccd1 vccd1 _01652_ sky130_fd_sc_hd__inv_2
X_08321_ cell0.CB_1.config_dataB\[2\] _03354_ _03355_ _03358_ vssd1 vssd1 vccd1 vccd1
+ _03359_ sky130_fd_sc_hd__o22a_1
XANTENNA__07610__B net353 vssd1 vssd1 vccd1 vccd1 sky130_fd_sc_hd__diode_2
XFILLER_20_401 vssd1 vssd1 vccd1 vccd1 sky130_fd_sc_hd__fill_1
XFILLER_20_423 vssd1 vssd1 vccd1 vccd1 sky130_fd_sc_hd__fill_4
X_08252_ net536 _02761_ vssd1 vssd1 vccd1 vccd1 _03292_ sky130_fd_sc_hd__nand2_1
X_07203_ cell0.SB0.route_sel\[91\] cell0.SB0.route_sel\[90\] vssd1 vssd1 vccd1 vccd1
+ _02263_ sky130_fd_sc_hd__nand2_1
XANTENNA__12943__S net932 vssd1 vssd1 vccd1 vccd1 sky130_fd_sc_hd__diode_2
Xclkbuf_4_12_0_clk clknet_0_clk vssd1 vssd1 vccd1 vccd1 clknet_4_12_0_clk sky130_fd_sc_hd__clkbuf_8
X_08183_ net542 _02277_ vssd1 vssd1 vccd1 vccd1 _03223_ sky130_fd_sc_hd__nand2_1
XANTENNA__10024__A2 net315 vssd1 vssd1 vccd1 vccd1 sky130_fd_sc_hd__diode_2
XANTENNA__10971__B _05924_ vssd1 vssd1 vccd1 vccd1 sky130_fd_sc_hd__diode_2
XTAP_TAPCELL_ROW_95_1737 vssd1 vccd1 sky130_fd_sc_hd__tapvpwrvgnd_1
XTAP_TAPCELL_ROW_95_1726 vssd1 vccd1 sky130_fd_sc_hd__tapvpwrvgnd_1
X_07134_ cell0.SB0.route_sel\[83\] cell0.SB0.route_sel\[82\] vssd1 vssd1 vccd1 vccd1
+ _02196_ sky130_fd_sc_hd__nand2_1
X_07065_ _02122_ _02128_ vssd1 vssd1 vccd1 vccd1 _02129_ sky130_fd_sc_hd__nor2_1
Xoutput253 net253 vssd1 vssd1 vccd1 vccd1 SBwest_out[30] sky130_fd_sc_hd__buf_2
XFILLER_133_358 vssd1 vssd1 vccd1 vccd1 sky130_fd_sc_hd__fill_1
Xoutput242 net242 vssd1 vssd1 vccd1 vccd1 SBwest_out[20] sky130_fd_sc_hd__buf_2
Xoutput231 net231 vssd1 vssd1 vccd1 vccd1 SBwest_out[10] sky130_fd_sc_hd__buf_2
Xoutput220 net220 vssd1 vssd1 vccd1 vccd1 SBsouth_out[2] sky130_fd_sc_hd__buf_2
XFILLER_87_412 vssd1 vssd1 vccd1 vccd1 sky130_fd_sc_hd__fill_1
XTAP_TAPCELL_ROW_7_416 vssd1 vccd1 sky130_fd_sc_hd__tapvpwrvgnd_1
XFILLER_141_391 vssd1 vssd1 vccd1 vccd1 sky130_fd_sc_hd__fill_1
XTAP_TAPCELL_ROW_126_2203 vssd1 vccd1 sky130_fd_sc_hd__tapvpwrvgnd_1
X_07967_ _03010_ vssd1 vssd1 vccd1 vccd1 _03011_ sky130_fd_sc_hd__inv_2
X_09706_ net328 _02573_ _02576_ _04717_ _04718_ vssd1 vssd1 vccd1 vccd1 _04719_ sky130_fd_sc_hd__o221a_1
X_06918_ _01462_ cell0.SB0.route_sel\[60\] _01463_ cell0.SB0.route_sel\[63\] _01984_
+ vssd1 vssd1 vccd1 vccd1 _01985_ sky130_fd_sc_hd__a221o_2
XANTENNA_fanout759_A net807 vssd1 vssd1 vccd1 vccd1 sky130_fd_sc_hd__diode_2
XANTENNA__06951__A2 net358 vssd1 vssd1 vccd1 vccd1 sky130_fd_sc_hd__diode_2
X_07898_ _02940_ _02941_ _01569_ vssd1 vssd1 vccd1 vccd1 _02942_ sky130_fd_sc_hd__mux2_1
XANTENNA_fanout926_A net934 vssd1 vssd1 vccd1 vccd1 sky130_fd_sc_hd__diode_2
XANTENNA__10211__B _05148_ vssd1 vssd1 vccd1 vccd1 sky130_fd_sc_hd__diode_2
X_09637_ _01737_ _01738_ _04637_ _04645_ _04652_ vssd1 vssd1 vccd1 vccd1 _04653_ sky130_fd_sc_hd__o41a_1
X_06849_ cell2.SB0.route_sel\[51\] cell2.SB0.route_sel\[50\] _01916_ _01917_ _01910_
+ vssd1 vssd1 vccd1 vccd1 _01918_ sky130_fd_sc_hd__a41o_1
XFILLER_55_364 vssd1 vssd1 vccd1 vccd1 sky130_fd_sc_hd__fill_1
XANTENNA__07900__A1 net347 vssd1 vssd1 vccd1 vccd1 sky130_fd_sc_hd__diode_2
XFILLER_15_217 vssd1 vssd1 vccd1 vccd1 sky130_fd_sc_hd__fill_2
XTAP_TAPCELL_ROW_26_702 vssd1 vccd1 sky130_fd_sc_hd__tapvpwrvgnd_1
XFILLER_28_589 vssd1 vssd1 vccd1 vccd1 sky130_fd_sc_hd__fill_1
XFILLER_82_172 vssd1 vssd1 vccd1 vccd1 sky130_fd_sc_hd__fill_1
X_09568_ cell3.SB0.route_sel\[85\] cell3.SB0.route_sel\[84\] _04585_ vssd1 vssd1 vccd1
+ vccd1 _04586_ sky130_fd_sc_hd__and3_1
XANTENNA__10799__A0 net298 vssd1 vssd1 vccd1 vccd1 sky130_fd_sc_hd__diode_2
XTAP_TAPCELL_ROW_104_1866 vssd1 vccd1 sky130_fd_sc_hd__tapvpwrvgnd_1
X_08519_ net29 net30 net494 vssd1 vssd1 vccd1 vccd1 _03555_ sky130_fd_sc_hd__mux2_1
X_11530_ cell2.SB0.route_sel\[112\] cell2.SB0.route_sel\[113\] _01649_ cell2.SB0.route_sel\[116\]
+ _06353_ vssd1 vssd1 vccd1 vccd1 _06354_ sky130_fd_sc_hd__o221a_1
X_09499_ net909 _04519_ vssd1 vssd1 vccd1 vccd1 _04520_ sky130_fd_sc_hd__or2_1
XFILLER_135_3 vccd1 vssd1 vccd1 vssd1 sky130_ef_sc_hd__decap_40_12
XPHY_EDGE_ROW_137_Right_137 vssd1 vssd1 vccd1 vccd1 sky130_fd_sc_hd__decap_3
XTAP_TAPCELL_ROW_137_2365 vssd1 vccd1 sky130_fd_sc_hd__tapvpwrvgnd_1
XFILLER_99_13 vccd1 vssd1 vccd1 vssd1 sky130_ef_sc_hd__decap_40_12
XFILLER_7_449 vssd1 vssd1 vccd1 vccd1 sky130_fd_sc_hd__fill_4
XFILLER_7_438 vssd1 vssd1 vccd1 vccd1 sky130_fd_sc_hd__fill_8
X_11461_ cell1.SB0.route_sel\[56\] _01521_ _01522_ cell1.SB0.route_sel\[59\] _06307_
+ vssd1 vssd1 vccd1 vccd1 _06308_ sky130_fd_sc_hd__a221o_1
X_14180_ clknet_leaf_58_clk _01152_ net722 vssd1 vssd1 vccd1 vccd1 cell3.CB_0.config_dataB\[15\]
+ sky130_fd_sc_hd__dfstp_1
XANTENNA__11212__A1 net50 vssd1 vssd1 vccd1 vccd1 sky130_fd_sc_hd__diode_2
X_10412_ cell2.CB_0.config_dataB\[18\] _01761_ cell2.CB_0.config_dataB\[19\] _05385_
+ vssd1 vssd1 vccd1 vccd1 _05411_ sky130_fd_sc_hd__and4b_1
X_13200_ clknet_leaf_6_clk net1060 net567 vssd1 vssd1 vccd1 vccd1 cell0.LE_0A.config_data\[7\]
+ sky130_fd_sc_hd__dfrtp_1
XANTENNA__08191__X _03231_ vssd1 vssd1 vccd1 vccd1 sky130_fd_sc_hd__diode_2
X_11392_ cell0.SB0.route_sel\[70\] cell0.SB0.route_sel\[71\] _01468_ cell0.SB0.route_sel\[66\]
+ _06261_ vssd1 vssd1 vccd1 vccd1 _06262_ sky130_fd_sc_hd__o221a_1
XFILLER_136_174 vssd1 vssd1 vccd1 vccd1 sky130_fd_sc_hd__fill_1
X_10343_ net313 net308 net318 net304 cell2.LEI0.config_data\[3\] cell2.LEI0.config_data\[4\]
+ vssd1 vssd1 vccd1 vccd1 _05342_ sky130_fd_sc_hd__mux4_1
XANTENNA__10566__A3 _05521_ vssd1 vssd1 vccd1 vccd1 sky130_fd_sc_hd__diode_2
X_13131_ clknet_leaf_127_clk _00103_ net577 vssd1 vssd1 vccd1 vccd1 cell0.CB_1.config_dataB\[8\]
+ sky130_fd_sc_hd__dfstp_1
XFILLER_2_121 vccd1 vssd1 vccd1 vssd1 sky130_ef_sc_hd__decap_40_12
XANTENNA_input55_A CBnorth_in[2] vssd1 vssd1 vccd1 vccd1 sky130_fd_sc_hd__diode_2
X_10274_ _05274_ _05271_ _05230_ vssd1 vssd1 vccd1 vccd1 _05275_ sky130_fd_sc_hd__mux2_1
XFILLER_2_165 vccd1 vssd1 vccd1 vssd1 sky130_ef_sc_hd__decap_40_12
X_13062_ clknet_leaf_110_clk _00034_ net654 vssd1 vssd1 vccd1 vccd1 cell0.CB_1.config_dataA\[14\]
+ sky130_fd_sc_hd__dfstp_1
X_12013_ cell0.SB0.route_sel\[119\] cell0.SB0.route_sel\[118\] net774 vssd1 vssd1
+ vccd1 vccd1 _00450_ sky130_fd_sc_hd__mux2_1
Xfanout480 cell1.CB_0.config_dataB\[10\] vssd1 vssd1 vccd1 vccd1 net480 sky130_fd_sc_hd__buf_1
Xfanout491 net492 vssd1 vssd1 vccd1 vccd1 net491 sky130_fd_sc_hd__buf_2
XANTENNA_input10_X net10 vssd1 vssd1 vccd1 vccd1 sky130_fd_sc_hd__diode_2
X_13964_ clknet_leaf_39_clk _00936_ net645 vssd1 vssd1 vccd1 vccd1 cell2.LEI0.config_data\[21\]
+ sky130_fd_sc_hd__dfrtp_1
XFILLER_47_843 vssd1 vssd1 vccd1 vccd1 sky130_fd_sc_hd__fill_1
XFILLER_19_534 vssd1 vssd1 vccd1 vccd1 sky130_fd_sc_hd__fill_8
X_13895_ clknet_leaf_39_clk _00867_ net644 vssd1 vssd1 vccd1 vccd1 cell2.LE_1A.reset_val
+ sky130_fd_sc_hd__dfrtp_1
X_12915_ cell3.LE_1A.config_data\[3\] net1406 net954 vssd1 vssd1 vccd1 vccd1 _01344_
+ sky130_fd_sc_hd__mux2_1
XPHY_EDGE_ROW_100_Left_243 vssd1 vssd1 vccd1 vccd1 sky130_fd_sc_hd__decap_3
XTAP_TAPCELL_ROW_66_1305 vssd1 vccd1 sky130_fd_sc_hd__tapvpwrvgnd_1
XFILLER_46_353 vssd1 vssd1 vccd1 vccd1 sky130_fd_sc_hd__fill_2
XFILLER_0_57 vccd1 vssd1 vccd1 vssd1 sky130_ef_sc_hd__decap_40_12
XANTENNA_output211_A net211 vssd1 vssd1 vccd1 vccd1 sky130_fd_sc_hd__diode_2
X_12846_ cell2.SB0.route_sel\[88\] cell2.SB0.route_sel\[87\] net830 vssd1 vssd1 vccd1
+ vccd1 _01275_ sky130_fd_sc_hd__mux2_1
XANTENNA__07270__X _02328_ vssd1 vssd1 vccd1 vccd1 sky130_fd_sc_hd__diode_2
X_12777_ cell2.SB0.route_sel\[19\] cell2.SB0.route_sel\[18\] net829 vssd1 vssd1 vccd1
+ vccd1 _01206_ sky130_fd_sc_hd__mux2_1
XANTENNA__10254__A2 _05088_ vssd1 vssd1 vccd1 vccd1 sky130_fd_sc_hd__diode_2
X_11728_ net997 cell0.LE_0A.config_data\[0\] net808 vssd1 vssd1 vccd1 vccd1 _00166_
+ sky130_fd_sc_hd__mux2_1
XANTENNA__07375__B1_N net86 vssd1 vssd1 vccd1 vccd1 sky130_fd_sc_hd__diode_2
XFILLER_9_55 vssd1 vssd1 vccd1 vccd1 sky130_fd_sc_hd__fill_1
XANTENNA__07655__B1 bus1_0\[2\] vssd1 vssd1 vccd1 vccd1 sky130_fd_sc_hd__diode_2
X_14447_ clknet_leaf_60_clk _01419_ net735 vssd1 vssd1 vccd1 vccd1 cell3.LEI0.config_data\[12\]
+ sky130_fd_sc_hd__dfrtp_1
XPHY_EDGE_ROW_104_Right_104 vssd1 vssd1 vccd1 vccd1 sky130_fd_sc_hd__decap_3
XFILLER_80_81 vssd1 vssd1 vccd1 vccd1 sky130_fd_sc_hd__fill_2
X_11659_ cell0.CB_1.config_dataB\[5\] cell0.CB_1.config_dataB\[4\] net789 vssd1 vssd1
+ vccd1 vccd1 _00100_ sky130_fd_sc_hd__mux2_1
X_14378_ clknet_leaf_70_clk _01350_ net731 vssd1 vssd1 vccd1 vccd1 cell3.LE_1A.config_data\[9\]
+ sky130_fd_sc_hd__dfrtp_1
XANTENNA__10006__A2 _04298_ vssd1 vssd1 vccd1 vccd1 sky130_fd_sc_hd__diode_2
XTAP_TAPCELL_ROW_12_484 vssd1 vccd1 sky130_fd_sc_hd__tapvpwrvgnd_1
XTAP_TAPCELL_ROW_12_495 vssd1 vccd1 sky130_fd_sc_hd__tapvpwrvgnd_1
XTAP_TAPCELL_ROW_77_1456 vssd1 vccd1 sky130_fd_sc_hd__tapvpwrvgnd_1
XANTENNA__07958__B2 _02456_ vssd1 vssd1 vccd1 vccd1 sky130_fd_sc_hd__diode_2
X_13329_ clknet_leaf_86_clk _00301_ net685 vssd1 vssd1 vccd1 vccd1 cell1.CB_0.config_dataB\[20\]
+ sky130_fd_sc_hd__dfstp_2
XANTENNA__07958__A1 _02388_ vssd1 vssd1 vccd1 vccd1 sky130_fd_sc_hd__diode_2
XTAP_TAPCELL_ROW_77_1467 vssd1 vccd1 sky130_fd_sc_hd__tapvpwrvgnd_1
XTAP_TAPCELL_ROW_90_1656 vssd1 vccd1 sky130_fd_sc_hd__tapvpwrvgnd_1
X_08870_ _03898_ _03899_ _03901_ vssd1 vssd1 vccd1 vccd1 _03902_ sky130_fd_sc_hd__and3_1
X_07821_ cell1.SB0.route_sel\[40\] cell1.SB0.route_sel\[41\] _02858_ _02865_ net861
+ vssd1 vssd1 vccd1 vccd1 _02866_ sky130_fd_sc_hd__a311o_2
XANTENNA__10190__A1 net64 vssd1 vssd1 vccd1 vccd1 sky130_fd_sc_hd__diode_2
X_07752_ _02797_ _02793_ _02794_ vssd1 vssd1 vccd1 vccd1 _02798_ sky130_fd_sc_hd__mux2_1
X_06703_ cell2.CB_0.config_dataA\[17\] vssd1 vssd1 vccd1 vccd1 _01773_ sky130_fd_sc_hd__inv_2
X_07683_ _02723_ _02724_ _02725_ _02730_ vssd1 vssd1 vccd1 vccd1 _02731_ sky130_fd_sc_hd__a31o_1
XTAP_TAPCELL_ROW_121_2122 vssd1 vccd1 sky130_fd_sc_hd__tapvpwrvgnd_1
X_06634_ cell3.SB0.route_sel\[41\] vssd1 vssd1 vccd1 vccd1 _01704_ sky130_fd_sc_hd__inv_2
X_09422_ _04442_ _04444_ vssd1 vssd1 vccd1 vccd1 _04445_ sky130_fd_sc_hd__nand2_2
XFILLER_52_312 vssd1 vssd1 vccd1 vccd1 sky130_fd_sc_hd__fill_1
X_09353_ _01699_ _01700_ vssd1 vssd1 vccd1 vccd1 _04377_ sky130_fd_sc_hd__nor2_1
XANTENNA__07621__A net354 vssd1 vssd1 vccd1 vccd1 sky130_fd_sc_hd__diode_2
XANTENNA__11414__Y net232 vssd1 vssd1 vccd1 vccd1 sky130_fd_sc_hd__diode_2
XFILLER_100_25 vssd1 vssd1 vccd1 vccd1 sky130_fd_sc_hd__fill_2
X_06565_ cell2.SB0.route_sel\[94\] vssd1 vssd1 vccd1 vccd1 _01635_ sky130_fd_sc_hd__inv_2
X_08304_ net350 net338 cell0.LEI0.config_data\[21\] vssd1 vssd1 vccd1 vccd1 _03342_
+ sky130_fd_sc_hd__mux2_1
XANTENNA__07646__A0 bus3_1\[1\] vssd1 vssd1 vccd1 vccd1 sky130_fd_sc_hd__diode_2
X_09284_ net295 _04306_ vssd1 vssd1 vccd1 vccd1 _04310_ sky130_fd_sc_hd__nor2_1
X_06496_ cell2.SB0.route_sel\[7\] vssd1 vssd1 vccd1 vccd1 _01566_ sky130_fd_sc_hd__inv_2
XFILLER_60_29 vssd1 vssd1 vccd1 vccd1 sky130_fd_sc_hd__fill_1
XTAP_TAPCELL_ROW_31_771 vssd1 vccd1 sky130_fd_sc_hd__tapvpwrvgnd_1
X_08235_ net537 _02277_ vssd1 vssd1 vccd1 vccd1 _03275_ sky130_fd_sc_hd__nand2_1
XTAP_TAPCELL_ROW_119_2095 vssd1 vccd1 sky130_fd_sc_hd__tapvpwrvgnd_1
X_08166_ _01499_ _03205_ vssd1 vssd1 vccd1 vccd1 _03206_ sky130_fd_sc_hd__nand2_1
X_07117_ cell2.CB_0.config_dataA\[24\] cell2.CB_0.config_dataA\[21\] cell2.CB_0.config_dataA\[20\]
+ vssd1 vssd1 vccd1 vccd1 _02180_ sky130_fd_sc_hd__or3b_2
XANTENNA__07949__B2 _02905_ vssd1 vssd1 vccd1 vccd1 sky130_fd_sc_hd__diode_2
XANTENNA__07949__A1 _02902_ vssd1 vssd1 vccd1 vccd1 sky130_fd_sc_hd__diode_2
XFILLER_4_419 vssd1 vssd1 vccd1 vccd1 sky130_fd_sc_hd__fill_1
X_08097_ net524 _02585_ vssd1 vssd1 vccd1 vccd1 _03139_ sky130_fd_sc_hd__nand2_1
XTAP_TAPCELL_ROW_132_2295 vssd1 vccd1 sky130_fd_sc_hd__tapvpwrvgnd_1
XTAP_TAPCELL_ROW_132_2284 vssd1 vccd1 sky130_fd_sc_hd__tapvpwrvgnd_1
XFILLER_133_177 vssd1 vssd1 vccd1 vccd1 sky130_fd_sc_hd__fill_1
Xclkload90 clknet_leaf_102_clk vssd1 vssd1 vccd1 vccd1 clkload90/X sky130_fd_sc_hd__clkbuf_4
X_07048_ net339 net357 net355 _02109_ _02013_ vssd1 vssd1 vccd1 vccd1 _02112_ sky130_fd_sc_hd__o32a_1
XFILLER_102_520 vssd1 vssd1 vccd1 vccd1 sky130_fd_sc_hd__fill_1
XFILLER_125_55 vssd1 vssd1 vccd1 vccd1 sky130_fd_sc_hd__fill_1
XANTENNA_input2_X net2 vssd1 vssd1 vccd1 vccd1 sky130_fd_sc_hd__diode_2
XFILLER_0_669 vssd1 vssd1 vccd1 vccd1 sky130_fd_sc_hd__fill_2
XANTENNA__09761__A1_N _04671_ vssd1 vssd1 vccd1 vccd1 sky130_fd_sc_hd__diode_2
XFILLER_102_586 vssd1 vssd1 vccd1 vccd1 sky130_fd_sc_hd__fill_2
X_08999_ cell1.CB_0.config_dataB\[6\] _04027_ _04028_ vssd1 vssd1 vccd1 vccd1 _04029_
+ sky130_fd_sc_hd__a21o_1
XFILLER_18_53 vccd1 vssd1 vccd1 vssd1 sky130_ef_sc_hd__decap_40_12
XFILLER_28_320 vssd1 vssd1 vccd1 vccd1 sky130_fd_sc_hd__fill_1
XANTENNA__09874__A1 bus3_2\[9\] vssd1 vssd1 vccd1 vccd1 sky130_fd_sc_hd__diode_2
X_10961_ cell3.SB0.route_sel\[27\] cell3.SB0.route_sel\[26\] _01696_ cell3.SB0.route_sel\[30\]
+ _05914_ vssd1 vssd1 vccd1 vccd1 _05915_ sky130_fd_sc_hd__o221a_1
XFILLER_16_504 vssd1 vssd1 vccd1 vccd1 sky130_fd_sc_hd__fill_1
XANTENNA_fanout929_X net929 vssd1 vssd1 vccd1 vccd1 sky130_fd_sc_hd__diode_2
X_13680_ clknet_leaf_30_clk _00652_ net620 vssd1 vssd1 vccd1 vccd1 cell2.CB_0.config_dataB\[7\]
+ sky130_fd_sc_hd__dfstp_1
X_12700_ cell3.CB_1.config_dataA\[17\] cell3.CB_1.config_dataA\[16\] net939 vssd1
+ vssd1 vccd1 vccd1 _01129_ sky130_fd_sc_hd__mux2_1
XTAP_TAPCELL_ROW_48_1035 vssd1 vccd1 sky130_fd_sc_hd__tapvpwrvgnd_1
XTAP_TAPCELL_ROW_48_1024 vssd1 vccd1 sky130_fd_sc_hd__tapvpwrvgnd_1
XTAP_TAPCELL_ROW_39_893 vssd1 vccd1 sky130_fd_sc_hd__tapvpwrvgnd_1
X_10892_ cell3.SB0.route_sel\[115\] cell3.SB0.route_sel\[114\] cell3.SB0.route_sel\[118\]
+ _01746_ _05845_ vssd1 vssd1 vccd1 vccd1 _05846_ sky130_fd_sc_hd__o221a_1
X_12631_ cell3.SB0.route_sel\[96\] cell3.SB0.route_sel\[95\] net920 vssd1 vssd1 vccd1
+ vccd1 _01060_ sky130_fd_sc_hd__mux2_1
XANTENNA__11053__A _05879_ vssd1 vssd1 vccd1 vccd1 sky130_fd_sc_hd__diode_2
XTAP_TAPCELL_ROW_61_1224 vssd1 vccd1 sky130_fd_sc_hd__tapvpwrvgnd_1
XFILLER_24_570 vssd1 vssd1 vccd1 vccd1 sky130_fd_sc_hd__fill_1
XFILLER_34_41 vccd1 vssd1 vccd1 vssd1 sky130_ef_sc_hd__decap_40_12
X_12562_ cell3.SB0.route_sel\[27\] cell3.SB0.route_sel\[26\] net910 vssd1 vssd1 vccd1
+ vccd1 _00991_ sky130_fd_sc_hd__mux2_1
XFILLER_70_197 vssd1 vssd1 vccd1 vccd1 sky130_fd_sc_hd__fill_4
XFILLER_34_85 vssd1 vssd1 vccd1 vccd1 sky130_fd_sc_hd__fill_2
X_12493_ net1506 cell2.LEI0.config_data\[6\] net838 vssd1 vssd1 vccd1 vccd1 _00922_
+ sky130_fd_sc_hd__mux2_1
X_11513_ _06342_ _02106_ vssd1 vssd1 vccd1 vccd1 net246 sky130_fd_sc_hd__and2b_1
X_14301_ clknet_leaf_12_clk _01273_ net590 vssd1 vssd1 vccd1 vccd1 cell2.SB0.route_sel\[86\]
+ sky130_fd_sc_hd__dfstp_1
XFILLER_8_747 vssd1 vssd1 vccd1 vccd1 sky130_fd_sc_hd__fill_1
XFILLER_8_725 vccd1 vssd1 vccd1 vssd1 sky130_ef_sc_hd__decap_40_12
XANTENNA__11340__X net180 vssd1 vssd1 vccd1 vccd1 sky130_fd_sc_hd__diode_2
X_14232_ clknet_leaf_20_clk _01204_ net611 vssd1 vssd1 vccd1 vccd1 cell2.SB0.route_sel\[17\]
+ sky130_fd_sc_hd__dfstp_1
X_11444_ _06296_ _02698_ vssd1 vssd1 vccd1 vccd1 net206 sky130_fd_sc_hd__and2b_1
XANTENNA__10539__A3 net11 vssd1 vssd1 vccd1 vccd1 sky130_fd_sc_hd__diode_2
XFILLER_7_279 vssd1 vssd1 vccd1 vccd1 sky130_fd_sc_hd__fill_1
X_14163_ clknet_leaf_74_clk _01135_ net729 vssd1 vssd1 vccd1 vccd1 cell3.CB_1.config_dataA\[23\]
+ sky130_fd_sc_hd__dfstp_1
XANTENNA__08601__A2 net2 vssd1 vssd1 vccd1 vccd1 sky130_fd_sc_hd__diode_2
X_11375_ _02842_ _06250_ vssd1 vssd1 vccd1 vccd1 net225 sky130_fd_sc_hd__nor2_1
XANTENNA_input58_X net58 vssd1 vssd1 vccd1 vccd1 sky130_fd_sc_hd__diode_2
X_10326_ _05324_ vssd1 vssd1 vccd1 vccd1 _05325_ sky130_fd_sc_hd__inv_2
XFILLER_98_529 vssd1 vssd1 vccd1 vccd1 sky130_fd_sc_hd__fill_2
X_14094_ clknet_leaf_77_clk _01066_ net712 vssd1 vssd1 vccd1 vccd1 cell3.SB0.route_sel\[102\]
+ sky130_fd_sc_hd__dfstp_1
XANTENNA__09745__X bus2_0\[4\] vssd1 vssd1 vccd1 vccd1 sky130_fd_sc_hd__diode_2
XTAP_TAPCELL_ROW_59_1197 vssd1 vccd1 sky130_fd_sc_hd__tapvpwrvgnd_1
XTAP_TAPCELL_ROW_59_1186 vssd1 vccd1 sky130_fd_sc_hd__tapvpwrvgnd_1
X_13114_ clknet_leaf_3_clk _00086_ net564 vssd1 vssd1 vccd1 vccd1 cell0.CB_0.config_dataA\[16\]
+ sky130_fd_sc_hd__dfstp_1
XFILLER_3_441 vssd1 vssd1 vccd1 vccd1 sky130_fd_sc_hd__fill_4
X_10257_ net63 net64 net34 net35 net413 cell2.CB_0.config_dataA\[16\] vssd1 vssd1
+ vccd1 vccd1 _05258_ sky130_fd_sc_hd__mux4_1
XANTENNA_output259_A net259 vssd1 vssd1 vccd1 vccd1 sky130_fd_sc_hd__diode_2
X_13045_ clknet_leaf_13_clk _00017_ net597 vssd1 vssd1 vccd1 vccd1 cell0.LE_1B.edge_mode
+ sky130_fd_sc_hd__dfstp_1
XFILLER_3_485 vccd1 vssd1 vccd1 vssd1 sky130_ef_sc_hd__decap_40_12
XFILLER_78_242 vssd1 vssd1 vccd1 vccd1 sky130_fd_sc_hd__fill_4
XTAP_TAPCELL_ROW_72_1386 vssd1 vccd1 sky130_fd_sc_hd__tapvpwrvgnd_1
XANTENNA__10172__A1 _05152_ vssd1 vssd1 vccd1 vccd1 sky130_fd_sc_hd__diode_2
XANTENNA__10172__B2 _05156_ vssd1 vssd1 vccd1 vccd1 sky130_fd_sc_hd__diode_2
X_10188_ cell2.CB_0.config_dataA\[2\] _05187_ _05188_ _05185_ vssd1 vssd1 vccd1 vccd1
+ _05189_ sky130_fd_sc_hd__o31a_1
XFILLER_79_787 vssd1 vssd1 vccd1 vccd1 sky130_fd_sc_hd__fill_1
XFILLER_94_757 vssd1 vssd1 vccd1 vccd1 sky130_fd_sc_hd__fill_1
XFILLER_19_331 vssd1 vssd1 vccd1 vccd1 sky130_fd_sc_hd__fill_4
X_13947_ clknet_leaf_34_clk net1429 net636 vssd1 vssd1 vccd1 vccd1 cell2.LEI0.config_data\[4\]
+ sky130_fd_sc_hd__dfrtp_1
XFILLER_19_364 vssd1 vssd1 vccd1 vccd1 sky130_fd_sc_hd__fill_1
XFILLER_46_183 vssd1 vssd1 vccd1 vccd1 sky130_fd_sc_hd__fill_1
X_13878_ clknet_leaf_39_clk _00850_ net647 vssd1 vssd1 vccd1 vccd1 cell2.LE_1A.config_data\[1\]
+ sky130_fd_sc_hd__dfrtp_1
XANTENNA__07441__A _02494_ vssd1 vssd1 vccd1 vccd1 sky130_fd_sc_hd__diode_2
X_12829_ cell2.SB0.route_sel\[71\] cell2.SB0.route_sel\[70\] net815 vssd1 vssd1 vccd1
+ vccd1 _01258_ sky130_fd_sc_hd__mux2_1
XTAP_TAPCELL_ROW_17_565 vssd1 vccd1 sky130_fd_sc_hd__tapvpwrvgnd_1
XANTENNA__10227__A2 net315 vssd1 vssd1 vccd1 vccd1 sky130_fd_sc_hd__diode_2
X_08020_ _02074_ _03060_ _03061_ _02172_ cell0.CB_0.config_dataB\[2\] vssd1 vssd1
+ vccd1 vccd1 _03062_ sky130_fd_sc_hd__a221o_1
XANTENNA__08840__A2 _03868_ vssd1 vssd1 vccd1 vccd1 sky130_fd_sc_hd__diode_2
XANTENNA__09250__C1 _03857_ vssd1 vssd1 vccd1 vccd1 sky130_fd_sc_hd__diode_2
X_09971_ net407 cell2.CB_1.config_dataB\[6\] _04641_ _04974_ cell2.CB_1.config_dataB\[7\]
+ vssd1 vssd1 vccd1 vccd1 _04975_ sky130_fd_sc_hd__o311a_1
XANTENNA__09655__X _04670_ vssd1 vssd1 vccd1 vccd1 sky130_fd_sc_hd__diode_2
X_08922_ net467 _03820_ vssd1 vssd1 vccd1 vccd1 _03954_ sky130_fd_sc_hd__nand2_1
XANTENNA__09553__A0 net50 vssd1 vssd1 vccd1 vccd1 sky130_fd_sc_hd__diode_2
X_08853_ _01897_ _03884_ vssd1 vssd1 vccd1 vccd1 _03885_ sky130_fd_sc_hd__or2_4
X_08784_ cell1.SB0.route_sel\[117\] cell1.SB0.route_sel\[116\] vssd1 vssd1 vccd1 vccd1
+ _03816_ sky130_fd_sc_hd__nand2b_1
X_07804_ cell1.SB0.route_sel\[46\] cell1.SB0.route_sel\[47\] _02825_ _02848_ vssd1
+ vssd1 vccd1 vccd1 _02849_ sky130_fd_sc_hd__a211o_1
XFILLER_29_128 vssd1 vssd1 vccd1 vccd1 sky130_fd_sc_hd__fill_1
XANTENNA__11112__A0 net47 vssd1 vssd1 vccd1 vccd1 sky130_fd_sc_hd__diode_2
X_07735_ cell1.SB0.route_sel\[26\] _01509_ cell1.SB0.route_sel\[29\] _01510_ _02781_
+ vssd1 vssd1 vccd1 vccd1 _02782_ sky130_fd_sc_hd__a221o_1
XANTENNA__08659__A2 _03493_ vssd1 vssd1 vccd1 vccd1 sky130_fd_sc_hd__diode_2
X_09405_ cell2.SB0.route_sel\[40\] cell2.SB0.route_sel\[41\] vssd1 vssd1 vccd1 vccd1
+ _04428_ sky130_fd_sc_hd__and2_1
X_07666_ bus2_0\[2\] _02712_ _02713_ _02710_ vssd1 vssd1 vccd1 vccd1 _02714_ sky130_fd_sc_hd__a211o_1
XTAP_TAPCELL_ROW_36_841 vssd1 vccd1 sky130_fd_sc_hd__tapvpwrvgnd_1
XTAP_TAPCELL_ROW_36_852 vssd1 vccd1 sky130_fd_sc_hd__tapvpwrvgnd_1
XTAP_TAPCELL_ROW_101_1825 vssd1 vccd1 sky130_fd_sc_hd__tapvpwrvgnd_1
X_06617_ cell3.SB0.route_sel\[10\] vssd1 vssd1 vccd1 vccd1 _01687_ sky130_fd_sc_hd__inv_2
X_07597_ net330 _02057_ _02646_ vssd1 vssd1 vccd1 vccd1 _02647_ sky130_fd_sc_hd__or3_1
X_09336_ net294 _04360_ _04357_ vssd1 vssd1 vccd1 vccd1 _04361_ sky130_fd_sc_hd__mux2_1
X_06548_ net112 vssd1 vssd1 vccd1 vccd1 _01618_ sky130_fd_sc_hd__inv_2
X_09267_ _04292_ net309 _04291_ vssd1 vssd1 vccd1 vccd1 _04293_ sky130_fd_sc_hd__mux2_1
XTAP_TAPCELL_ROW_134_2324 vssd1 vccd1 sky130_fd_sc_hd__tapvpwrvgnd_1
XTAP_TAPCELL_ROW_134_2313 vssd1 vccd1 sky130_fd_sc_hd__tapvpwrvgnd_1
X_06479_ cell1.SB0.route_sel\[118\] vssd1 vssd1 vccd1 vccd1 _01549_ sky130_fd_sc_hd__inv_2
XANTENNA__07205__B1_N net67 vssd1 vssd1 vccd1 vccd1 sky130_fd_sc_hd__diode_2
X_08218_ net538 _03256_ _03257_ vssd1 vssd1 vccd1 vccd1 _03258_ sky130_fd_sc_hd__a21oi_1
XANTENNA__08453__Y _03489_ vssd1 vssd1 vccd1 vccd1 sky130_fd_sc_hd__diode_2
X_09198_ cell3.SB0.route_sel\[6\] cell3.SB0.route_sel\[7\] vssd1 vssd1 vccd1 vccd1
+ _04226_ sky130_fd_sc_hd__nor2_1
X_08149_ _03188_ vssd1 vssd1 vccd1 vccd1 _03189_ sky130_fd_sc_hd__inv_2
XFILLER_136_21 vssd1 vssd1 vccd1 vccd1 sky130_fd_sc_hd__fill_4
X_11160_ _05874_ _05871_ net385 vssd1 vssd1 vccd1 vccd1 _06112_ sky130_fd_sc_hd__mux2_1
XFILLER_136_65 vccd1 vssd1 vccd1 vssd1 sky130_ef_sc_hd__decap_40_12
X_11091_ cell3.LE_0A.config_data\[16\] _06042_ _06043_ net351 vssd1 vssd1 vccd1 vccd1
+ cell3.CB_0.le_outA sky130_fd_sc_hd__o211a_1
X_10111_ cell2.SB0.route_sel\[99\] cell2.SB0.route_sel\[98\] vssd1 vssd1 vccd1 vccd1
+ _05112_ sky130_fd_sc_hd__nor2_1
XFILLER_96_25 vssd1 vssd1 vccd1 vccd1 sky130_fd_sc_hd__fill_2
XFILLER_0_400 vssd1 vssd1 vccd1 vccd1 sky130_fd_sc_hd__fill_4
XFILLER_20_98 vssd1 vssd1 vccd1 vccd1 sky130_fd_sc_hd__fill_2
XTAP_TAPCELL_ROW_112_1987 vssd1 vccd1 sky130_fd_sc_hd__tapvpwrvgnd_1
X_10042_ _05036_ _05044_ cell2.CB_1.config_dataB\[17\] vssd1 vssd1 vccd1 vccd1 _05046_
+ sky130_fd_sc_hd__mux2_1
XANTENNA__08347__A1 _02422_ vssd1 vssd1 vccd1 vccd1 sky130_fd_sc_hd__diode_2
XANTENNA__10504__X net135 vssd1 vssd1 vccd1 vccd1 sky130_fd_sc_hd__diode_2
Xhold30 _00174_ vssd1 vssd1 vccd1 vccd1 net989 sky130_fd_sc_hd__dlygate4sd3_1
XANTENNA__08121__S _03151_ vssd1 vssd1 vccd1 vccd1 sky130_fd_sc_hd__diode_2
XFILLER_0_477 vssd1 vssd1 vccd1 vccd1 sky130_fd_sc_hd__fill_1
Xhold41 cell1.LE_1A.config_data\[15\] vssd1 vssd1 vccd1 vccd1 net1000 sky130_fd_sc_hd__dlygate4sd3_1
Xhold74 _00514_ vssd1 vssd1 vccd1 vccd1 net1033 sky130_fd_sc_hd__dlygate4sd3_1
Xhold52 _00513_ vssd1 vssd1 vccd1 vccd1 net1011 sky130_fd_sc_hd__dlygate4sd3_1
Xhold63 cell0.LE_1A.config_data\[11\] vssd1 vssd1 vccd1 vccd1 net1022 sky130_fd_sc_hd__dlygate4sd3_1
XANTENNA_input18_A CBeast_in[25] vssd1 vssd1 vccd1 vccd1 sky130_fd_sc_hd__diode_2
Xhold96 cell2.LE_0A.config_data\[4\] vssd1 vssd1 vccd1 vccd1 net1055 sky130_fd_sc_hd__dlygate4sd3_1
Xhold85 _00899_ vssd1 vssd1 vccd1 vccd1 net1044 sky130_fd_sc_hd__dlygate4sd3_1
X_13801_ clknet_leaf_112_clk _00773_ net656 vssd1 vssd1 vccd1 vccd1 cell1.SB0.route_sel\[78\]
+ sky130_fd_sc_hd__dfstp_1
XFILLER_28_150 vssd1 vssd1 vccd1 vccd1 sky130_fd_sc_hd__fill_2
XANTENNA__09847__A1 bus3_2\[7\] vssd1 vssd1 vccd1 vccd1 sky130_fd_sc_hd__diode_2
X_11993_ cell0.SB0.route_sel\[99\] cell0.SB0.route_sel\[98\] net775 vssd1 vssd1 vccd1
+ vccd1 _00430_ sky130_fd_sc_hd__mux2_1
X_13732_ clknet_leaf_105_clk _00704_ net660 vssd1 vssd1 vccd1 vccd1 cell1.SB0.route_sel\[9\]
+ sky130_fd_sc_hd__dfstp_2
X_10944_ _04463_ _05897_ vssd1 vssd1 vccd1 vccd1 _05898_ sky130_fd_sc_hd__nand2_2
XANTENNA__12851__A0 cell2.SB0.route_sel\[93\] vssd1 vssd1 vccd1 vccd1 sky130_fd_sc_hd__diode_2
XFILLER_16_334 vssd1 vssd1 vccd1 vccd1 sky130_fd_sc_hd__fill_1
X_13663_ clknet_leaf_47_clk _00635_ net704 vssd1 vssd1 vccd1 vccd1 cell2.CB_1.config_dataA\[15\]
+ sky130_fd_sc_hd__dfstp_1
X_10875_ cell3.CB_1.config_dataB\[19\] _05824_ _05829_ _05830_ vssd1 vssd1 vccd1 vccd1
+ _05831_ sky130_fd_sc_hd__o211ai_2
XTAP_TAPCELL_ROW_14_513 vssd1 vccd1 sky130_fd_sc_hd__tapvpwrvgnd_1
X_12614_ cell3.SB0.route_sel\[79\] cell3.SB0.route_sel\[78\] net834 vssd1 vssd1 vccd1
+ vccd1 _01043_ sky130_fd_sc_hd__mux2_1
X_13594_ clknet_leaf_88_clk _00566_ net688 vssd1 vssd1 vccd1 vccd1 cell1.LEI0.config_data\[15\]
+ sky130_fd_sc_hd__dfrtp_1
XANTENNA__09075__A2 bus3_1\[2\] vssd1 vssd1 vccd1 vccd1 sky130_fd_sc_hd__diode_2
XTAP_TAPCELL_ROW_14_524 vssd1 vccd1 sky130_fd_sc_hd__tapvpwrvgnd_1
XFILLER_31_337 vssd1 vssd1 vccd1 vccd1 sky130_fd_sc_hd__fill_1
XFILLER_84_9 vccd1 vssd1 vccd1 vssd1 sky130_ef_sc_hd__decap_40_12
X_12545_ cell3.SB0.route_sel\[10\] cell3.SB0.route_sel\[9\] net935 vssd1 vssd1 vccd1
+ vccd1 _00974_ sky130_fd_sc_hd__mux2_1
XANTENNA__09480__C1 _04500_ vssd1 vssd1 vccd1 vccd1 sky130_fd_sc_hd__diode_2
XANTENNA__08822__A2 _03849_ vssd1 vssd1 vccd1 vccd1 sky130_fd_sc_hd__diode_2
Xclkbuf_leaf_132_clk clknet_4_0_0_clk vssd1 vssd1 vccd1 vccd1 clknet_leaf_132_clk
+ sky130_fd_sc_hd__clkbuf_8
XFILLER_138_781 vccd1 vssd1 vccd1 vssd1 sky130_ef_sc_hd__decap_40_12
X_12476_ net1039 cell2.LE_0A.config_data\[12\] net824 vssd1 vssd1 vccd1 vccd1 _00906_
+ sky130_fd_sc_hd__mux2_1
XANTENNA__10127__A _02008_ vssd1 vssd1 vccd1 vccd1 sky130_fd_sc_hd__diode_2
X_14215_ clknet_leaf_15_clk _01187_ net625 vssd1 vssd1 vccd1 vccd1 cell2.SB0.route_sel\[0\]
+ sky130_fd_sc_hd__dfstp_1
X_11427_ cell0.SB0.route_sel\[118\] cell0.SB0.route_sel\[119\] vssd1 vssd1 vccd1 vccd1
+ _06285_ sky130_fd_sc_hd__or2_1
XANTENNA_5 _02278_ vssd1 vssd1 vccd1 vccd1 sky130_fd_sc_hd__diode_2
X_11358_ _06244_ net284 _04735_ vssd1 vssd1 vccd1 vccd1 net190 sky130_fd_sc_hd__mux2_2
XFILLER_113_615 vssd1 vssd1 vccd1 vccd1 sky130_fd_sc_hd__fill_1
X_14146_ clknet_leaf_77_clk _01118_ net726 vssd1 vssd1 vccd1 vccd1 cell3.CB_1.config_dataA\[6\]
+ sky130_fd_sc_hd__dfstp_1
XTAP_TAPCELL_ROW_74_1415 vssd1 vccd1 sky130_fd_sc_hd__tapvpwrvgnd_1
X_10309_ cell2.LEI0.config_data\[17\] _05307_ _01758_ _05306_ vssd1 vssd1 vccd1 vccd1
+ _05308_ sky130_fd_sc_hd__a2bb2o_1
X_11289_ clknet_leaf_36_clk cell2.LE_0B.edge_mode vssd1 vssd1 vccd1 vccd1 cell2.LE_0B.sel_clk
+ sky130_fd_sc_hd__xnor2_2
X_14077_ clknet_leaf_82_clk _01049_ net670 vssd1 vssd1 vccd1 vccd1 cell3.SB0.route_sel\[85\]
+ sky130_fd_sc_hd__dfstp_1
XFILLER_3_293 vccd1 vssd1 vccd1 vssd1 sky130_ef_sc_hd__decap_40_12
XANTENNA__08338__A1 _02136_ vssd1 vssd1 vccd1 vccd1 sky130_fd_sc_hd__diode_2
X_13028_ clknet_leaf_122_clk _00000_ net593 vssd1 vssd1 vccd1 vccd1 cell0.LE_1B.config_data\[0\]
+ sky130_fd_sc_hd__dfrtp_1
XFILLER_94_521 vssd1 vssd1 vccd1 vccd1 sky130_fd_sc_hd__fill_2
XFILLER_13_3 vccd1 vssd1 vccd1 vssd1 sky130_ef_sc_hd__decap_40_12
XANTENNA__07723__X _02770_ vssd1 vssd1 vccd1 vccd1 sky130_fd_sc_hd__diode_2
X_07520_ _02564_ _02565_ _02566_ _02571_ vssd1 vssd1 vccd1 vccd1 _02572_ sky130_fd_sc_hd__a31o_1
XFILLER_35_643 vssd1 vssd1 vccd1 vccd1 sky130_fd_sc_hd__fill_1
XFILLER_35_665 vssd1 vssd1 vccd1 vccd1 sky130_fd_sc_hd__fill_1
XANTENNA__13693__SET_B net621 vssd1 vssd1 vccd1 vccd1 sky130_fd_sc_hd__diode_2
XTAP_TAPCELL_ROW_85_1588 vssd1 vccd1 sky130_fd_sc_hd__tapvpwrvgnd_1
XTAP_TAPCELL_ROW_85_1577 vssd1 vccd1 sky130_fd_sc_hd__tapvpwrvgnd_1
XTAP_TAPCELL_ROW_33_800 vssd1 vccd1 sky130_fd_sc_hd__tapvpwrvgnd_1
X_07451_ cell1.SB0.route_sel\[114\] cell1.SB0.route_sel\[115\] net335 _02503_ vssd1
+ vssd1 vccd1 vccd1 _02505_ sky130_fd_sc_hd__a22o_1
X_07382_ _02151_ _02365_ vssd1 vssd1 vccd1 vccd1 _02438_ sky130_fd_sc_hd__or2_1
X_06402_ cell0.SB0.route_sel\[86\] vssd1 vssd1 vccd1 vccd1 _01472_ sky130_fd_sc_hd__inv_2
X_09121_ _04150_ _04149_ cell1.CB_0.config_dataB\[17\] vssd1 vssd1 vccd1 vccd1 _04151_
+ sky130_fd_sc_hd__mux2_1
XFILLER_136_707 vssd1 vssd1 vccd1 vccd1 sky130_fd_sc_hd__fill_1
Xclkbuf_leaf_123_clk clknet_4_2_0_clk vssd1 vssd1 vccd1 vccd1 clknet_leaf_123_clk
+ sky130_fd_sc_hd__clkbuf_8
XTAP_TAPCELL_ROW_116_2043 vssd1 vccd1 sky130_fd_sc_hd__tapvpwrvgnd_1
XANTENNA__10620__A2 _05548_ vssd1 vssd1 vccd1 vccd1 sky130_fd_sc_hd__diode_2
X_09052_ cell1.LEI0.config_data\[3\] net324 vssd1 vssd1 vccd1 vccd1 _04082_ sky130_fd_sc_hd__nand2_1
XANTENNA__06824__A1 bus3_1\[6\] vssd1 vssd1 vccd1 vccd1 sky130_fd_sc_hd__diode_2
Xhold511 cell2.LEI0.config_data\[28\] vssd1 vssd1 vccd1 vccd1 net1470 sky130_fd_sc_hd__dlygate4sd3_1
Xhold500 _01411_ vssd1 vssd1 vccd1 vccd1 net1459 sky130_fd_sc_hd__dlygate4sd3_1
XANTENNA__14213__SET_B net723 vssd1 vssd1 vccd1 vccd1 sky130_fd_sc_hd__diode_2
XTAP_TAPCELL_ROW_116_2054 vssd1 vccd1 sky130_fd_sc_hd__tapvpwrvgnd_1
XANTENNA__09223__C1 _04249_ vssd1 vssd1 vccd1 vccd1 sky130_fd_sc_hd__diode_2
XANTENNA__08026__A0 bus2_0\[12\] vssd1 vssd1 vccd1 vccd1 sky130_fd_sc_hd__diode_2
X_08003_ _02902_ _03029_ _03030_ _02905_ cell0.CB_0.config_dataB\[7\] vssd1 vssd1
+ vccd1 vccd1 _03045_ sky130_fd_sc_hd__a221o_1
Xhold544 cell2.LE_1B.reset_val vssd1 vssd1 vccd1 vccd1 net1503 sky130_fd_sc_hd__dlygate4sd3_1
Xhold522 cell3.LEI0.config_data\[8\] vssd1 vssd1 vccd1 vccd1 net1481 sky130_fd_sc_hd__dlygate4sd3_1
XANTENNA__09385__X _04409_ vssd1 vssd1 vccd1 vccd1 sky130_fd_sc_hd__diode_2
Xhold533 cell1.LE_0B.config_data\[0\] vssd1 vssd1 vccd1 vccd1 net1492 sky130_fd_sc_hd__dlygate4sd3_1
Xhold577 cell3.LEI0.config_data\[20\] vssd1 vssd1 vccd1 vccd1 net1536 sky130_fd_sc_hd__dlygate4sd3_1
XFILLER_104_637 vssd1 vssd1 vccd1 vccd1 sky130_fd_sc_hd__fill_1
Xmax_cap263 _04295_ vssd1 vssd1 vccd1 vccd1 net263 sky130_fd_sc_hd__clkbuf_2
Xmax_cap274 _04550_ vssd1 vssd1 vccd1 vccd1 net274 sky130_fd_sc_hd__clkbuf_2
XANTENNA__06802__X _01872_ vssd1 vssd1 vccd1 vccd1 sky130_fd_sc_hd__diode_2
Xhold588 cell1.LE_1B.reset_val vssd1 vssd1 vccd1 vccd1 net1547 sky130_fd_sc_hd__dlygate4sd3_1
Xhold555 cell1.LE_1B.config_data\[15\] vssd1 vssd1 vccd1 vccd1 net1514 sky130_fd_sc_hd__dlygate4sd3_1
Xhold566 cell1.LE_1B.config_data\[13\] vssd1 vssd1 vccd1 vccd1 net1525 sky130_fd_sc_hd__dlygate4sd3_1
XFILLER_131_434 vssd1 vssd1 vccd1 vccd1 sky130_fd_sc_hd__fill_1
X_09954_ cell2.CB_1.config_dataB\[6\] net407 vssd1 vssd1 vccd1 vccd1 _04958_ sky130_fd_sc_hd__and2b_2
X_09885_ bus3_2\[0\] bus3_2\[2\] bus3_2\[1\] bus3_2\[3\] net437 net439 vssd1 vssd1
+ vccd1 vccd1 _04891_ sky130_fd_sc_hd__mux4_1
XANTENNA_fanout574_A net575 vssd1 vssd1 vccd1 vccd1 sky130_fd_sc_hd__diode_2
X_08905_ cell1.LE_0A.config_data\[5\] cell1.LE_0A.config_data\[4\] _03936_ vssd1 vssd1
+ vccd1 vccd1 _03937_ sky130_fd_sc_hd__mux2_1
X_08836_ _03867_ vssd1 vssd1 vccd1 vccd1 _03868_ sky130_fd_sc_hd__inv_2
XFILLER_73_727 vssd1 vssd1 vccd1 vccd1 sky130_fd_sc_hd__fill_1
XANTENNA_fanout741_A net742 vssd1 vssd1 vccd1 vccd1 sky130_fd_sc_hd__diode_2
X_08767_ cell1.LE_1B.config_data\[3\] cell1.LE_1B.config_data\[2\] _03735_ vssd1 vssd1
+ vccd1 vccd1 _03801_ sky130_fd_sc_hd__mux2_1
XFILLER_82_27 vssd1 vssd1 vccd1 vccd1 sky130_fd_sc_hd__fill_1
XFILLER_81_760 vssd1 vssd1 vccd1 vccd1 sky130_fd_sc_hd__fill_1
X_08698_ net331 net326 net336 net323 cell1.LEI0.config_data\[9\] cell1.LEI0.config_data\[10\]
+ vssd1 vssd1 vccd1 vccd1 _03732_ sky130_fd_sc_hd__mux4_1
X_07718_ _02743_ _02762_ _02764_ vssd1 vssd1 vccd1 vccd1 _02765_ sky130_fd_sc_hd__o21ai_1
XFILLER_26_643 vssd1 vssd1 vccd1 vccd1 sky130_fd_sc_hd__fill_1
XTAP_TAPCELL_ROW_0_296 vssd1 vccd1 sky130_fd_sc_hd__tapvpwrvgnd_1
X_07649_ cell1.SB0.route_sel\[8\] cell1.SB0.route_sel\[9\] _02691_ _02697_ net866
+ vssd1 vssd1 vccd1 vccd1 _02698_ sky130_fd_sc_hd__a311oi_4
XANTENNA__07081__A net32 vssd1 vssd1 vccd1 vccd1 sky130_fd_sc_hd__diode_2
X_10660_ net393 net392 _05489_ cell3.CB_1.config_dataA\[12\] vssd1 vssd1 vccd1 vccd1
+ _05618_ sky130_fd_sc_hd__o31a_1
X_09319_ _04340_ _04342_ _04343_ vssd1 vssd1 vccd1 vccd1 _04344_ sky130_fd_sc_hd__a21o_1
X_10591_ net273 _05548_ vssd1 vssd1 vccd1 vccd1 _05549_ sky130_fd_sc_hd__nand2_2
Xclkbuf_leaf_114_clk clknet_4_9_0_clk vssd1 vssd1 vccd1 vccd1 clknet_leaf_114_clk
+ sky130_fd_sc_hd__clkbuf_8
XANTENNA__08116__S _03057_ vssd1 vssd1 vccd1 vccd1 sky130_fd_sc_hd__diode_2
X_12330_ cell1.SB0.route_sel\[68\] cell1.SB0.route_sel\[67\] net869 vssd1 vssd1 vccd1
+ vccd1 _00763_ sky130_fd_sc_hd__mux2_1
X_12261_ cell2.CB_0.config_dataA\[24\] cell2.CB_0.config_dataA\[23\] net841 vssd1
+ vssd1 vccd1 vccd1 _00694_ sky130_fd_sc_hd__mux2_1
X_11212_ net49 net50 net51 net52 net383 net382 vssd1 vssd1 vccd1 vccd1 _06164_ sky130_fd_sc_hd__mux4_1
X_14000_ clknet_leaf_75_clk _00972_ net725 vssd1 vssd1 vccd1 vccd1 cell3.SB0.route_sel\[8\]
+ sky130_fd_sc_hd__dfstp_1
XANTENNA__10375__A1 net64 vssd1 vssd1 vccd1 vccd1 sky130_fd_sc_hd__diode_2
X_12192_ net445 cell2.CB_1.config_dataA\[4\] net848 vssd1 vssd1 vccd1 vccd1 _00625_
+ sky130_fd_sc_hd__mux2_1
XFILLER_107_486 vssd1 vssd1 vccd1 vccd1 sky130_fd_sc_hd__fill_8
XTAP_TAPCELL_ROW_56_1145 vssd1 vccd1 sky130_fd_sc_hd__tapvpwrvgnd_1
X_11143_ net47 net48 cell3.CB_0.config_dataB\[5\] vssd1 vssd1 vccd1 vccd1 _06095_
+ sky130_fd_sc_hd__mux2_1
XFILLER_0_230 vssd1 vssd1 vccd1 vccd1 sky130_fd_sc_hd__fill_4
XFILLER_1_731 vccd1 vssd1 vccd1 vssd1 sky130_ef_sc_hd__decap_40_12
X_11074_ cell3.LE_0A.config_data\[12\] cell3.LE_0A.config_data\[13\] _05930_ vssd1
+ vssd1 vccd1 vccd1 _06028_ sky130_fd_sc_hd__mux2_1
Xinput120 SBwest_in[30] vssd1 vssd1 vccd1 vccd1 net120 sky130_fd_sc_hd__buf_1
X_10025_ cell2.LEI0.config_data\[35\] _05026_ _05028_ _05024_ vssd1 vssd1 vccd1 vccd1
+ _05029_ sky130_fd_sc_hd__o31ai_2
XFILLER_48_212 vssd1 vssd1 vccd1 vccd1 sky130_fd_sc_hd__fill_1
Xinput131 le_en vssd1 vssd1 vccd1 vccd1 net131 sky130_fd_sc_hd__dlymetal6s2s_1
XFILLER_0_285 vssd1 vssd1 vccd1 vccd1 sky130_fd_sc_hd__fill_1
XFILLER_0_296 vssd1 vssd1 vccd1 vccd1 sky130_fd_sc_hd__fill_2
XFILLER_1_797 vssd1 vssd1 vccd1 vccd1 sky130_fd_sc_hd__fill_8
XANTENNA__08740__B2 _03473_ vssd1 vssd1 vccd1 vccd1 sky130_fd_sc_hd__diode_2
XANTENNA__08740__A1 _03477_ vssd1 vssd1 vccd1 vccd1 sky130_fd_sc_hd__diode_2
XFILLER_17_665 vssd1 vssd1 vccd1 vccd1 sky130_fd_sc_hd__fill_1
X_11976_ cell0.SB0.route_sel\[82\] cell0.SB0.route_sel\[81\] net785 vssd1 vssd1 vccd1
+ vccd1 _00413_ sky130_fd_sc_hd__mux2_1
X_13715_ clknet_leaf_28_clk _00687_ net618 vssd1 vssd1 vccd1 vccd1 cell2.CB_0.config_dataA\[17\]
+ sky130_fd_sc_hd__dfstp_2
XANTENNA__13703__SET_B net621 vssd1 vssd1 vccd1 vccd1 sky130_fd_sc_hd__diode_2
X_10927_ cell3.SB0.route_sel\[75\] cell3.SB0.route_sel\[74\] vssd1 vssd1 vccd1 vccd1
+ _05881_ sky130_fd_sc_hd__nor2_1
X_13646_ clknet_leaf_37_clk _00618_ net646 vssd1 vssd1 vccd1 vccd1 cell2.LE_1B.reset_val
+ sky130_fd_sc_hd__dfrtp_1
XFILLER_71_281 vssd1 vssd1 vccd1 vccd1 sky130_fd_sc_hd__fill_1
XFILLER_16_197 vssd1 vssd1 vccd1 vccd1 sky130_fd_sc_hd__fill_1
X_10858_ net15 net16 net365 vssd1 vssd1 vccd1 vccd1 _05814_ sky130_fd_sc_hd__mux2_1
XANTENNA__10546__A_N _05503_ vssd1 vssd1 vccd1 vccd1 sky130_fd_sc_hd__diode_2
X_10789_ net368 _05743_ _05744_ vssd1 vssd1 vccd1 vccd1 _05745_ sky130_fd_sc_hd__a21o_1
X_13577_ clknet_1_1__leaf_cell1.LE_0B.sel_clk _00549_ net753 vssd1 vssd1 vccd1 vccd1
+ cell1.LE_0B.dff1_out sky130_fd_sc_hd__dfstp_1
Xclkbuf_leaf_105_clk clknet_4_8_0_clk vssd1 vssd1 vccd1 vccd1 clknet_leaf_105_clk
+ sky130_fd_sc_hd__clkbuf_8
X_12528_ cell2.LEI0.config_data\[42\] cell2.LEI0.config_data\[41\] net839 vssd1 vssd1
+ vccd1 vccd1 _00957_ sky130_fd_sc_hd__mux2_1
X_12459_ cell2.LE_0B.reset_mode cell2.LE_0B.reset_val net851 vssd1 vssd1 vccd1 vccd1
+ _00890_ sky130_fd_sc_hd__mux2_1
XANTENNA__09756__A0 bus3_2\[12\] vssd1 vssd1 vccd1 vccd1 sky130_fd_sc_hd__diode_2
Xfanout309 net310 vssd1 vssd1 vccd1 vccd1 net309 sky130_fd_sc_hd__clkbuf_2
X_14129_ clknet_leaf_65_clk _01101_ net745 vssd1 vssd1 vccd1 vccd1 cell3.LE_1B.config_data\[9\]
+ sky130_fd_sc_hd__dfrtp_1
XANTENNA__09771__A3 bus3_2\[3\] vssd1 vssd1 vccd1 vccd1 sky130_fd_sc_hd__diode_2
XFILLER_98_156 vssd1 vssd1 vccd1 vccd1 sky130_fd_sc_hd__fill_2
XANTENNA__10118__A1 net64 vssd1 vssd1 vccd1 vccd1 sky130_fd_sc_hd__diode_2
X_06951_ net339 net358 net357 _02011_ _02013_ vssd1 vssd1 vccd1 vccd1 _02017_ sky130_fd_sc_hd__o32a_1
X_09670_ net277 _04265_ _04654_ _04656_ _04267_ vssd1 vssd1 vccd1 vccd1 _04685_ sky130_fd_sc_hd__o32a_1
XFILLER_95_841 vssd1 vssd1 vccd1 vccd1 sky130_fd_sc_hd__fill_1
XFILLER_39_234 vssd1 vssd1 vccd1 vccd1 sky130_fd_sc_hd__fill_1
XTAP_TAPCELL_ROW_87_1617 vssd1 vccd1 sky130_fd_sc_hd__tapvpwrvgnd_1
XTAP_TAPCELL_ROW_87_1606 vssd1 vccd1 sky130_fd_sc_hd__tapvpwrvgnd_1
X_06882_ net345 net359 _01947_ vssd1 vssd1 vccd1 vccd1 _01950_ sky130_fd_sc_hd__nor3_1
X_08621_ _03619_ _03656_ _03653_ vssd1 vssd1 vccd1 vccd1 _03657_ sky130_fd_sc_hd__o21ai_1
XFILLER_55_727 vssd1 vssd1 vccd1 vccd1 sky130_fd_sc_hd__fill_1
XFILLER_82_579 vssd1 vssd1 vccd1 vccd1 sky130_fd_sc_hd__fill_4
X_08552_ net490 net491 vssd1 vssd1 vccd1 vccd1 _03588_ sky130_fd_sc_hd__and2b_1
X_07503_ _02550_ _02552_ _02553_ _02551_ vssd1 vssd1 vccd1 vccd1 _02555_ sky130_fd_sc_hd__o31a_1
X_08483_ _03474_ _03514_ _03517_ _03478_ cell1.CB_1.config_dataA\[2\] vssd1 vssd1
+ vccd1 vccd1 _03519_ sky130_fd_sc_hd__a221o_1
XANTENNA__11850__S net897 vssd1 vssd1 vccd1 vccd1 sky130_fd_sc_hd__diode_2
X_07434_ cell0.CB_0.le_outB _01866_ _02339_ vssd1 vssd1 vccd1 vccd1 _02488_ sky130_fd_sc_hd__and3_1
XFILLER_50_421 vssd1 vssd1 vccd1 vccd1 sky130_fd_sc_hd__fill_1
XTAP_TAPCELL_ROW_46_991 vssd1 vccd1 sky130_fd_sc_hd__tapvpwrvgnd_1
XANTENNA__10054__A0 bus3_2\[0\] vssd1 vssd1 vccd1 vccd1 sky130_fd_sc_hd__diode_2
X_07365_ cell0.SB0.route_sel\[104\] cell0.SB0.route_sel\[105\] _02414_ _02420_ net774
+ vssd1 vssd1 vccd1 vccd1 _02421_ sky130_fd_sc_hd__a311oi_2
XANTENNA_fanout322_A cell1.CB_1.le_outB vssd1 vssd1 vccd1 vccd1 sky130_fd_sc_hd__diode_2
XANTENNA_clkbuf_4_8_0_clk_X clknet_4_8_0_clk vssd1 vssd1 vccd1 vccd1 sky130_fd_sc_hd__diode_2
X_09104_ _03868_ _04128_ _04129_ _03871_ vssd1 vssd1 vccd1 vccd1 _04134_ sky130_fd_sc_hd__a22o_1
X_07296_ _02327_ _02351_ _02353_ vssd1 vssd1 vccd1 vccd1 _02354_ sky130_fd_sc_hd__o21ba_1
XTAP_TAPCELL_ROW_98_1779 vssd1 vccd1 sky130_fd_sc_hd__tapvpwrvgnd_1
X_09035_ _03871_ _04054_ _04055_ _03868_ cell1.CB_0.config_dataB\[2\] vssd1 vssd1
+ vccd1 vccd1 _04065_ sky130_fd_sc_hd__a221o_1
Xhold330 cell2.LE_1B.config_data\[8\] vssd1 vssd1 vccd1 vccd1 net1289 sky130_fd_sc_hd__dlygate4sd3_1
XFILLER_132_710 vssd1 vssd1 vccd1 vccd1 sky130_fd_sc_hd__fill_1
XANTENNA_fanout691_A net750 vssd1 vssd1 vccd1 vccd1 sky130_fd_sc_hd__diode_2
Xhold341 _00122_ vssd1 vssd1 vccd1 vccd1 net1300 sky130_fd_sc_hd__dlygate4sd3_1
Xhold352 cell0.LE_1A.config_data\[3\] vssd1 vssd1 vccd1 vccd1 net1311 sky130_fd_sc_hd__dlygate4sd3_1
XANTENNA__07758__C1 net551 vssd1 vssd1 vccd1 vccd1 sky130_fd_sc_hd__diode_2
Xhold374 cell3.LE_0B.config_data\[15\] vssd1 vssd1 vccd1 vccd1 net1333 sky130_fd_sc_hd__dlygate4sd3_1
Xhold385 cell3.LE_1B.config_data\[10\] vssd1 vssd1 vccd1 vccd1 net1344 sky130_fd_sc_hd__dlygate4sd3_1
Xhold363 _00926_ vssd1 vssd1 vccd1 vccd1 net1322 sky130_fd_sc_hd__dlygate4sd3_1
Xhold396 cell1.LE_0A.config_data\[6\] vssd1 vssd1 vccd1 vccd1 net1355 sky130_fd_sc_hd__dlygate4sd3_1
XANTENNA_fanout789_A net790 vssd1 vssd1 vccd1 vccd1 sky130_fd_sc_hd__diode_2
Xfanout843 net845 vssd1 vssd1 vccd1 vccd1 net843 sky130_fd_sc_hd__clkbuf_4
Xfanout821 net828 vssd1 vssd1 vccd1 vccd1 net821 sky130_fd_sc_hd__clkbuf_2
Xfanout832 net833 vssd1 vssd1 vccd1 vccd1 net832 sky130_fd_sc_hd__clkbuf_4
X_09937_ _04641_ _04923_ cell2.CB_1.config_dataB\[2\] vssd1 vssd1 vccd1 vccd1 _04941_
+ sky130_fd_sc_hd__o21ai_1
Xfanout810 net811 vssd1 vssd1 vccd1 vccd1 net810 sky130_fd_sc_hd__buf_2
Xfanout854 net855 vssd1 vssd1 vccd1 vccd1 net854 sky130_fd_sc_hd__buf_2
XTAP_TAPCELL_ROW_129_2245 vssd1 vccd1 sky130_fd_sc_hd__tapvpwrvgnd_1
Xfanout876 net877 vssd1 vssd1 vccd1 vccd1 net876 sky130_fd_sc_hd__clkbuf_4
Xfanout865 net867 vssd1 vssd1 vccd1 vccd1 net865 sky130_fd_sc_hd__clkbuf_2
XFILLER_133_55 vssd1 vssd1 vccd1 vccd1 sky130_fd_sc_hd__fill_1
XFILLER_93_15 vccd1 vssd1 vccd1 vssd1 sky130_ef_sc_hd__decap_40_12
X_09868_ net439 _04583_ _04873_ net437 vssd1 vssd1 vccd1 vccd1 _04874_ sky130_fd_sc_hd__o211a_1
XFILLER_73_502 vssd1 vssd1 vccd1 vccd1 sky130_fd_sc_hd__fill_2
Xfanout898 net908 vssd1 vssd1 vccd1 vccd1 net898 sky130_fd_sc_hd__clkbuf_2
XTAP_TAPCELL_ROW_51_1075 vssd1 vccd1 sky130_fd_sc_hd__tapvpwrvgnd_1
XTAP_TAPCELL_ROW_5_388 vssd1 vccd1 sky130_fd_sc_hd__tapvpwrvgnd_1
XTAP_TAPCELL_ROW_5_377 vssd1 vccd1 sky130_fd_sc_hd__tapvpwrvgnd_1
XANTENNA__08722__A1 net5 vssd1 vssd1 vccd1 vccd1 sky130_fd_sc_hd__diode_2
Xfanout887 net908 vssd1 vssd1 vccd1 vccd1 net887 sky130_fd_sc_hd__clkbuf_4
XTAP_TAPCELL_ROW_142_2445 vssd1 vccd1 sky130_fd_sc_hd__tapvpwrvgnd_1
XTAP_TAPCELL_ROW_142_2434 vssd1 vccd1 sky130_fd_sc_hd__tapvpwrvgnd_1
X_09799_ _04796_ _04797_ _04798_ cell2.CB_1.config_dataA\[2\] vssd1 vssd1 vccd1 vccd1
+ _04805_ sky130_fd_sc_hd__o211ai_1
XFILLER_58_587 vssd1 vssd1 vccd1 vccd1 sky130_fd_sc_hd__fill_1
X_08819_ cell1.SB0.route_sel\[66\] cell1.SB0.route_sel\[67\] vssd1 vssd1 vccd1 vccd1
+ _03851_ sky130_fd_sc_hd__or2_1
XTAP_TAPCELL_ROW_142_2456 vssd1 vccd1 sky130_fd_sc_hd__tapvpwrvgnd_1
XFILLER_73_546 vssd1 vssd1 vccd1 vccd1 sky130_fd_sc_hd__fill_1
X_11830_ cell1.CB_1.config_dataA\[11\] net492 net886 vssd1 vssd1 vccd1 vccd1 _00267_
+ sky130_fd_sc_hd__mux2_1
XFILLER_26_20 vssd1 vssd1 vccd1 vccd1 sky130_fd_sc_hd__fill_8
X_11761_ cell0.LEI0.config_data\[11\] net1497 net799 vssd1 vssd1 vccd1 vccd1 _00198_
+ sky130_fd_sc_hd__mux2_1
XFILLER_26_53 vccd1 vssd1 vccd1 vssd1 sky130_ef_sc_hd__decap_40_12
X_10712_ cell3.CB_1.config_dataA\[19\] _05644_ _05658_ vssd1 vssd1 vccd1 vccd1 _05670_
+ sky130_fd_sc_hd__nand3_1
XFILLER_53_281 vssd1 vssd1 vccd1 vccd1 sky130_fd_sc_hd__fill_1
X_13500_ clknet_leaf_98_clk _00472_ net683 vssd1 vssd1 vccd1 vccd1 cell1.CB_1.config_dataB\[13\]
+ sky130_fd_sc_hd__dfstp_1
X_14480_ clknet_leaf_60_clk _01452_ net737 vssd1 vssd1 vccd1 vccd1 cell3.LEI0.config_data\[45\]
+ sky130_fd_sc_hd__dfrtp_1
X_11692_ net1022 cell0.LE_1A.config_data\[10\] net873 vssd1 vssd1 vccd1 vccd1 _00132_
+ sky130_fd_sc_hd__mux2_1
XANTENNA__13839__SET_B net674 vssd1 vssd1 vccd1 vccd1 sky130_fd_sc_hd__diode_2
XFILLER_9_105 vssd1 vssd1 vccd1 vccd1 sky130_fd_sc_hd__fill_4
XTAP_TAPCELL_ROW_24_663 vssd1 vccd1 sky130_fd_sc_hd__tapvpwrvgnd_1
XFILLER_139_331 vssd1 vssd1 vccd1 vccd1 sky130_fd_sc_hd__fill_1
X_10643_ cell3.LE_1A.config_data\[4\] cell3.LE_1A.config_data\[5\] _05600_ vssd1 vssd1
+ vccd1 vccd1 _05601_ sky130_fd_sc_hd__mux2_1
XFILLER_42_41 vssd1 vssd1 vccd1 vccd1 sky130_fd_sc_hd__fill_2
XTAP_TAPCELL_ROW_24_674 vssd1 vccd1 sky130_fd_sc_hd__tapvpwrvgnd_1
X_13431_ clknet_leaf_131_clk _00403_ net562 vssd1 vssd1 vccd1 vccd1 cell0.SB0.route_sel\[72\]
+ sky130_fd_sc_hd__dfstp_1
XANTENNA__11242__C1 net352 vssd1 vssd1 vccd1 vccd1 sky130_fd_sc_hd__diode_2
X_10574_ _05531_ vssd1 vssd1 vccd1 vccd1 _05532_ sky130_fd_sc_hd__inv_2
XANTENNA_input85_A SBsouth_in[28] vssd1 vssd1 vccd1 vccd1 sky130_fd_sc_hd__diode_2
X_13362_ clknet_leaf_127_clk _00334_ net576 vssd1 vssd1 vccd1 vccd1 cell0.SB0.route_sel\[3\]
+ sky130_fd_sc_hd__dfstp_1
XFILLER_10_841 vssd1 vssd1 vccd1 vccd1 sky130_fd_sc_hd__fill_1
XANTENNA_clkbuf_leaf_5_clk_A clknet_4_1_0_clk vssd1 vssd1 vccd1 vccd1 sky130_fd_sc_hd__diode_2
X_12313_ cell1.SB0.route_sel\[51\] cell1.SB0.route_sel\[50\] net857 vssd1 vssd1 vccd1
+ vccd1 _00746_ sky130_fd_sc_hd__mux2_1
XANTENNA__10060__A3 net302 vssd1 vssd1 vccd1 vccd1 sky130_fd_sc_hd__diode_2
X_13293_ clknet_leaf_101_clk _00265_ net679 vssd1 vssd1 vccd1 vccd1 cell1.CB_1.config_dataA\[9\]
+ sky130_fd_sc_hd__dfstp_1
X_12244_ cell2.CB_0.config_dataA\[7\] net417 net823 vssd1 vssd1 vccd1 vccd1 _00677_
+ sky130_fd_sc_hd__mux2_1
X_12175_ net1289 net1199 net852 vssd1 vssd1 vccd1 vccd1 _00608_ sky130_fd_sc_hd__mux2_1
XANTENNA__10899__A2 _05847_ vssd1 vssd1 vccd1 vccd1 sky130_fd_sc_hd__diode_2
XANTENNA_input40_X net40 vssd1 vssd1 vccd1 vccd1 sky130_fd_sc_hd__diode_2
X_11126_ net386 net387 vssd1 vssd1 vccd1 vccd1 _06078_ sky130_fd_sc_hd__nor2_1
XFILLER_68_329 vssd1 vssd1 vccd1 vccd1 sky130_fd_sc_hd__fill_1
XFILLER_1_561 vccd1 vssd1 vccd1 vssd1 sky130_ef_sc_hd__decap_40_12
XANTENNA_output241_A net241 vssd1 vssd1 vccd1 vccd1 sky130_fd_sc_hd__diode_2
XFILLER_77_841 vssd1 vssd1 vccd1 vccd1 sky130_fd_sc_hd__fill_1
XFILLER_77_830 vssd1 vssd1 vccd1 vccd1 sky130_fd_sc_hd__fill_1
XFILLER_3_57 vccd1 vssd1 vccd1 vssd1 sky130_ef_sc_hd__decap_40_12
X_11057_ _05902_ _05997_ _05999_ _05898_ _01812_ vssd1 vssd1 vccd1 vccd1 _06011_ sky130_fd_sc_hd__a221oi_1
XFILLER_95_159 vssd1 vssd1 vccd1 vccd1 sky130_fd_sc_hd__fill_8
X_10008_ cell2.CB_1.config_dataB\[13\] cell2.CB_1.config_dataB\[12\] vssd1 vssd1 vccd1
+ vccd1 _05012_ sky130_fd_sc_hd__nor2_1
XFILLER_92_822 vssd1 vssd1 vccd1 vccd1 sky130_fd_sc_hd__fill_1
XTAP_TAPCELL_ROW_69_1336 vssd1 vccd1 sky130_fd_sc_hd__tapvpwrvgnd_1
XTAP_TAPCELL_ROW_69_1347 vssd1 vccd1 sky130_fd_sc_hd__tapvpwrvgnd_1
XTAP_TAPCELL_ROW_82_1536 vssd1 vccd1 sky130_fd_sc_hd__tapvpwrvgnd_1
X_11959_ cell0.SB0.route_sel\[65\] cell0.SB0.route_sel\[64\] net765 vssd1 vssd1 vccd1
+ vccd1 _00396_ sky130_fd_sc_hd__mux2_1
XFILLER_32_421 vssd1 vssd1 vccd1 vccd1 sky130_fd_sc_hd__fill_1
XANTENNA__09140__S _04120_ vssd1 vssd1 vccd1 vccd1 sky130_fd_sc_hd__diode_2
XTAP_TAPCELL_ROW_43_950 vssd1 vccd1 sky130_fd_sc_hd__tapvpwrvgnd_1
XFILLER_32_454 vssd1 vssd1 vccd1 vccd1 sky130_fd_sc_hd__fill_1
X_13629_ clknet_leaf_39_clk _00601_ net645 vssd1 vssd1 vccd1 vccd1 cell2.LE_1B.config_data\[1\]
+ sky130_fd_sc_hd__dfrtp_1
XANTENNA__08229__A0 bus1_0\[12\] vssd1 vssd1 vccd1 vccd1 sky130_fd_sc_hd__diode_2
X_07150_ net361 net357 net341 _02210_ vssd1 vssd1 vccd1 vccd1 _02212_ sky130_fd_sc_hd__o211ai_2
XFILLER_8_171 vccd1 vssd1 vccd1 vssd1 sky130_ef_sc_hd__decap_40_12
XFILLER_8_160 vssd1 vssd1 vccd1 vccd1 sky130_fd_sc_hd__fill_1
X_07081_ net32 _02144_ vssd1 vssd1 vccd1 vccd1 _02145_ sky130_fd_sc_hd__or2_1
XTAP_TAPCELL_ROW_113_2002 vssd1 vccd1 sky130_fd_sc_hd__tapvpwrvgnd_1
XANTENNA__09729__B1 net262 vssd1 vssd1 vccd1 vccd1 sky130_fd_sc_hd__diode_2
XANTENNA__10339__A1 net37 vssd1 vssd1 vccd1 vccd1 sky130_fd_sc_hd__diode_2
XANTENNA__10315__A _05136_ vssd1 vssd1 vccd1 vccd1 sky130_fd_sc_hd__diode_2
XTAP_TAPCELL_ROW_93_1698 vssd1 vccd1 sky130_fd_sc_hd__tapvpwrvgnd_1
XANTENNA__08952__A1 _03890_ vssd1 vssd1 vccd1 vccd1 sky130_fd_sc_hd__diode_2
XANTENNA__08952__B2 _03894_ vssd1 vssd1 vccd1 vccd1 sky130_fd_sc_hd__diode_2
X_09722_ _04366_ _04656_ vssd1 vssd1 vccd1 vccd1 _04735_ sky130_fd_sc_hd__nor2_1
XFILLER_101_437 vssd1 vssd1 vccd1 vccd1 sky130_fd_sc_hd__fill_2
XANTENNA__10034__B _04583_ vssd1 vssd1 vccd1 vccd1 sky130_fd_sc_hd__diode_2
XANTENNA__11845__S net883 vssd1 vssd1 vccd1 vccd1 sky130_fd_sc_hd__diode_2
X_07983_ _01576_ cell0.LE_0A.dff_out vssd1 vssd1 vccd1 vccd1 _03026_ sky130_fd_sc_hd__or2_1
X_06934_ _02000_ vssd1 vssd1 vccd1 vccd1 _02001_ sky130_fd_sc_hd__inv_2
X_09653_ _02438_ _02440_ _04665_ _04667_ vssd1 vssd1 vccd1 vccd1 _04668_ sky130_fd_sc_hd__a31o_1
XTAP_TAPCELL_ROW_2_336 vssd1 vccd1 sky130_fd_sc_hd__tapvpwrvgnd_1
X_06865_ cell0.CB_1.config_dataB\[24\] cell0.CB_1.config_dataB\[20\] cell0.CB_1.config_dataB\[21\]
+ vssd1 vssd1 vccd1 vccd1 _01933_ sky130_fd_sc_hd__nand3b_4
X_09584_ _04589_ _04595_ _04601_ vssd1 vssd1 vccd1 vccd1 _04602_ sky130_fd_sc_hd__a21oi_1
XANTENNA__08180__A2 bus1_0\[10\] vssd1 vssd1 vccd1 vccd1 sky130_fd_sc_hd__diode_2
X_08604_ net489 _03486_ net487 vssd1 vssd1 vccd1 vccd1 _03640_ sky130_fd_sc_hd__o21ai_1
XTAP_TAPCELL_ROW_124_2175 vssd1 vccd1 sky130_fd_sc_hd__tapvpwrvgnd_1
XTAP_TAPCELL_ROW_124_2164 vssd1 vccd1 sky130_fd_sc_hd__tapvpwrvgnd_1
XPHY_EDGE_ROW_118_Right_118 vssd1 vssd1 vccd1 vccd1 sky130_fd_sc_hd__decap_3
X_06796_ cell0.CB_0.config_dataB\[24\] cell0.CB_0.config_dataB\[20\] cell0.CB_0.config_dataB\[21\]
+ vssd1 vssd1 vccd1 vccd1 _01866_ sky130_fd_sc_hd__nor3b_1
X_08535_ net495 _03468_ vssd1 vssd1 vccd1 vccd1 _03571_ sky130_fd_sc_hd__nand2_1
Xclkbuf_1_1__f_cell1.LE_1A.sel_clk clknet_0_cell1.LE_1A.sel_clk vssd1 vssd1 vccd1
+ vccd1 clknet_1_1__leaf_cell1.LE_1A.sel_clk sky130_fd_sc_hd__clkbuf_16
XANTENNA__10814__A2 net10 vssd1 vssd1 vccd1 vccd1 sky130_fd_sc_hd__diode_2
XFILLER_51_752 vssd1 vssd1 vccd1 vccd1 sky130_fd_sc_hd__fill_1
X_08466_ cell1.SB0.route_sel\[16\] cell1.SB0.route_sel\[17\] vssd1 vssd1 vccd1 vccd1
+ _03502_ sky130_fd_sc_hd__nand2b_1
X_07417_ _02469_ _02471_ vssd1 vssd1 vccd1 vccd1 bus2_0\[13\] sky130_fd_sc_hd__and2b_2
XFILLER_11_638 vccd1 vssd1 vccd1 vssd1 sky130_ef_sc_hd__decap_40_12
X_08397_ _02633_ _03420_ _03422_ _02678_ cell0.CB_1.config_dataB\[17\] vssd1 vssd1
+ vccd1 vccd1 _03435_ sky130_fd_sc_hd__a221o_1
X_07348_ _02404_ _02402_ vssd1 vssd1 vccd1 vccd1 bus2_0\[12\] sky130_fd_sc_hd__and2b_2
XTAP_TAPCELL_ROW_21_622 vssd1 vccd1 sky130_fd_sc_hd__tapvpwrvgnd_1
XFILLER_12_22 vssd1 vssd1 vccd1 vccd1 sky130_fd_sc_hd__fill_4
X_07279_ _02026_ _02336_ vssd1 vssd1 vccd1 vccd1 _02337_ sky130_fd_sc_hd__nor2_1
XFILLER_12_77 vssd1 vssd1 vccd1 vccd1 sky130_fd_sc_hd__fill_4
X_10290_ net61 net62 net432 vssd1 vssd1 vccd1 vccd1 _05289_ sky130_fd_sc_hd__mux2_1
XANTENNA__07994__A2 bus2_0\[14\] vssd1 vssd1 vccd1 vccd1 sky130_fd_sc_hd__diode_2
X_09018_ net332 cell1.CB_0.le_outB net337 net324 cell1.LEI0.config_data\[15\] cell1.LEI0.config_data\[16\]
+ vssd1 vssd1 vccd1 vccd1 _04048_ sky130_fd_sc_hd__mux4_1
XFILLER_3_837 vssd1 vssd1 vccd1 vccd1 sky130_fd_sc_hd__fill_1
Xhold160 cell3.LE_0B.config_data\[6\] vssd1 vssd1 vccd1 vccd1 net1119 sky130_fd_sc_hd__dlygate4sd3_1
Xhold171 cell3.LE_0A.config_data\[12\] vssd1 vssd1 vccd1 vccd1 net1130 sky130_fd_sc_hd__dlygate4sd3_1
XANTENNA__13942__RESET_B net752 vssd1 vssd1 vccd1 vccd1 sky130_fd_sc_hd__diode_2
XTAP_TAPCELL_ROW_53_1104 vssd1 vccd1 sky130_fd_sc_hd__tapvpwrvgnd_1
Xhold182 cell1.LE_0A.config_data\[11\] vssd1 vssd1 vccd1 vccd1 net1141 sky130_fd_sc_hd__dlygate4sd3_1
Xhold193 cell0.LE_1A.config_data\[5\] vssd1 vssd1 vccd1 vccd1 net1152 sky130_fd_sc_hd__dlygate4sd3_1
XANTENNA_fanout959_X net959 vssd1 vssd1 vccd1 vccd1 sky130_fd_sc_hd__diode_2
Xfanout640 net650 vssd1 vssd1 vccd1 vccd1 net640 sky130_fd_sc_hd__clkbuf_2
Xfanout651 net657 vssd1 vssd1 vccd1 vccd1 net651 sky130_fd_sc_hd__clkbuf_4
X_13980_ clknet_leaf_42_clk _00952_ net634 vssd1 vssd1 vccd1 vccd1 cell2.LEI0.config_data\[37\]
+ sky130_fd_sc_hd__dfrtp_1
Xfanout673 net674 vssd1 vssd1 vccd1 vccd1 net673 sky130_fd_sc_hd__clkbuf_4
Xfanout684 net750 vssd1 vssd1 vccd1 vccd1 net684 sky130_fd_sc_hd__clkbuf_2
Xfanout662 net663 vssd1 vssd1 vccd1 vccd1 net662 sky130_fd_sc_hd__clkbuf_4
X_12931_ cell3.LE_1A.reset_mode net1505 net956 vssd1 vssd1 vccd1 vccd1 _01360_ sky130_fd_sc_hd__mux2_1
XTAP_TAPCELL_ROW_109_1937 vssd1 vccd1 sky130_fd_sc_hd__tapvpwrvgnd_1
XFILLER_86_682 vssd1 vssd1 vccd1 vccd1 sky130_fd_sc_hd__fill_1
XFILLER_74_811 vssd1 vssd1 vccd1 vccd1 sky130_fd_sc_hd__fill_1
Xfanout695 net700 vssd1 vssd1 vccd1 vccd1 net695 sky130_fd_sc_hd__clkbuf_2
XFILLER_19_727 vssd1 vssd1 vccd1 vccd1 sky130_fd_sc_hd__fill_1
XTAP_TAPCELL_ROW_109_1948 vssd1 vccd1 sky130_fd_sc_hd__tapvpwrvgnd_1
X_12862_ cell2.SB0.route_sel\[104\] cell2.SB0.route_sel\[103\] net819 vssd1 vssd1
+ vccd1 vccd1 _01291_ sky130_fd_sc_hd__mux2_1
XTAP_TAPCELL_ROW_29_744 vssd1 vccd1 sky130_fd_sc_hd__tapvpwrvgnd_1
X_11813_ cell1.LE_1B.config_data\[14\] net1525 net905 vssd1 vssd1 vccd1 vccd1 _00250_
+ sky130_fd_sc_hd__mux2_1
X_12793_ cell2.SB0.route_sel\[35\] cell2.SB0.route_sel\[34\] net820 vssd1 vssd1 vccd1
+ vccd1 _01222_ sky130_fd_sc_hd__mux2_1
XANTENNA__09120__A1 bus3_1\[9\] vssd1 vssd1 vccd1 vccd1 sky130_fd_sc_hd__diode_2
XTAP_TAPCELL_ROW_64_1266 vssd1 vccd1 sky130_fd_sc_hd__tapvpwrvgnd_1
X_11744_ cell0.LE_0A.edge_mode net1157 net795 vssd1 vssd1 vccd1 vccd1 _00182_ sky130_fd_sc_hd__mux2_1
X_14463_ clknet_leaf_62_clk _01435_ net741 vssd1 vssd1 vccd1 vccd1 cell3.LEI0.config_data\[28\]
+ sky130_fd_sc_hd__dfrtp_1
X_11675_ cell0.CB_1.config_dataB\[21\] cell0.CB_1.config_dataB\[20\] net784 vssd1
+ vssd1 vccd1 vccd1 _00116_ sky130_fd_sc_hd__mux2_1
XFILLER_128_813 vssd1 vssd1 vccd1 vccd1 sky130_fd_sc_hd__fill_2
XANTENNA__09959__A0 bus3_2\[6\] vssd1 vssd1 vccd1 vccd1 sky130_fd_sc_hd__diode_2
XANTENNA__09748__X bus2_0\[5\] vssd1 vssd1 vccd1 vccd1 sky130_fd_sc_hd__diode_2
X_10626_ net396 _05581_ _05582_ _05583_ _01784_ vssd1 vssd1 vccd1 vccd1 _05584_ sky130_fd_sc_hd__a2111o_1
X_13414_ clknet_leaf_133_clk _00386_ net556 vssd1 vssd1 vccd1 vccd1 cell0.SB0.route_sel\[55\]
+ sky130_fd_sc_hd__dfstp_1
XANTENNA_output191_A net191 vssd1 vssd1 vccd1 vccd1 sky130_fd_sc_hd__diode_2
X_14394_ clknet_leaf_57_clk _01366_ net721 vssd1 vssd1 vccd1 vccd1 cell3.LE_0B.config_data\[3\]
+ sky130_fd_sc_hd__dfrtp_1
XANTENNA_input88_X net88 vssd1 vssd1 vccd1 vccd1 sky130_fd_sc_hd__diode_2
X_10557_ _05485_ _05510_ _05514_ _05507_ vssd1 vssd1 vccd1 vccd1 _05515_ sky130_fd_sc_hd__a211oi_1
XANTENNA__09974__A3 bus3_2\[11\] vssd1 vssd1 vccd1 vccd1 sky130_fd_sc_hd__diode_2
X_13345_ clknet_leaf_113_clk _00317_ net673 vssd1 vssd1 vccd1 vccd1 cell1.CB_0.config_dataA\[11\]
+ sky130_fd_sc_hd__dfstp_1
XFILLER_6_642 vssd1 vssd1 vccd1 vccd1 sky130_fd_sc_hd__fill_2
XFILLER_10_693 vssd1 vssd1 vccd1 vccd1 sky130_fd_sc_hd__fill_4
X_13276_ clknet_leaf_93_clk _00248_ net694 vssd1 vssd1 vccd1 vccd1 cell1.LE_1B.config_data\[12\]
+ sky130_fd_sc_hd__dfrtp_1
XFILLER_6_697 vssd1 vssd1 vccd1 vccd1 sky130_fd_sc_hd__fill_2
X_10488_ _05459_ net334 _02727_ vssd1 vssd1 vccd1 vccd1 net156 sky130_fd_sc_hd__mux2_1
X_12227_ net424 cell2.CB_0.config_dataB\[14\] net824 vssd1 vssd1 vccd1 vccd1 _00660_
+ sky130_fd_sc_hd__mux2_1
XANTENNA__08934__A1 net327 vssd1 vssd1 vccd1 vccd1 sky130_fd_sc_hd__diode_2
XFILLER_68_126 vssd1 vssd1 vccd1 vccd1 sky130_fd_sc_hd__fill_1
X_12158_ net1302 net1270 net894 vssd1 vssd1 vccd1 vccd1 _00591_ sky130_fd_sc_hd__mux2_1
X_11109_ _01796_ _05890_ _06060_ vssd1 vssd1 vccd1 vccd1 _06061_ sky130_fd_sc_hd__o21ai_1
X_12089_ cell1.LE_0B.edge_mode cell1.LE_0B.config_data\[16\] net906 vssd1 vssd1 vccd1
+ vccd1 _00524_ sky130_fd_sc_hd__mux2_1
XFILLER_1_391 vssd1 vssd1 vccd1 vccd1 sky130_fd_sc_hd__fill_1
XFILLER_77_682 vssd1 vssd1 vccd1 vccd1 sky130_fd_sc_hd__fill_2
XFILLER_76_170 vssd1 vssd1 vccd1 vccd1 sky130_fd_sc_hd__fill_4
X_06650_ cell3.SB0.route_sel\[70\] vssd1 vssd1 vccd1 vccd1 _01720_ sky130_fd_sc_hd__inv_2
XANTENNA__07731__X _02778_ vssd1 vssd1 vccd1 vccd1 sky130_fd_sc_hd__diode_2
XANTENNA__11049__A2 net51 vssd1 vssd1 vccd1 vccd1 sky130_fd_sc_hd__diode_2
XANTENNA__10257__A0 net63 vssd1 vssd1 vccd1 vccd1 sky130_fd_sc_hd__diode_2
X_06581_ cell2.SB0.route_sel\[126\] vssd1 vssd1 vccd1 vccd1 _01651_ sky130_fd_sc_hd__inv_2
XANTENNA__07122__B1 _02184_ vssd1 vssd1 vccd1 vccd1 sky130_fd_sc_hd__diode_2
X_08320_ net508 _03356_ _03357_ vssd1 vssd1 vccd1 vccd1 _03358_ sky130_fd_sc_hd__a21oi_1
X_08251_ _03285_ _03288_ _03290_ cell0.CB_1.config_dataA\[17\] vssd1 vssd1 vccd1 vccd1
+ _03291_ sky130_fd_sc_hd__o22a_1
XFILLER_33_785 vssd1 vssd1 vccd1 vccd1 sky130_fd_sc_hd__fill_1
XANTENNA__10009__A0 bus3_2\[6\] vssd1 vssd1 vccd1 vccd1 sky130_fd_sc_hd__diode_2
XANTENNA__09658__X _04673_ vssd1 vssd1 vccd1 vccd1 sky130_fd_sc_hd__diode_2
X_07202_ _02257_ _02259_ _02261_ _02260_ vssd1 vssd1 vccd1 vccd1 _02262_ sky130_fd_sc_hd__a31o_1
X_08182_ _03220_ _03221_ cell0.CB_1.config_dataA\[7\] vssd1 vssd1 vccd1 vccd1 _03222_
+ sky130_fd_sc_hd__mux2_1
XTAP_TAPCELL_ROW_95_1738 vssd1 vccd1 sky130_fd_sc_hd__tapvpwrvgnd_1
XTAP_TAPCELL_ROW_95_1727 vssd1 vccd1 sky130_fd_sc_hd__tapvpwrvgnd_1
X_07133_ _02190_ _02191_ _02194_ _02193_ vssd1 vssd1 vccd1 vccd1 _02195_ sky130_fd_sc_hd__a31o_1
X_07064_ net345 _02032_ _02125_ vssd1 vssd1 vccd1 vccd1 _02128_ sky130_fd_sc_hd__nor3_1
Xoutput210 net210 vssd1 vssd1 vccd1 vccd1 SBsouth_out[20] sky130_fd_sc_hd__buf_2
XPHY_EDGE_ROW_12_Right_12 vssd1 vssd1 vccd1 vccd1 sky130_fd_sc_hd__decap_3
Xoutput243 net243 vssd1 vssd1 vccd1 vccd1 SBwest_out[21] sky130_fd_sc_hd__buf_2
Xoutput232 net232 vssd1 vssd1 vccd1 vccd1 SBwest_out[11] sky130_fd_sc_hd__buf_2
XTAP_TAPCELL_ROW_7_406 vssd1 vccd1 sky130_fd_sc_hd__tapvpwrvgnd_1
Xoutput221 net221 vssd1 vssd1 vccd1 vccd1 SBsouth_out[30] sky130_fd_sc_hd__buf_2
Xoutput254 net254 vssd1 vssd1 vccd1 vccd1 SBwest_out[31] sky130_fd_sc_hd__buf_2
XANTENNA__07189__A0 net34 vssd1 vssd1 vccd1 vccd1 sky130_fd_sc_hd__diode_2
XTAP_TAPCELL_ROW_7_417 vssd1 vccd1 sky130_fd_sc_hd__tapvpwrvgnd_1
XFILLER_141_370 vssd1 vssd1 vccd1 vccd1 sky130_fd_sc_hd__fill_1
XFILLER_101_223 vssd1 vssd1 vccd1 vccd1 sky130_fd_sc_hd__fill_1
XFILLER_99_284 vssd1 vssd1 vccd1 vccd1 sky130_fd_sc_hd__fill_1
XTAP_TAPCELL_ROW_126_2204 vssd1 vccd1 sky130_fd_sc_hd__tapvpwrvgnd_1
X_07966_ net344 net347 cell0.CB_1.le_outA cell0.CB_1.le_outB cell0.LEI0.config_data\[36\]
+ cell0.LEI0.config_data\[37\] vssd1 vssd1 vccd1 vccd1 _03010_ sky130_fd_sc_hd__mux4_1
X_09705_ cell3.SB0.route_sel\[125\] cell3.SB0.route_sel\[124\] vssd1 vssd1 vccd1 vccd1
+ _04718_ sky130_fd_sc_hd__nand2_1
XANTENNA__08689__A0 net29 vssd1 vssd1 vccd1 vccd1 sky130_fd_sc_hd__diode_2
X_06917_ cell0.SB0.route_sel\[59\] cell0.SB0.route_sel\[58\] vssd1 vssd1 vccd1 vccd1
+ _01984_ sky130_fd_sc_hd__nor2_1
XANTENNA__06951__A3 net357 vssd1 vssd1 vccd1 vccd1 sky130_fd_sc_hd__diode_2
X_09636_ net296 _04650_ _04651_ _04648_ _04638_ vssd1 vssd1 vccd1 vccd1 _04652_ sky130_fd_sc_hd__a221o_1
X_07897_ bus2_0\[8\] bus2_0\[9\] bus2_0\[10\] bus2_0\[11\] net521 net520 vssd1 vssd1
+ vccd1 vccd1 _02941_ sky130_fd_sc_hd__mux4_1
XFILLER_55_343 vssd1 vssd1 vccd1 vccd1 sky130_fd_sc_hd__fill_1
Xclkbuf_leaf_94_clk clknet_4_11_0_clk vssd1 vssd1 vccd1 vccd1 clknet_leaf_94_clk sky130_fd_sc_hd__clkbuf_8
X_06848_ cell2.SB0.route_sel\[54\] cell2.SB0.route_sel\[55\] _01614_ _01915_ vssd1
+ vssd1 vccd1 vccd1 _01917_ sky130_fd_sc_hd__a211o_1
XANTENNA__07361__B1 bus2_0\[13\] vssd1 vssd1 vccd1 vccd1 sky130_fd_sc_hd__diode_2
XANTENNA__07900__A2 cell0.CB_1.le_outA vssd1 vssd1 vccd1 vccd1 sky130_fd_sc_hd__diode_2
XPHY_EDGE_ROW_21_Right_21 vssd1 vssd1 vccd1 vccd1 sky130_fd_sc_hd__decap_3
XTAP_TAPCELL_ROW_26_703 vssd1 vccd1 sky130_fd_sc_hd__tapvpwrvgnd_1
Xclkbuf_1_1__f_cell3.LE_1B.sel_clk clknet_0_cell3.LE_1B.sel_clk vssd1 vssd1 vccd1
+ vccd1 clknet_1_1__leaf_cell3.LE_1B.sel_clk sky130_fd_sc_hd__clkbuf_16
XANTENNA_fanout821_A net828 vssd1 vssd1 vccd1 vccd1 sky130_fd_sc_hd__diode_2
X_09567_ cell3.SB0.route_sel\[87\] cell3.SB0.route_sel\[86\] _02245_ vssd1 vssd1 vccd1
+ vccd1 _04585_ sky130_fd_sc_hd__a21oi_1
XFILLER_71_847 vssd1 vssd1 vccd1 vccd1 sky130_fd_sc_hd__fill_1
X_06779_ cell0.CB_1.config_dataA\[23\] cell0.CB_1.config_dataA\[22\] vssd1 vssd1 vccd1
+ vccd1 _01849_ sky130_fd_sc_hd__nand2b_1
XTAP_TAPCELL_ROW_104_1867 vssd1 vccd1 sky130_fd_sc_hd__tapvpwrvgnd_1
XFILLER_90_27 vssd1 vssd1 vccd1 vccd1 sky130_fd_sc_hd__fill_1
X_09498_ _04518_ _04507_ vssd1 vssd1 vccd1 vccd1 _04519_ sky130_fd_sc_hd__and2b_1
X_08518_ cell1.CB_1.config_dataA\[8\] cell1.CB_1.config_dataA\[7\] vssd1 vssd1 vccd1
+ vccd1 _03554_ sky130_fd_sc_hd__nor2_1
XANTENNA__10799__A1 net291 vssd1 vssd1 vccd1 vccd1 sky130_fd_sc_hd__diode_2
XANTENNA__11323__B _05519_ vssd1 vssd1 vccd1 vccd1 sky130_fd_sc_hd__diode_2
X_08449_ cell1.SB0.route_sel\[117\] cell1.SB0.route_sel\[116\] cell1.SB0.route_sel\[119\]
+ _01549_ _03484_ vssd1 vssd1 vccd1 vccd1 _03485_ sky130_fd_sc_hd__o221a_1
XTAP_TAPCELL_ROW_137_2366 vssd1 vccd1 sky130_fd_sc_hd__tapvpwrvgnd_1
X_11460_ cell1.SB0.route_sel\[62\] cell1.SB0.route_sel\[63\] vssd1 vssd1 vccd1 vccd1
+ _06307_ sky130_fd_sc_hd__nor2_1
X_10411_ _01760_ _05392_ _05395_ _05409_ _01762_ vssd1 vssd1 vccd1 vccd1 _05410_ sky130_fd_sc_hd__o311a_1
XANTENNA__11212__A2 net51 vssd1 vssd1 vccd1 vccd1 sky130_fd_sc_hd__diode_2
XFILLER_99_25 vccd1 vssd1 vccd1 vssd1 sky130_ef_sc_hd__decap_40_12
XFILLER_99_47 vssd1 vssd1 vccd1 vccd1 sky130_fd_sc_hd__fill_1
XFILLER_23_98 vssd1 vssd1 vccd1 vccd1 sky130_fd_sc_hd__fill_2
X_11391_ cell0.SB0.route_sel\[64\] _01466_ vssd1 vssd1 vccd1 vccd1 _06261_ sky130_fd_sc_hd__nand2_1
XPHY_EDGE_ROW_30_Right_30 vssd1 vssd1 vccd1 vccd1 sky130_fd_sc_hd__decap_3
X_10342_ _05319_ _05326_ _05335_ _05340_ cell2.CB_0.config_dataB\[4\] vssd1 vssd1
+ vccd1 vccd1 _05341_ sky130_fd_sc_hd__a221o_1
X_13130_ clknet_leaf_128_clk _00102_ net577 vssd1 vssd1 vccd1 vccd1 cell0.CB_1.config_dataB\[7\]
+ sky130_fd_sc_hd__dfstp_2
X_13061_ clknet_leaf_109_clk _00033_ net651 vssd1 vssd1 vccd1 vccd1 cell0.CB_1.config_dataA\[13\]
+ sky130_fd_sc_hd__dfstp_1
X_10273_ _05273_ _05272_ _05164_ vssd1 vssd1 vccd1 vccd1 _05274_ sky130_fd_sc_hd__mux2_1
X_12012_ cell0.SB0.route_sel\[118\] cell0.SB0.route_sel\[117\] net774 vssd1 vssd1
+ vccd1 vccd1 _00449_ sky130_fd_sc_hd__mux2_1
XFILLER_2_133 vssd1 vssd1 vccd1 vccd1 sky130_fd_sc_hd__fill_4
XANTENNA_input48_A CBnorth_in[23] vssd1 vssd1 vccd1 vccd1 sky130_fd_sc_hd__diode_2
XANTENNA__06927__B1 bus3_2\[7\] vssd1 vssd1 vccd1 vccd1 sky130_fd_sc_hd__diode_2
XFILLER_2_177 vccd1 vssd1 vccd1 vssd1 sky130_ef_sc_hd__decap_40_12
XANTENNA__11338__X net179 vssd1 vssd1 vccd1 vccd1 sky130_fd_sc_hd__diode_2
XFILLER_78_479 vssd1 vssd1 vccd1 vccd1 sky130_fd_sc_hd__fill_2
Xfanout481 cell1.CB_0.config_dataB\[6\] vssd1 vssd1 vccd1 vccd1 net481 sky130_fd_sc_hd__buf_2
Xfanout470 cell1.CB_0.config_dataA\[5\] vssd1 vssd1 vccd1 vccd1 net470 sky130_fd_sc_hd__buf_2
Xfanout492 cell1.CB_1.config_dataA\[10\] vssd1 vssd1 vccd1 vccd1 net492 sky130_fd_sc_hd__buf_2
XFILLER_19_513 vssd1 vssd1 vccd1 vccd1 sky130_fd_sc_hd__fill_2
X_13963_ clknet_leaf_37_clk _00935_ net645 vssd1 vssd1 vccd1 vccd1 cell2.LEI0.config_data\[20\]
+ sky130_fd_sc_hd__dfrtp_1
Xclkbuf_leaf_85_clk clknet_4_11_0_clk vssd1 vssd1 vccd1 vccd1 clknet_leaf_85_clk sky130_fd_sc_hd__clkbuf_8
X_13894_ clknet_leaf_39_clk _00866_ net644 vssd1 vssd1 vccd1 vccd1 cell2.LE_1A.edge_mode
+ sky130_fd_sc_hd__dfstp_1
X_12914_ net1406 net1410 net954 vssd1 vssd1 vccd1 vccd1 _01343_ sky130_fd_sc_hd__mux2_1
XFILLER_0_69 vssd1 vssd1 vccd1 vccd1 sky130_fd_sc_hd__fill_1
XANTENNA__07352__B1 bus1_0\[13\] vssd1 vssd1 vccd1 vccd1 sky130_fd_sc_hd__diode_2
X_12845_ cell2.SB0.route_sel\[87\] cell2.SB0.route_sel\[86\] net797 vssd1 vssd1 vccd1
+ vccd1 _01274_ sky130_fd_sc_hd__mux2_1
XFILLER_62_847 vssd1 vssd1 vccd1 vccd1 sky130_fd_sc_hd__fill_1
XANTENNA_output204_A net204 vssd1 vssd1 vccd1 vccd1 sky130_fd_sc_hd__diode_2
X_12776_ cell2.SB0.route_sel\[18\] cell2.SB0.route_sel\[17\] net816 vssd1 vssd1 vccd1
+ vccd1 _01205_ sky130_fd_sc_hd__mux2_1
X_11727_ net1117 net129 net808 vssd1 vssd1 vccd1 vccd1 _00165_ sky130_fd_sc_hd__mux2_1
XFILLER_15_785 vssd1 vssd1 vccd1 vccd1 sky130_fd_sc_hd__fill_1
X_14446_ clknet_leaf_67_clk _01418_ net736 vssd1 vssd1 vccd1 vccd1 cell3.LEI0.config_data\[11\]
+ sky130_fd_sc_hd__dfrtp_1
X_11658_ cell0.CB_1.config_dataB\[4\] cell0.CB_1.config_dataB\[3\] net789 vssd1 vssd1
+ vccd1 vccd1 _00099_ sky130_fd_sc_hd__mux2_1
X_14377_ clknet_leaf_70_clk net1393 net731 vssd1 vssd1 vccd1 vccd1 cell3.LE_1A.config_data\[8\]
+ sky130_fd_sc_hd__dfrtp_1
X_10609_ _04662_ _05527_ _05566_ vssd1 vssd1 vccd1 vccd1 _05567_ sky130_fd_sc_hd__a21oi_1
X_11589_ net540 cell0.CB_1.config_dataA\[9\] net790 vssd1 vssd1 vccd1 vccd1 _00030_
+ sky130_fd_sc_hd__mux2_1
XTAP_TAPCELL_ROW_12_485 vssd1 vccd1 sky130_fd_sc_hd__tapvpwrvgnd_1
XTAP_TAPCELL_ROW_77_1457 vssd1 vccd1 sky130_fd_sc_hd__tapvpwrvgnd_1
X_13328_ clknet_leaf_86_clk _00300_ net691 vssd1 vssd1 vccd1 vccd1 cell1.CB_0.config_dataB\[19\]
+ sky130_fd_sc_hd__dfstp_1
XTAP_TAPCELL_ROW_77_1468 vssd1 vccd1 sky130_fd_sc_hd__tapvpwrvgnd_1
X_13259_ clknet_leaf_122_clk _00231_ net593 vssd1 vssd1 vccd1 vccd1 cell0.LEI0.config_data\[44\]
+ sky130_fd_sc_hd__dfrtp_1
XTAP_TAPCELL_ROW_90_1657 vssd1 vccd1 sky130_fd_sc_hd__tapvpwrvgnd_1
XFILLER_69_457 vssd1 vssd1 vccd1 vccd1 sky130_fd_sc_hd__fill_2
X_07820_ cell1.SB0.route_sel\[40\] cell1.SB0.route_sel\[41\] _02864_ vssd1 vssd1 vccd1
+ vccd1 _02865_ sky130_fd_sc_hd__a21oi_1
XANTENNA__10190__A2 net34 vssd1 vssd1 vccd1 vccd1 sky130_fd_sc_hd__diode_2
XANTENNA__07174__A _02208_ vssd1 vssd1 vccd1 vccd1 sky130_fd_sc_hd__diode_2
X_07751_ _02796_ net91 _02795_ vssd1 vssd1 vccd1 vccd1 _02797_ sky130_fd_sc_hd__mux2_1
X_06702_ cell2.CB_0.config_dataA\[18\] vssd1 vssd1 vccd1 vccd1 _01772_ sky130_fd_sc_hd__inv_2
Xclkbuf_leaf_76_clk clknet_4_14_0_clk vssd1 vssd1 vccd1 vccd1 clknet_leaf_76_clk sky130_fd_sc_hd__clkbuf_8
XANTENNA__11408__B _02208_ vssd1 vssd1 vccd1 vccd1 sky130_fd_sc_hd__diode_2
XANTENNA__08135__A2 _02494_ vssd1 vssd1 vccd1 vccd1 sky130_fd_sc_hd__diode_2
XANTENNA_clkbuf_leaf_92_clk_A clknet_4_11_0_clk vssd1 vssd1 vccd1 vccd1 sky130_fd_sc_hd__diode_2
XANTENNA__09883__A2 _04298_ vssd1 vssd1 vccd1 vccd1 sky130_fd_sc_hd__diode_2
X_07682_ _02724_ _02729_ vssd1 vssd1 vccd1 vccd1 _02730_ sky130_fd_sc_hd__nor2_1
XTAP_TAPCELL_ROW_121_2123 vssd1 vccd1 sky130_fd_sc_hd__tapvpwrvgnd_1
X_09421_ _01606_ cell2.SB0.route_sel\[41\] cell2.SB0.route_sel\[46\] _01608_ _04443_
+ vssd1 vssd1 vccd1 vccd1 _04444_ sky130_fd_sc_hd__a221o_1
X_06633_ cell3.SB0.route_sel\[37\] vssd1 vssd1 vccd1 vccd1 _01703_ sky130_fd_sc_hd__inv_2
XFILLER_53_847 vssd1 vssd1 vccd1 vccd1 sky130_fd_sc_hd__fill_1
XANTENNA__07894__A1 _02172_ vssd1 vssd1 vccd1 vccd1 sky130_fd_sc_hd__diode_2
XANTENNA__07894__B2 _02074_ vssd1 vssd1 vccd1 vccd1 sky130_fd_sc_hd__diode_2
X_06564_ cell2.SB0.route_sel\[91\] vssd1 vssd1 vccd1 vccd1 _01634_ sky130_fd_sc_hd__inv_2
X_09352_ cell3.SB0.route_sel\[36\] cell3.SB0.route_sel\[37\] _02817_ _04375_ _02815_
+ vssd1 vssd1 vccd1 vccd1 _04376_ sky130_fd_sc_hd__a221o_1
XANTENNA__08717__B _03468_ vssd1 vssd1 vccd1 vccd1 sky130_fd_sc_hd__diode_2
XANTENNA__07646__A1 net327 vssd1 vssd1 vccd1 vccd1 sky130_fd_sc_hd__diode_2
X_08303_ _03336_ _03340_ cell0.CB_1.config_dataB\[9\] vssd1 vssd1 vccd1 vccd1 _03341_
+ sky130_fd_sc_hd__a21oi_1
XANTENNA__10052__A1_N _04399_ vssd1 vssd1 vccd1 vccd1 sky130_fd_sc_hd__diode_2
X_09283_ net289 net10 _04308_ vssd1 vssd1 vccd1 vccd1 _04309_ sky130_fd_sc_hd__mux2_1
X_06495_ cell2.SB0.route_sel\[2\] vssd1 vssd1 vccd1 vccd1 _01565_ sky130_fd_sc_hd__inv_2
XANTENNA_clkbuf_leaf_30_clk_A clknet_4_5_0_clk vssd1 vssd1 vccd1 vccd1 sky130_fd_sc_hd__diode_2
X_08234_ _03269_ _03273_ cell0.CB_1.config_dataA\[17\] vssd1 vssd1 vccd1 vccd1 _03274_
+ sky130_fd_sc_hd__o21ai_1
XTAP_TAPCELL_ROW_119_2096 vssd1 vccd1 sky130_fd_sc_hd__tapvpwrvgnd_1
X_08165_ bus1_0\[0\] bus1_0\[1\] bus1_0\[2\] bus1_0\[3\] net542 net541 vssd1 vssd1
+ vccd1 vccd1 _03205_ sky130_fd_sc_hd__mux4_1
XTAP_TAPCELL_ROW_31_772 vssd1 vccd1 sky130_fd_sc_hd__tapvpwrvgnd_1
X_07116_ _02097_ _02178_ vssd1 vssd1 vccd1 vccd1 _02179_ sky130_fd_sc_hd__nor2_1
XFILLER_114_9 vccd1 vssd1 vccd1 vssd1 sky130_ef_sc_hd__decap_40_12
XANTENNA__13534__RESET_B net753 vssd1 vssd1 vccd1 vccd1 sky130_fd_sc_hd__diode_2
XFILLER_118_197 vssd1 vssd1 vccd1 vccd1 sky130_fd_sc_hd__fill_1
Xclkload80 clknet_leaf_83_clk vssd1 vssd1 vccd1 vccd1 clkload80/Y sky130_fd_sc_hd__clkinvlp_4
X_08096_ bus2_0\[12\] bus2_0\[13\] bus2_0\[14\] bus2_0\[15\] net525 cell0.CB_0.config_dataB\[16\]
+ vssd1 vssd1 vccd1 vccd1 _03138_ sky130_fd_sc_hd__mux4_1
XTAP_TAPCELL_ROW_132_2285 vssd1 vccd1 sky130_fd_sc_hd__tapvpwrvgnd_1
XANTENNA_clkbuf_leaf_45_clk_A clknet_4_6_0_clk vssd1 vssd1 vccd1 vccd1 sky130_fd_sc_hd__diode_2
Xclkload91 clknet_leaf_103_clk vssd1 vssd1 vccd1 vccd1 clkload91/Y sky130_fd_sc_hd__inv_6
X_07047_ net357 net355 vssd1 vssd1 vccd1 vccd1 _02111_ sky130_fd_sc_hd__nor2_1
XANTENNA_fanout771_A net773 vssd1 vssd1 vccd1 vccd1 sky130_fd_sc_hd__diode_2
XFILLER_88_755 vssd1 vssd1 vccd1 vccd1 sky130_fd_sc_hd__fill_1
X_08998_ bus3_1\[4\] _04020_ _04021_ bus3_1\[5\] cell1.CB_0.config_dataB\[8\] vssd1
+ vssd1 vccd1 vccd1 _04028_ sky130_fd_sc_hd__a221o_1
XFILLER_18_10 vccd1 vssd1 vccd1 vssd1 sky130_ef_sc_hd__decap_40_12
Xclkbuf_leaf_67_clk clknet_4_15_0_clk vssd1 vssd1 vccd1 vccd1 clknet_leaf_67_clk sky130_fd_sc_hd__clkbuf_8
XFILLER_75_449 vssd1 vssd1 vccd1 vccd1 sky130_fd_sc_hd__fill_1
X_07949_ _02902_ _02983_ _02984_ _02905_ cell0.CB_0.config_dataA\[17\] vssd1 vssd1
+ vccd1 vccd1 _02993_ sky130_fd_sc_hd__a221o_1
XANTENNA__08126__A2 _02211_ vssd1 vssd1 vccd1 vccd1 sky130_fd_sc_hd__diode_2
XFILLER_141_55 vssd1 vssd1 vccd1 vccd1 sky130_fd_sc_hd__fill_1
XFILLER_90_419 vssd1 vssd1 vccd1 vccd1 sky130_fd_sc_hd__fill_1
X_10960_ _01697_ cell3.SB0.route_sel\[28\] vssd1 vssd1 vccd1 vccd1 _05914_ sky130_fd_sc_hd__nand2_1
XANTENNA__07334__B1 _02390_ vssd1 vssd1 vccd1 vccd1 sky130_fd_sc_hd__diode_2
XFILLER_18_65 vssd1 vssd1 vccd1 vccd1 sky130_fd_sc_hd__fill_4
XANTENNA_clkbuf_leaf_103_clk_A clknet_4_10_0_clk vssd1 vssd1 vccd1 vccd1 sky130_fd_sc_hd__diode_2
XFILLER_28_365 vssd1 vssd1 vccd1 vccd1 sky130_fd_sc_hd__fill_1
XANTENNA_fanout824_X net824 vssd1 vssd1 vccd1 vccd1 sky130_fd_sc_hd__diode_2
X_10891_ cell3.SB0.route_sel\[117\] cell3.SB0.route_sel\[116\] vssd1 vssd1 vccd1 vccd1
+ _05845_ sky130_fd_sc_hd__nand2b_1
XANTENNA__09874__A2 bus3_2\[10\] vssd1 vssd1 vccd1 vccd1 sky130_fd_sc_hd__diode_2
XTAP_TAPCELL_ROW_48_1025 vssd1 vccd1 sky130_fd_sc_hd__tapvpwrvgnd_1
XANTENNA__07885__B2 bus2_0\[4\] vssd1 vssd1 vccd1 vccd1 sky130_fd_sc_hd__diode_2
XANTENNA__07885__A1 bus2_0\[5\] vssd1 vssd1 vccd1 vccd1 sky130_fd_sc_hd__diode_2
X_09619_ _02368_ _02373_ _03829_ vssd1 vssd1 vccd1 vccd1 _04635_ sky130_fd_sc_hd__nand3_1
XTAP_TAPCELL_ROW_39_894 vssd1 vccd1 sky130_fd_sc_hd__tapvpwrvgnd_1
X_12630_ cell3.SB0.route_sel\[95\] cell3.SB0.route_sel\[94\] net918 vssd1 vssd1 vccd1
+ vccd1 _01059_ sky130_fd_sc_hd__mux2_1
XFILLER_43_357 vssd1 vssd1 vccd1 vccd1 sky130_fd_sc_hd__fill_1
XANTENNA_input102_A SBwest_in[14] vssd1 vssd1 vccd1 vccd1 sky130_fd_sc_hd__diode_2
XANTENNA__08119__S _03057_ vssd1 vssd1 vccd1 vccd1 sky130_fd_sc_hd__diode_2
XANTENNA_clkbuf_leaf_118_clk_A clknet_4_3_0_clk vssd1 vssd1 vccd1 vccd1 sky130_fd_sc_hd__diode_2
XFILLER_34_53 vccd1 vssd1 vccd1 vssd1 sky130_ef_sc_hd__decap_40_12
X_12561_ cell3.SB0.route_sel\[26\] cell3.SB0.route_sel\[25\] net918 vssd1 vssd1 vccd1
+ vccd1 _00990_ sky130_fd_sc_hd__mux2_1
XTAP_TAPCELL_ROW_61_1225 vssd1 vccd1 sky130_fd_sc_hd__tapvpwrvgnd_1
X_12492_ cell2.LEI0.config_data\[6\] cell2.LEI0.config_data\[5\] net843 vssd1 vssd1
+ vccd1 vccd1 _00921_ sky130_fd_sc_hd__mux2_1
X_11512_ cell2.SB0.route_sel\[64\] cell2.SB0.route_sel\[65\] _01623_ cell2.SB0.route_sel\[68\]
+ _06341_ vssd1 vssd1 vccd1 vccd1 _06342_ sky130_fd_sc_hd__o221a_1
XANTENNA__09298__X bus3_1\[2\] vssd1 vssd1 vccd1 vccd1 sky130_fd_sc_hd__diode_2
X_14300_ clknet_leaf_13_clk _01272_ net590 vssd1 vssd1 vccd1 vccd1 cell2.SB0.route_sel\[85\]
+ sky130_fd_sc_hd__dfstp_1
XFILLER_8_737 vssd1 vssd1 vccd1 vccd1 sky130_fd_sc_hd__fill_4
X_14231_ clknet_leaf_16_clk _01203_ net624 vssd1 vssd1 vccd1 vccd1 cell2.SB0.route_sel\[16\]
+ sky130_fd_sc_hd__dfstp_1
X_11443_ _01502_ cell1.SB0.route_sel\[9\] cell1.SB0.route_sel\[14\] cell1.SB0.route_sel\[15\]
+ _06295_ vssd1 vssd1 vccd1 vccd1 _06296_ sky130_fd_sc_hd__o221a_1
XANTENNA__11197__A1 net45 vssd1 vssd1 vccd1 vccd1 sky130_fd_sc_hd__diode_2
XANTENNA__11197__B2 net46 vssd1 vssd1 vccd1 vccd1 sky130_fd_sc_hd__diode_2
X_14162_ clknet_leaf_73_clk _01134_ net729 vssd1 vssd1 vccd1 vccd1 cell3.CB_1.config_dataA\[22\]
+ sky130_fd_sc_hd__dfstp_1
XANTENNA__08062__A1 _02902_ vssd1 vssd1 vccd1 vccd1 sky130_fd_sc_hd__diode_2
X_13113_ clknet_leaf_5_clk _00085_ net566 vssd1 vssd1 vccd1 vccd1 cell0.CB_0.config_dataA\[15\]
+ sky130_fd_sc_hd__dfstp_1
XANTENNA__08062__B2 _02905_ vssd1 vssd1 vccd1 vccd1 sky130_fd_sc_hd__diode_2
XANTENNA__08601__A3 net3 vssd1 vssd1 vccd1 vccd1 sky130_fd_sc_hd__diode_2
X_11374_ _01609_ cell0.SB0.route_sel\[42\] cell0.SB0.route_sel\[47\] cell0.SB0.route_sel\[46\]
+ _06249_ vssd1 vssd1 vccd1 vccd1 _06250_ sky130_fd_sc_hd__o221a_1
X_10325_ net33 net44 net55 net58 net436 net434 vssd1 vssd1 vccd1 vccd1 _05324_ sky130_fd_sc_hd__mux4_1
X_14093_ clknet_leaf_79_clk _01065_ net708 vssd1 vssd1 vccd1 vccd1 cell3.SB0.route_sel\[101\]
+ sky130_fd_sc_hd__dfstp_2
XTAP_TAPCELL_ROW_59_1198 vssd1 vccd1 sky130_fd_sc_hd__tapvpwrvgnd_1
XTAP_TAPCELL_ROW_59_1187 vssd1 vccd1 sky130_fd_sc_hd__tapvpwrvgnd_1
X_10256_ cell2.CB_0.config_dataA\[17\] _05255_ _05256_ _05253_ vssd1 vssd1 vccd1 vccd1
+ _05257_ sky130_fd_sc_hd__o31a_1
XFILLER_79_711 vssd1 vssd1 vccd1 vccd1 sky130_fd_sc_hd__fill_1
X_13044_ clknet_leaf_119_clk _00016_ net594 vssd1 vssd1 vccd1 vccd1 cell0.LE_1B.config_data\[16\]
+ sky130_fd_sc_hd__dfrtp_1
XFILLER_3_497 vssd1 vssd1 vccd1 vccd1 sky130_fd_sc_hd__fill_4
Xclkbuf_0_cell2.LE_1A.sel_clk cell2.LE_1A.sel_clk vssd1 vssd1 vccd1 vccd1 clknet_0_cell2.LE_1A.sel_clk
+ sky130_fd_sc_hd__clkbuf_16
XANTENNA_output154_A net154 vssd1 vssd1 vccd1 vccd1 sky130_fd_sc_hd__diode_2
XTAP_TAPCELL_ROW_72_1387 vssd1 vccd1 sky130_fd_sc_hd__tapvpwrvgnd_1
X_10187_ _02106_ _05096_ _05168_ _05167_ _05093_ vssd1 vssd1 vccd1 vccd1 _05188_ sky130_fd_sc_hd__a32o_1
XFILLER_78_276 vssd1 vssd1 vccd1 vccd1 sky130_fd_sc_hd__fill_1
Xclkbuf_leaf_58_clk clknet_4_13_0_clk vssd1 vssd1 vccd1 vccd1 clknet_leaf_58_clk sky130_fd_sc_hd__clkbuf_8
X_13946_ clknet_leaf_34_clk _00918_ net635 vssd1 vssd1 vccd1 vccd1 cell2.LEI0.config_data\[3\]
+ sky130_fd_sc_hd__dfrtp_1
Xclkbuf_4_11_0_clk clknet_0_clk vssd1 vssd1 vccd1 vccd1 clknet_4_11_0_clk sky130_fd_sc_hd__clkbuf_8
XFILLER_74_471 vssd1 vssd1 vccd1 vccd1 sky130_fd_sc_hd__fill_4
X_13877_ clknet_leaf_39_clk _00849_ net647 vssd1 vssd1 vccd1 vccd1 cell2.LE_1A.config_data\[0\]
+ sky130_fd_sc_hd__dfrtp_1
XFILLER_61_132 vssd1 vssd1 vccd1 vccd1 sky130_fd_sc_hd__fill_1
XANTENNA__09078__A0 bus3_1\[6\] vssd1 vssd1 vccd1 vccd1 sky130_fd_sc_hd__diode_2
X_12828_ cell2.SB0.route_sel\[70\] cell2.SB0.route_sel\[69\] net815 vssd1 vssd1 vccd1
+ vccd1 _01257_ sky130_fd_sc_hd__mux2_1
XTAP_TAPCELL_ROW_17_566 vssd1 vccd1 sky130_fd_sc_hd__tapvpwrvgnd_1
XANTENNA__10227__A3 net302 vssd1 vssd1 vccd1 vccd1 sky130_fd_sc_hd__diode_2
X_12759_ cell2.SB0.route_sel\[1\] cell2.SB0.route_sel\[0\] net830 vssd1 vssd1 vccd1
+ vccd1 _01188_ sky130_fd_sc_hd__mux2_1
XANTENNA__11531__X net253 vssd1 vssd1 vccd1 vccd1 sky130_fd_sc_hd__diode_2
XFILLER_30_563 vssd1 vssd1 vccd1 vccd1 sky130_fd_sc_hd__fill_2
X_14429_ clknet_leaf_55_clk _01401_ net719 vssd1 vssd1 vccd1 vccd1 cell3.LE_0A.config_data\[16\]
+ sky130_fd_sc_hd__dfrtp_1
XANTENNA__10147__X _05148_ vssd1 vssd1 vccd1 vccd1 sky130_fd_sc_hd__diode_2
X_09970_ net407 _04724_ _04973_ vssd1 vssd1 vccd1 vccd1 _04974_ sky130_fd_sc_hd__a21o_1
XANTENNA__07261__C1 net551 vssd1 vssd1 vccd1 vccd1 sky130_fd_sc_hd__diode_2
X_08921_ _03951_ _03952_ _03943_ _03949_ vssd1 vssd1 vccd1 vccd1 _03953_ sky130_fd_sc_hd__o211ai_1
XFILLER_130_137 vssd1 vssd1 vccd1 vccd1 sky130_fd_sc_hd__fill_1
XFILLER_97_541 vssd1 vssd1 vccd1 vccd1 sky130_fd_sc_hd__fill_2
X_08852_ cell1.SB0.route_sel\[50\] cell1.SB0.route_sel\[51\] cell1.SB0.route_sel\[53\]
+ _01519_ _03883_ vssd1 vssd1 vccd1 vccd1 _03884_ sky130_fd_sc_hd__o221a_1
X_07803_ cell1.SB0.route_sel\[45\] cell1.SB0.route_sel\[44\] vssd1 vssd1 vccd1 vccd1
+ _02848_ sky130_fd_sc_hd__nand2_1
Xclkbuf_leaf_49_clk clknet_4_12_0_clk vssd1 vssd1 vccd1 vccd1 clknet_leaf_49_clk sky130_fd_sc_hd__clkbuf_8
XFILLER_85_769 vssd1 vssd1 vccd1 vccd1 sky130_fd_sc_hd__fill_1
X_08783_ cell1.SB0.route_sel\[114\] cell1.SB0.route_sel\[115\] vssd1 vssd1 vccd1 vccd1
+ _03815_ sky130_fd_sc_hd__or2_1
XANTENNA__11112__A1 net48 vssd1 vssd1 vccd1 vccd1 sky130_fd_sc_hd__diode_2
X_07734_ cell1.SB0.route_sel\[24\] cell1.SB0.route_sel\[25\] vssd1 vssd1 vccd1 vccd1
+ _02781_ sky130_fd_sc_hd__nor2_1
X_07665_ net347 _01866_ _02623_ vssd1 vssd1 vccd1 vccd1 _02713_ sky130_fd_sc_hd__and3_1
XANTENNA__10871__A0 net298 vssd1 vssd1 vccd1 vccd1 sky130_fd_sc_hd__diode_2
X_09404_ net301 _04426_ _04425_ vssd1 vssd1 vccd1 vccd1 _04427_ sky130_fd_sc_hd__o21ai_1
XANTENNA_fanout352_A _03025_ vssd1 vssd1 vccd1 vccd1 sky130_fd_sc_hd__diode_2
X_06616_ cell3.SB0.route_sel\[11\] vssd1 vssd1 vccd1 vccd1 _01686_ sky130_fd_sc_hd__inv_2
XANTENNA__06519__Y _01589_ vssd1 vssd1 vccd1 vccd1 sky130_fd_sc_hd__diode_2
XTAP_TAPCELL_ROW_36_842 vssd1 vccd1 sky130_fd_sc_hd__tapvpwrvgnd_1
XTAP_TAPCELL_ROW_36_853 vssd1 vccd1 sky130_fd_sc_hd__tapvpwrvgnd_1
X_07596_ cell1.CB_0.config_dataA\[22\] cell1.CB_0.config_dataA\[23\] vssd1 vssd1 vccd1
+ vccd1 _02646_ sky130_fd_sc_hd__or2_1
XFILLER_40_305 vssd1 vssd1 vccd1 vccd1 sky130_fd_sc_hd__fill_1
XANTENNA_fanout617_A net619 vssd1 vssd1 vccd1 vccd1 sky130_fd_sc_hd__diode_2
XTAP_TAPCELL_ROW_101_1826 vssd1 vccd1 sky130_fd_sc_hd__tapvpwrvgnd_1
X_09335_ net288 net11 _04359_ vssd1 vssd1 vccd1 vccd1 _04360_ sky130_fd_sc_hd__mux2_1
X_06547_ cell2.SB0.route_sel\[62\] vssd1 vssd1 vccd1 vccd1 _01617_ sky130_fd_sc_hd__inv_2
XFILLER_21_530 vssd1 vssd1 vccd1 vccd1 sky130_fd_sc_hd__fill_4
X_09266_ net307 net55 _04290_ vssd1 vssd1 vccd1 vccd1 _04292_ sky130_fd_sc_hd__mux2_1
XANTENNA__10623__A0 _05475_ vssd1 vssd1 vccd1 vccd1 sky130_fd_sc_hd__diode_2
X_06478_ cell1.SB0.route_sel\[115\] vssd1 vssd1 vccd1 vccd1 _01548_ sky130_fd_sc_hd__inv_2
XTAP_TAPCELL_ROW_134_2325 vssd1 vccd1 sky130_fd_sc_hd__tapvpwrvgnd_1
XTAP_TAPCELL_ROW_134_2314 vssd1 vccd1 sky130_fd_sc_hd__tapvpwrvgnd_1
X_08217_ bus1_0\[1\] _03233_ _03234_ bus1_0\[0\] cell0.CB_1.config_dataA\[12\] vssd1
+ vssd1 vccd1 vccd1 _03257_ sky130_fd_sc_hd__a221o_1
X_09197_ _04205_ _04214_ _04224_ vssd1 vssd1 vccd1 vccd1 _04225_ sky130_fd_sc_hd__o21a_1
XFILLER_5_729 vccd1 vssd1 vccd1 vssd1 sky130_ef_sc_hd__decap_40_12
XANTENNA__13941__SET_B net752 vssd1 vssd1 vccd1 vccd1 sky130_fd_sc_hd__diode_2
XANTENNA__10926__A1 net274 vssd1 vssd1 vccd1 vccd1 sky130_fd_sc_hd__diode_2
XFILLER_106_112 vssd1 vssd1 vccd1 vccd1 sky130_fd_sc_hd__fill_1
X_08148_ bus1_0\[0\] bus1_0\[1\] bus1_0\[2\] bus1_0\[3\] net547 net545 vssd1 vssd1
+ vccd1 vccd1 _03188_ sky130_fd_sc_hd__mux4_1
XANTENNA__09565__Y _04583_ vssd1 vssd1 vccd1 vccd1 sky130_fd_sc_hd__diode_2
X_08079_ cell0.LE_0B.config_data\[7\] cell0.LE_0B.config_data\[6\] _03087_ vssd1 vssd1
+ vccd1 vccd1 _03121_ sky130_fd_sc_hd__mux2_1
XFILLER_136_77 vssd1 vssd1 vccd1 vccd1 sky130_fd_sc_hd__fill_4
X_11090_ _01813_ cell3.LE_0A.dff_out vssd1 vssd1 vccd1 vccd1 _06043_ sky130_fd_sc_hd__or2_1
XFILLER_121_104 vssd1 vssd1 vccd1 vccd1 sky130_fd_sc_hd__fill_1
XFILLER_106_178 vssd1 vssd1 vccd1 vccd1 sky130_fd_sc_hd__fill_1
X_10110_ _02469_ _05110_ vssd1 vssd1 vccd1 vccd1 _05111_ sky130_fd_sc_hd__nor2_4
XANTENNA__09294__A net551 vssd1 vssd1 vccd1 vccd1 sky130_fd_sc_hd__diode_2
XFILLER_0_412 vssd1 vssd1 vccd1 vccd1 sky130_fd_sc_hd__fill_8
XANTENNA__07366__X _02422_ vssd1 vssd1 vccd1 vccd1 sky130_fd_sc_hd__diode_2
XTAP_TAPCELL_ROW_112_1988 vssd1 vccd1 sky130_fd_sc_hd__tapvpwrvgnd_1
XFILLER_103_841 vssd1 vssd1 vccd1 vccd1 sky130_fd_sc_hd__fill_1
X_10041_ net399 _05037_ _05038_ _05039_ cell2.CB_1.config_dataB\[17\] vssd1 vssd1
+ vccd1 vccd1 _05045_ sky130_fd_sc_hd__a311o_1
XFILLER_88_552 vssd1 vssd1 vccd1 vccd1 sky130_fd_sc_hd__fill_1
XANTENNA__08347__A2 _02424_ vssd1 vssd1 vccd1 vccd1 sky130_fd_sc_hd__diode_2
Xhold20 _01355_ vssd1 vssd1 vccd1 vccd1 net979 sky130_fd_sc_hd__dlygate4sd3_1
Xhold31 cell0.LEI0.config_data\[20\] vssd1 vssd1 vccd1 vccd1 net990 sky130_fd_sc_hd__dlygate4sd3_1
Xhold53 cell1.LE_0B.config_data\[4\] vssd1 vssd1 vccd1 vccd1 net1012 sky130_fd_sc_hd__dlygate4sd3_1
Xhold64 _00132_ vssd1 vssd1 vccd1 vccd1 net1023 sky130_fd_sc_hd__dlygate4sd3_1
Xhold42 cell1.LE_1A.config_data\[3\] vssd1 vssd1 vccd1 vccd1 net1001 sky130_fd_sc_hd__dlygate4sd3_1
Xhold97 _00897_ vssd1 vssd1 vccd1 vccd1 net1056 sky130_fd_sc_hd__dlygate4sd3_1
Xhold75 cell2.LE_0A.config_data\[1\] vssd1 vssd1 vccd1 vccd1 net1034 sky130_fd_sc_hd__dlygate4sd3_1
XANTENNA__10520__X _05478_ vssd1 vssd1 vccd1 vccd1 sky130_fd_sc_hd__diode_2
XFILLER_91_706 vssd1 vssd1 vccd1 vccd1 sky130_fd_sc_hd__fill_1
XFILLER_75_279 vssd1 vssd1 vccd1 vccd1 sky130_fd_sc_hd__fill_1
Xhold86 cell1.LE_0A.config_data\[1\] vssd1 vssd1 vccd1 vccd1 net1045 sky130_fd_sc_hd__dlygate4sd3_1
X_13800_ clknet_leaf_105_clk _00772_ net659 vssd1 vssd1 vccd1 vccd1 cell1.SB0.route_sel\[77\]
+ sky130_fd_sc_hd__dfstp_1
X_11992_ cell0.SB0.route_sel\[98\] cell0.SB0.route_sel\[97\] net775 vssd1 vssd1 vccd1
+ vccd1 _00429_ sky130_fd_sc_hd__mux2_1
X_10943_ _01705_ _01706_ _01707_ cell3.SB0.route_sel\[47\] _05896_ vssd1 vssd1 vccd1
+ vccd1 _05897_ sky130_fd_sc_hd__a221o_1
XANTENNA__07542__A net301 vssd1 vssd1 vccd1 vccd1 sky130_fd_sc_hd__diode_2
XANTENNA__10945__A_N cell3.SB0.route_sel\[37\] vssd1 vssd1 vccd1 vccd1 sky130_fd_sc_hd__diode_2
XFILLER_16_313 vssd1 vssd1 vccd1 vccd1 sky130_fd_sc_hd__fill_2
XFILLER_16_324 vssd1 vssd1 vccd1 vccd1 sky130_fd_sc_hd__fill_8
X_13731_ clknet_leaf_105_clk _00703_ net660 vssd1 vssd1 vccd1 vccd1 cell1.SB0.route_sel\[8\]
+ sky130_fd_sc_hd__dfstp_2
XANTENNA__12851__A1 cell2.SB0.route_sel\[92\] vssd1 vssd1 vccd1 vccd1 sky130_fd_sc_hd__diode_2
X_13662_ clknet_leaf_48_clk _00634_ net704 vssd1 vssd1 vccd1 vccd1 cell2.CB_1.config_dataA\[14\]
+ sky130_fd_sc_hd__dfstp_1
X_10874_ cell3.CB_1.config_dataB\[19\] _05798_ _05813_ vssd1 vssd1 vccd1 vccd1 _05830_
+ sky130_fd_sc_hd__nand3_1
XANTENNA_input105_X net105 vssd1 vssd1 vccd1 vccd1 sky130_fd_sc_hd__diode_2
X_12613_ cell3.SB0.route_sel\[78\] cell3.SB0.route_sel\[77\] net834 vssd1 vssd1 vccd1
+ vccd1 _01042_ sky130_fd_sc_hd__mux2_1
X_13593_ clknet_leaf_89_clk net1036 net689 vssd1 vssd1 vccd1 vccd1 cell1.LEI0.config_data\[14\]
+ sky130_fd_sc_hd__dfrtp_1
XTAP_TAPCELL_ROW_14_514 vssd1 vccd1 sky130_fd_sc_hd__tapvpwrvgnd_1
XTAP_TAPCELL_ROW_14_525 vssd1 vccd1 sky130_fd_sc_hd__tapvpwrvgnd_1
XANTENNA__10614__A0 net17 vssd1 vssd1 vccd1 vccd1 sky130_fd_sc_hd__diode_2
X_12544_ cell3.SB0.route_sel\[9\] cell3.SB0.route_sel\[8\] net935 vssd1 vssd1 vccd1
+ vccd1 _00973_ sky130_fd_sc_hd__mux2_1
XANTENNA__09075__A3 bus3_1\[3\] vssd1 vssd1 vccd1 vccd1 sky130_fd_sc_hd__diode_2
XANTENNA__09480__B1 net314 vssd1 vssd1 vccd1 vccd1 sky130_fd_sc_hd__diode_2
X_12475_ net1223 net1198 net814 vssd1 vssd1 vccd1 vccd1 _00905_ sky130_fd_sc_hd__mux2_1
XANTENNA_input70_X net70 vssd1 vssd1 vccd1 vccd1 sky130_fd_sc_hd__diode_2
XFILLER_138_793 vccd1 vssd1 vccd1 vssd1 sky130_ef_sc_hd__decap_40_12
X_14214_ clknet_leaf_52_clk _01186_ net720 vssd1 vssd1 vccd1 vccd1 cell3.CB_0.config_dataA\[24\]
+ sky130_fd_sc_hd__dfstp_1
X_11426_ _02421_ _06284_ vssd1 vssd1 vccd1 vccd1 net234 sky130_fd_sc_hd__and2_1
XANTENNA_6 _03616_ vssd1 vssd1 vccd1 vccd1 sky130_fd_sc_hd__diode_2
X_11357_ _05850_ net277 _04734_ vssd1 vssd1 vccd1 vccd1 _06244_ sky130_fd_sc_hd__mux2_1
X_14145_ clknet_leaf_68_clk _01117_ net726 vssd1 vssd1 vccd1 vccd1 cell3.CB_1.config_dataA\[5\]
+ sky130_fd_sc_hd__dfstp_1
XANTENNA__09498__A_N _04518_ vssd1 vssd1 vccd1 vccd1 sky130_fd_sc_hd__diode_2
XTAP_TAPCELL_ROW_74_1416 vssd1 vccd1 sky130_fd_sc_hd__tapvpwrvgnd_1
X_10308_ _01822_ net305 net315 net302 cell2.LEI0.config_data\[15\] cell2.LEI0.config_data\[16\]
+ vssd1 vssd1 vccd1 vccd1 _05307_ sky130_fd_sc_hd__mux4_1
X_14076_ clknet_leaf_82_clk _01048_ net672 vssd1 vssd1 vccd1 vccd1 cell3.SB0.route_sel\[84\]
+ sky130_fd_sc_hd__dfstp_1
XFILLER_4_795 vssd1 vssd1 vccd1 vccd1 sky130_fd_sc_hd__fill_1
XFILLER_3_261 vccd1 vssd1 vccd1 vssd1 sky130_ef_sc_hd__decap_40_12
X_13027_ cell3.LE_0A.dff1_out _06042_ net756 vssd1 vssd1 vccd1 vccd1 _01455_ sky130_fd_sc_hd__mux2_1
X_11288_ net641 cell2.LE_1A.reset_mode vssd1 vssd1 vccd1 vccd1 _11288_/X sky130_fd_sc_hd__xor2_2
XFILLER_112_126 vssd1 vssd1 vccd1 vccd1 sky130_fd_sc_hd__fill_1
X_10239_ net412 _05131_ _05239_ net411 vssd1 vssd1 vccd1 vccd1 _05240_ sky130_fd_sc_hd__o211a_1
XFILLER_86_81 vssd1 vssd1 vccd1 vccd1 sky130_fd_sc_hd__fill_1
XANTENNA__09491__X _04512_ vssd1 vssd1 vccd1 vccd1 sky130_fd_sc_hd__diode_2
XANTENNA__07010__A2 _02037_ vssd1 vssd1 vccd1 vccd1 sky130_fd_sc_hd__diode_2
XFILLER_94_566 vssd1 vssd1 vccd1 vccd1 sky130_fd_sc_hd__fill_8
XFILLER_54_419 vssd1 vssd1 vccd1 vccd1 sky130_fd_sc_hd__fill_1
XFILLER_81_216 vssd1 vssd1 vccd1 vccd1 sky130_fd_sc_hd__fill_1
X_13929_ clknet_leaf_25_clk net1125 net609 vssd1 vssd1 vccd1 vccd1 cell2.LE_0A.config_data\[8\]
+ sky130_fd_sc_hd__dfrtp_1
XTAP_TAPCELL_ROW_85_1589 vssd1 vccd1 sky130_fd_sc_hd__tapvpwrvgnd_1
XTAP_TAPCELL_ROW_85_1578 vssd1 vccd1 sky130_fd_sc_hd__tapvpwrvgnd_1
XFILLER_23_839 vssd1 vssd1 vccd1 vccd1 sky130_fd_sc_hd__fill_1
X_07450_ net322 _01837_ _02356_ _02358_ _01841_ vssd1 vssd1 vccd1 vccd1 _02504_ sky130_fd_sc_hd__o32a_1
XFILLER_34_143 vssd1 vssd1 vccd1 vccd1 sky130_fd_sc_hd__fill_1
XTAP_TAPCELL_ROW_33_801 vssd1 vccd1 sky130_fd_sc_hd__tapvpwrvgnd_1
X_07381_ _02429_ _02430_ _02431_ _02436_ vssd1 vssd1 vccd1 vccd1 _02437_ sky130_fd_sc_hd__a31o_1
X_06401_ cell0.SB0.route_sel\[85\] vssd1 vssd1 vccd1 vccd1 _01471_ sky130_fd_sc_hd__inv_2
XFILLER_34_187 vssd1 vssd1 vccd1 vccd1 sky130_fd_sc_hd__fill_1
XANTENNA__11702__A net755 vssd1 vssd1 vccd1 vccd1 sky130_fd_sc_hd__diode_2
X_09120_ bus3_1\[8\] bus3_1\[9\] bus3_1\[10\] bus3_1\[11\] net476 net475 vssd1 vssd1
+ vccd1 vccd1 _04150_ sky130_fd_sc_hd__mux4_1
X_09051_ cell1.LEI0.config_data\[4\] _04080_ vssd1 vssd1 vccd1 vccd1 _04081_ sky130_fd_sc_hd__nor2_1
XTAP_TAPCELL_ROW_116_2044 vssd1 vccd1 sky130_fd_sc_hd__tapvpwrvgnd_1
X_08002_ net530 _02894_ _03043_ net529 vssd1 vssd1 vccd1 vccd1 _03044_ sky130_fd_sc_hd__o211a_1
XPHY_EDGE_ROW_6_Right_6 vssd1 vssd1 vccd1 vccd1 sky130_fd_sc_hd__decap_3
XTAP_TAPCELL_ROW_116_2055 vssd1 vccd1 sky130_fd_sc_hd__tapvpwrvgnd_1
XANTENNA__08026__A1 bus2_0\[13\] vssd1 vssd1 vccd1 vccd1 sky130_fd_sc_hd__diode_2
Xhold501 cell1.LEI0.config_data\[1\] vssd1 vssd1 vccd1 vccd1 net1460 sky130_fd_sc_hd__dlygate4sd3_1
Xhold545 cell2.LE_1A.reset_val vssd1 vssd1 vccd1 vccd1 net1504 sky130_fd_sc_hd__dlygate4sd3_1
Xhold534 cell3.LE_1A.dff1_out vssd1 vssd1 vccd1 vccd1 net1493 sky130_fd_sc_hd__dlygate4sd3_1
Xhold523 _01416_ vssd1 vssd1 vccd1 vccd1 net1482 sky130_fd_sc_hd__dlygate4sd3_1
XANTENNA__11848__S net897 vssd1 vssd1 vccd1 vccd1 sky130_fd_sc_hd__diode_2
Xhold512 cell0.LEI0.config_data\[37\] vssd1 vssd1 vccd1 vccd1 net1471 sky130_fd_sc_hd__dlygate4sd3_1
Xhold578 cell2.LEI0.config_data\[31\] vssd1 vssd1 vccd1 vccd1 net1537 sky130_fd_sc_hd__dlygate4sd3_1
Xmax_cap275 _04463_ vssd1 vssd1 vccd1 vccd1 net275 sky130_fd_sc_hd__clkbuf_2
XFILLER_89_327 vssd1 vssd1 vccd1 vccd1 sky130_fd_sc_hd__fill_1
Xmax_cap264 _02186_ vssd1 vssd1 vccd1 vccd1 net264 sky130_fd_sc_hd__clkbuf_2
Xhold556 _00251_ vssd1 vssd1 vccd1 vccd1 net1515 sky130_fd_sc_hd__dlygate4sd3_1
Xhold567 _00250_ vssd1 vssd1 vccd1 vccd1 net1526 sky130_fd_sc_hd__dlygate4sd3_1
XFILLER_106_25 vssd1 vssd1 vccd1 vccd1 sky130_fd_sc_hd__fill_2
X_09953_ net407 net405 vssd1 vssd1 vccd1 vccd1 _04957_ sky130_fd_sc_hd__nor2_1
Xhold589 cell0.LE_1A.reset_val vssd1 vssd1 vccd1 vccd1 net1548 sky130_fd_sc_hd__dlygate4sd3_1
XANTENNA__11333__A1 _05916_ vssd1 vssd1 vccd1 vccd1 sky130_fd_sc_hd__diode_2
X_09884_ _04260_ _04875_ _04876_ _04197_ cell2.CB_1.config_dataA\[17\] vssd1 vssd1
+ vccd1 vccd1 _04890_ sky130_fd_sc_hd__a221o_1
X_08904_ cell1.CB_0.config_dataA\[4\] _03932_ _03935_ vssd1 vssd1 vccd1 vccd1 _03936_
+ sky130_fd_sc_hd__o21ba_2
XANTENNA_clkbuf_4_4_0_clk_X clknet_4_4_0_clk vssd1 vssd1 vccd1 vccd1 sky130_fd_sc_hd__diode_2
X_08835_ _02655_ _03866_ vssd1 vssd1 vccd1 vccd1 _03867_ sky130_fd_sc_hd__nor2_1
X_08766_ cell1.CB_1.config_dataB\[19\] _03773_ _03787_ _03797_ _03799_ vssd1 vssd1
+ vccd1 vccd1 _03800_ sky130_fd_sc_hd__a311o_1
X_07717_ cell1.SB0.route_sel\[30\] cell1.SB0.route_sel\[31\] _02745_ _02763_ vssd1
+ vssd1 vccd1 vccd1 _02764_ sky130_fd_sc_hd__a211oi_1
XANTENNA__08458__A _02444_ vssd1 vssd1 vccd1 vccd1 sky130_fd_sc_hd__diode_2
XANTENNA_fanout734_A net742 vssd1 vssd1 vccd1 vccd1 sky130_fd_sc_hd__diode_2
XANTENNA__10844__A0 net21 vssd1 vssd1 vccd1 vccd1 sky130_fd_sc_hd__diode_2
X_08697_ _03726_ _03730_ cell1.CB_1.config_dataB\[4\] _03717_ vssd1 vssd1 vccd1 vccd1
+ _03731_ sky130_fd_sc_hd__a211o_1
XANTENNA_fanout355_X net355 vssd1 vssd1 vccd1 vccd1 sky130_fd_sc_hd__diode_2
XFILLER_81_783 vssd1 vssd1 vccd1 vccd1 sky130_fd_sc_hd__fill_1
XFILLER_41_603 vssd1 vssd1 vccd1 vccd1 sky130_fd_sc_hd__fill_1
XTAP_TAPCELL_ROW_0_286 vssd1 vccd1 sky130_fd_sc_hd__tapvpwrvgnd_1
XTAP_TAPCELL_ROW_0_297 vssd1 vccd1 sky130_fd_sc_hd__tapvpwrvgnd_1
X_07648_ cell1.SB0.route_sel\[8\] cell1.SB0.route_sel\[9\] _02696_ vssd1 vssd1 vccd1
+ vccd1 _02697_ sky130_fd_sc_hd__a21oi_1
XFILLER_26_699 vssd1 vssd1 vccd1 vccd1 sky130_fd_sc_hd__fill_1
XANTENNA_fanout901_A net907 vssd1 vssd1 vccd1 vccd1 sky130_fd_sc_hd__diode_2
XFILLER_15_55 vssd1 vssd1 vccd1 vccd1 sky130_fd_sc_hd__fill_1
X_07579_ cell0.SB0.route_sel\[1\] cell0.SB0.route_sel\[0\] _02622_ _02628_ vssd1 vssd1
+ vccd1 vccd1 _02629_ sky130_fd_sc_hd__a22oi_1
X_09318_ net311 _04341_ _04336_ vssd1 vssd1 vccd1 vccd1 _04343_ sky130_fd_sc_hd__a21bo_1
X_10590_ _01720_ cell3.SB0.route_sel\[71\] _05547_ vssd1 vssd1 vccd1 vccd1 _05548_
+ sky130_fd_sc_hd__o21ai_4
X_09249_ _04273_ _04275_ vssd1 vssd1 vccd1 vccd1 bus3_1\[1\] sky130_fd_sc_hd__and2_2
XFILLER_21_393 vssd1 vssd1 vccd1 vccd1 sky130_fd_sc_hd__fill_1
X_12260_ cell2.CB_0.config_dataA\[23\] cell2.CB_0.config_dataA\[22\] net841 vssd1
+ vssd1 vccd1 vccd1 _00693_ sky130_fd_sc_hd__mux2_1
XFILLER_5_537 vccd1 vssd1 vccd1 vssd1 sky130_ef_sc_hd__decap_40_12
X_11211_ net53 net54 net56 net57 net383 net382 vssd1 vssd1 vccd1 vccd1 _06163_ sky130_fd_sc_hd__mux4_1
X_12191_ cell2.CB_1.config_dataA\[4\] cell2.CB_1.config_dataA\[3\] net846 vssd1 vssd1
+ vccd1 vccd1 _00624_ sky130_fd_sc_hd__mux2_1
XFILLER_5_559 vssd1 vssd1 vccd1 vccd1 sky130_fd_sc_hd__fill_1
XFILLER_135_785 vccd1 vssd1 vccd1 vssd1 sky130_ef_sc_hd__decap_40_12
X_11142_ cell3.CB_0.config_dataB\[8\] cell3.CB_0.config_dataB\[7\] vssd1 vssd1 vccd1
+ vccd1 _06094_ sky130_fd_sc_hd__nor2_1
XANTENNA__10375__A2 net34 vssd1 vssd1 vccd1 vccd1 sky130_fd_sc_hd__diode_2
XFILLER_122_413 vssd1 vssd1 vccd1 vccd1 sky130_fd_sc_hd__fill_1
XTAP_TAPCELL_ROW_56_1146 vssd1 vccd1 sky130_fd_sc_hd__tapvpwrvgnd_1
XANTENNA__14431__Q cell3.LE_0A.reset_val vssd1 vssd1 vccd1 vccd1 sky130_fd_sc_hd__diode_2
XFILLER_1_721 vssd1 vssd1 vccd1 vccd1 sky130_fd_sc_hd__fill_2
XFILLER_1_743 vccd1 vssd1 vccd1 vssd1 sky130_ef_sc_hd__decap_40_12
X_11073_ cell3.LE_0A.config_data\[14\] cell3.LE_0A.config_data\[15\] _05930_ vssd1
+ vssd1 vccd1 vccd1 _06027_ sky130_fd_sc_hd__mux2_1
Xinput110 SBwest_in[21] vssd1 vssd1 vccd1 vccd1 net110 sky130_fd_sc_hd__buf_1
XANTENNA_hold567_X net1526 vssd1 vssd1 vccd1 vccd1 sky130_fd_sc_hd__diode_2
XFILLER_0_242 vssd1 vssd1 vccd1 vccd1 sky130_fd_sc_hd__fill_8
X_10024_ cell2.LEI0.config_data\[33\] net315 _05027_ cell2.LEI0.config_data\[34\]
+ vssd1 vssd1 vccd1 vccd1 _05028_ sky130_fd_sc_hd__o211a_1
XANTENNA_input30_A CBeast_in[7] vssd1 vssd1 vccd1 vccd1 sky130_fd_sc_hd__diode_2
Xinput121 SBwest_in[31] vssd1 vssd1 vccd1 vccd1 net121 sky130_fd_sc_hd__dlymetal6s2s_1
Xinput132 le_nrst vssd1 vssd1 vccd1 vccd1 net132 sky130_fd_sc_hd__dlymetal6s2s_1
XANTENNA__11346__X net183 vssd1 vssd1 vccd1 vccd1 sky130_fd_sc_hd__diode_2
XFILLER_76_577 vssd1 vssd1 vccd1 vccd1 sky130_fd_sc_hd__fill_1
XFILLER_36_419 vssd1 vssd1 vccd1 vccd1 sky130_fd_sc_hd__fill_1
XFILLER_91_558 vssd1 vssd1 vccd1 vccd1 sky130_fd_sc_hd__fill_2
XFILLER_17_655 vssd1 vssd1 vccd1 vccd1 sky130_fd_sc_hd__fill_4
X_11975_ cell0.SB0.route_sel\[81\] cell0.SB0.route_sel\[80\] net785 vssd1 vssd1 vccd1
+ vccd1 _00412_ sky130_fd_sc_hd__mux2_1
X_13714_ clknet_leaf_28_clk _00686_ net618 vssd1 vssd1 vccd1 vccd1 cell2.CB_0.config_dataA\[16\]
+ sky130_fd_sc_hd__dfstp_1
X_10926_ net274 _05878_ _05858_ vssd1 vssd1 vccd1 vccd1 _05880_ sky130_fd_sc_hd__a21o_1
X_13645_ clknet_leaf_37_clk _00617_ net646 vssd1 vssd1 vccd1 vccd1 cell2.LE_1B.edge_mode
+ sky130_fd_sc_hd__dfstp_1
X_10857_ cell3.CB_1.config_dataB\[18\] cell3.CB_1.config_dataB\[17\] vssd1 vssd1 vccd1
+ vccd1 _05813_ sky130_fd_sc_hd__nor2_1
X_10788_ net13 _05724_ _05726_ net14 cell3.CB_1.config_dataB\[8\] vssd1 vssd1 vccd1
+ vccd1 _05744_ sky130_fd_sc_hd__a221o_1
XPHY_EDGE_ROW_59_Right_59 vssd1 vssd1 vccd1 vccd1 sky130_fd_sc_hd__decap_3
X_13576_ clknet_leaf_91_clk _00548_ net698 vssd1 vssd1 vccd1 vccd1 cell1.LE_0A.reset_mode
+ sky130_fd_sc_hd__dfrtp_1
X_12527_ cell2.LEI0.config_data\[41\] net1386 net840 vssd1 vssd1 vccd1 vccd1 _00956_
+ sky130_fd_sc_hd__mux2_1
X_12458_ cell2.LE_0B.reset_val cell2.LE_0B.edge_mode net844 vssd1 vssd1 vccd1 vccd1
+ _00889_ sky130_fd_sc_hd__mux2_1
XANTENNA__09756__A1 bus3_2\[14\] vssd1 vssd1 vccd1 vccd1 sky130_fd_sc_hd__diode_2
XANTENNA__11668__S net787 vssd1 vssd1 vccd1 vccd1 sky130_fd_sc_hd__diode_2
X_11409_ cell0.SB0.route_sel\[94\] cell0.SB0.route_sel\[95\] vssd1 vssd1 vccd1 vccd1
+ _06273_ sky130_fd_sc_hd__nor2_1
X_12389_ cell1.SB0.config_data_out cell1.SB0.route_sel\[126\] net802 vssd1 vssd1 vccd1
+ vccd1 _00822_ sky130_fd_sc_hd__mux2_1
X_14128_ clknet_leaf_64_clk net1182 net744 vssd1 vssd1 vccd1 vccd1 cell3.LE_1B.config_data\[8\]
+ sky130_fd_sc_hd__dfrtp_1
XFILLER_4_581 vssd1 vssd1 vccd1 vccd1 sky130_fd_sc_hd__fill_4
XANTENNA__10118__A2 net34 vssd1 vssd1 vccd1 vccd1 sky130_fd_sc_hd__diode_2
X_14059_ clknet_leaf_81_clk _01031_ net702 vssd1 vssd1 vccd1 vccd1 cell3.SB0.route_sel\[67\]
+ sky130_fd_sc_hd__dfstp_1
X_06950_ net358 _02015_ vssd1 vssd1 vccd1 vccd1 _02016_ sky130_fd_sc_hd__nor2_1
XFILLER_79_393 vssd1 vssd1 vccd1 vccd1 sky130_fd_sc_hd__fill_8
XPHY_EDGE_ROW_68_Right_68 vssd1 vssd1 vccd1 vccd1 sky130_fd_sc_hd__decap_3
X_06881_ net359 _01947_ bus2_0\[7\] vssd1 vssd1 vccd1 vccd1 _01949_ sky130_fd_sc_hd__o21a_1
XANTENNA__11256__X net188 vssd1 vssd1 vccd1 vccd1 sky130_fd_sc_hd__diode_2
XTAP_TAPCELL_ROW_87_1618 vssd1 vccd1 sky130_fd_sc_hd__tapvpwrvgnd_1
XTAP_TAPCELL_ROW_87_1607 vssd1 vccd1 sky130_fd_sc_hd__tapvpwrvgnd_1
X_08620_ _03654_ _03655_ _03583_ vssd1 vssd1 vccd1 vccd1 _03656_ sky130_fd_sc_hd__mux2_1
XANTENNA__08731__A2 net336 vssd1 vssd1 vccd1 vccd1 sky130_fd_sc_hd__diode_2
XFILLER_82_569 vssd1 vssd1 vccd1 vccd1 sky130_fd_sc_hd__fill_1
XFILLER_82_547 vssd1 vssd1 vccd1 vccd1 sky130_fd_sc_hd__fill_1
XPHY_EDGE_ROW_59_Left_202 vssd1 vssd1 vccd1 vccd1 sky130_fd_sc_hd__decap_3
X_08551_ net491 net490 vssd1 vssd1 vccd1 vccd1 _03587_ sky130_fd_sc_hd__nor2_1
X_07502_ _02550_ _02553_ vssd1 vssd1 vccd1 vccd1 _02554_ sky130_fd_sc_hd__nor2_1
X_08482_ _03517_ vssd1 vssd1 vccd1 vccd1 _03518_ sky130_fd_sc_hd__inv_2
X_07433_ _01867_ _02340_ bus2_0\[14\] vssd1 vssd1 vccd1 vccd1 _02487_ sky130_fd_sc_hd__o21a_1
XTAP_TAPCELL_ROW_46_992 vssd1 vccd1 sky130_fd_sc_hd__tapvpwrvgnd_1
XANTENNA__12579__A0 cell3.SB0.route_sel\[44\] vssd1 vssd1 vccd1 vccd1 sky130_fd_sc_hd__diode_2
XPHY_EDGE_ROW_77_Right_77 vssd1 vssd1 vccd1 vccd1 sky130_fd_sc_hd__decap_3
XFILLER_22_135 vssd1 vssd1 vccd1 vccd1 sky130_fd_sc_hd__fill_1
X_09103_ net476 _03858_ _04132_ net475 vssd1 vssd1 vccd1 vccd1 _04133_ sky130_fd_sc_hd__o211a_1
XFILLER_50_477 vssd1 vssd1 vccd1 vccd1 sky130_fd_sc_hd__fill_1
X_07364_ cell0.SB0.route_sel\[104\] cell0.SB0.route_sel\[105\] _02419_ vssd1 vssd1
+ vccd1 vccd1 _02420_ sky130_fd_sc_hd__a21oi_1
XANTENNA__08247__B2 bus1_0\[4\] vssd1 vssd1 vccd1 vccd1 sky130_fd_sc_hd__diode_2
XANTENNA__08247__A1 bus1_0\[5\] vssd1 vssd1 vccd1 vccd1 sky130_fd_sc_hd__diode_2
XANTENNA_fanout315_A net316 vssd1 vssd1 vccd1 vccd1 sky130_fd_sc_hd__diode_2
XANTENNA__10054__A1 bus3_2\[2\] vssd1 vssd1 vccd1 vccd1 sky130_fd_sc_hd__diode_2
X_07295_ cell1.SB0.route_sel\[103\] cell1.SB0.route_sel\[102\] _02328_ _02352_ vssd1
+ vssd1 vccd1 vccd1 _02353_ sky130_fd_sc_hd__a211o_1
X_09034_ net485 _03858_ _04063_ net484 vssd1 vssd1 vccd1 vccd1 _04064_ sky130_fd_sc_hd__o211a_1
Xhold320 cell2.LE_0B.config_data\[9\] vssd1 vssd1 vccd1 vccd1 net1279 sky130_fd_sc_hd__dlygate4sd3_1
XFILLER_117_741 vssd1 vssd1 vccd1 vccd1 sky130_fd_sc_hd__fill_1
XPHY_EDGE_ROW_68_Left_211 vssd1 vssd1 vccd1 vccd1 sky130_fd_sc_hd__decap_3
XFILLER_116_262 vssd1 vssd1 vccd1 vccd1 sky130_fd_sc_hd__fill_1
Xhold342 cell0.LE_0B.config_data\[0\] vssd1 vssd1 vccd1 vccd1 net1301 sky130_fd_sc_hd__dlygate4sd3_1
Xhold353 _00124_ vssd1 vssd1 vccd1 vccd1 net1312 sky130_fd_sc_hd__dlygate4sd3_1
XFILLER_2_529 vssd1 vssd1 vccd1 vccd1 sky130_fd_sc_hd__fill_2
Xhold331 cell1.LE_1B.config_data\[1\] vssd1 vssd1 vccd1 vccd1 net1290 sky130_fd_sc_hd__dlygate4sd3_1
XFILLER_117_57 vssd1 vssd1 vccd1 vccd1 sky130_fd_sc_hd__fill_4
XFILLER_89_135 vssd1 vssd1 vccd1 vccd1 sky130_fd_sc_hd__fill_1
Xfanout800 net806 vssd1 vssd1 vccd1 vccd1 net800 sky130_fd_sc_hd__clkbuf_2
Xhold386 cell1.LEI0.config_data\[25\] vssd1 vssd1 vccd1 vccd1 net1345 sky130_fd_sc_hd__dlygate4sd3_1
Xhold375 cell0.LEI0.config_data\[15\] vssd1 vssd1 vccd1 vccd1 net1334 sky130_fd_sc_hd__dlygate4sd3_1
Xhold364 cell1.LEI0.config_data\[31\] vssd1 vssd1 vccd1 vccd1 net1323 sky130_fd_sc_hd__dlygate4sd3_1
XANTENNA_fanout684_A net750 vssd1 vssd1 vccd1 vccd1 sky130_fd_sc_hd__diode_2
Xfanout822 net824 vssd1 vssd1 vccd1 vccd1 net822 sky130_fd_sc_hd__clkbuf_4
Xfanout833 net837 vssd1 vssd1 vccd1 vccd1 net833 sky130_fd_sc_hd__clkbuf_4
X_09936_ net410 _04696_ _04939_ cell2.CB_1.config_dataB\[1\] vssd1 vssd1 vccd1 vccd1
+ _04940_ sky130_fd_sc_hd__o211a_1
Xfanout811 net828 vssd1 vssd1 vccd1 vccd1 net811 sky130_fd_sc_hd__clkbuf_2
XPHY_EDGE_ROW_86_Right_86 vssd1 vssd1 vccd1 vccd1 sky130_fd_sc_hd__decap_3
Xhold397 _00535_ vssd1 vssd1 vccd1 vccd1 net1356 sky130_fd_sc_hd__dlygate4sd3_1
Xfanout844 net845 vssd1 vssd1 vccd1 vccd1 net844 sky130_fd_sc_hd__clkbuf_2
Xfanout855 net130 vssd1 vssd1 vccd1 vccd1 net855 sky130_fd_sc_hd__clkbuf_4
XTAP_TAPCELL_ROW_129_2246 vssd1 vccd1 sky130_fd_sc_hd__tapvpwrvgnd_1
Xfanout866 net867 vssd1 vssd1 vccd1 vccd1 net866 sky130_fd_sc_hd__clkbuf_4
XANTENNA_fanout949_A net952 vssd1 vssd1 vccd1 vccd1 sky130_fd_sc_hd__diode_2
XANTENNA_fanout851_A net854 vssd1 vssd1 vccd1 vccd1 sky130_fd_sc_hd__diode_2
X_09867_ net439 _04608_ vssd1 vssd1 vccd1 vccd1 _04873_ sky130_fd_sc_hd__nand2_1
Xfanout877 net880 vssd1 vssd1 vccd1 vccd1 net877 sky130_fd_sc_hd__clkbuf_4
XTAP_TAPCELL_ROW_51_1076 vssd1 vccd1 sky130_fd_sc_hd__tapvpwrvgnd_1
Xfanout899 net907 vssd1 vssd1 vccd1 vccd1 net899 sky130_fd_sc_hd__clkbuf_4
XANTENNA__08722__A2 net6 vssd1 vssd1 vccd1 vccd1 sky130_fd_sc_hd__diode_2
XTAP_TAPCELL_ROW_5_389 vssd1 vccd1 sky130_fd_sc_hd__tapvpwrvgnd_1
XTAP_TAPCELL_ROW_5_378 vssd1 vccd1 sky130_fd_sc_hd__tapvpwrvgnd_1
Xfanout888 net890 vssd1 vssd1 vccd1 vccd1 net888 sky130_fd_sc_hd__clkbuf_4
XTAP_TAPCELL_ROW_142_2435 vssd1 vccd1 sky130_fd_sc_hd__tapvpwrvgnd_1
X_09798_ bus3_2\[8\] bus3_2\[9\] bus3_2\[10\] bus3_2\[11\] net447 net446 vssd1 vssd1
+ vccd1 vccd1 _04804_ sky130_fd_sc_hd__mux4_1
XFILLER_93_27 vccd1 vssd1 vccd1 vssd1 sky130_ef_sc_hd__decap_40_12
XPHY_EDGE_ROW_77_Left_220 vssd1 vssd1 vccd1 vccd1 sky130_fd_sc_hd__decap_3
XFILLER_73_514 vssd1 vssd1 vccd1 vccd1 sky130_fd_sc_hd__fill_2
X_08818_ _01527_ cell1.SB0.route_sel\[71\] vssd1 vssd1 vccd1 vccd1 _03850_ sky130_fd_sc_hd__nand2_1
XTAP_TAPCELL_ROW_142_2457 vssd1 vccd1 sky130_fd_sc_hd__tapvpwrvgnd_1
XTAP_TAPCELL_ROW_142_2446 vssd1 vccd1 sky130_fd_sc_hd__tapvpwrvgnd_1
XFILLER_73_558 vssd1 vssd1 vccd1 vccd1 sky130_fd_sc_hd__fill_2
X_08749_ net452 _03509_ vssd1 vssd1 vccd1 vccd1 _03783_ sky130_fd_sc_hd__nand2_1
XANTENNA__10817__A0 _05501_ vssd1 vssd1 vccd1 vccd1 sky130_fd_sc_hd__diode_2
X_11760_ net1497 cell0.LEI0.config_data\[9\] net799 vssd1 vssd1 vccd1 vccd1 _00197_
+ sky130_fd_sc_hd__mux2_1
XFILLER_14_614 vssd1 vssd1 vccd1 vccd1 sky130_fd_sc_hd__fill_2
XFILLER_26_65 vssd1 vssd1 vccd1 vccd1 sky130_fd_sc_hd__fill_4
XPHY_EDGE_ROW_95_Right_95 vssd1 vssd1 vccd1 vccd1 sky130_fd_sc_hd__decap_3
X_10711_ _05647_ _05651_ _05654_ _05668_ cell3.CB_1.config_dataA\[19\] vssd1 vssd1
+ vccd1 vccd1 _05669_ sky130_fd_sc_hd__a311o_1
XFILLER_26_76 vssd1 vssd1 vccd1 vccd1 sky130_fd_sc_hd__fill_8
XFILLER_26_98 vccd1 vssd1 vccd1 vssd1 sky130_ef_sc_hd__decap_40_12
XANTENNA__12438__A net755 vssd1 vssd1 vccd1 vccd1 sky130_fd_sc_hd__diode_2
X_11691_ net1266 net1155 net873 vssd1 vssd1 vccd1 vccd1 _00131_ sky130_fd_sc_hd__mux2_1
X_10642_ cell3.CB_1.config_dataA\[4\] _05596_ _05599_ vssd1 vssd1 vccd1 vccd1 _05600_
+ sky130_fd_sc_hd__o21ai_4
X_13430_ clknet_leaf_131_clk _00402_ net562 vssd1 vssd1 vccd1 vccd1 cell0.SB0.route_sel\[71\]
+ sky130_fd_sc_hd__dfstp_1
XTAP_TAPCELL_ROW_24_664 vssd1 vccd1 sky130_fd_sc_hd__tapvpwrvgnd_1
XTAP_TAPCELL_ROW_24_675 vssd1 vccd1 sky130_fd_sc_hd__tapvpwrvgnd_1
XANTENNA__11181__A1_N _05924_ vssd1 vssd1 vccd1 vccd1 sky130_fd_sc_hd__diode_2
X_10573_ _04676_ _04682_ _04687_ _05530_ vssd1 vssd1 vccd1 vccd1 _05531_ sky130_fd_sc_hd__a211o_4
XANTENNA__10045__A1 bus3_2\[4\] vssd1 vssd1 vccd1 vccd1 sky130_fd_sc_hd__diode_2
XANTENNA__10045__B2 bus3_2\[5\] vssd1 vssd1 vccd1 vccd1 sky130_fd_sc_hd__diode_2
X_13361_ clknet_leaf_128_clk _00333_ net577 vssd1 vssd1 vccd1 vccd1 cell0.SB0.route_sel\[2\]
+ sky130_fd_sc_hd__dfstp_1
XFILLER_5_301 vssd1 vssd1 vccd1 vccd1 sky130_fd_sc_hd__fill_2
X_12312_ cell1.SB0.route_sel\[50\] cell1.SB0.route_sel\[49\] net858 vssd1 vssd1 vccd1
+ vccd1 _00745_ sky130_fd_sc_hd__mux2_1
X_13292_ clknet_leaf_99_clk _00264_ net679 vssd1 vssd1 vccd1 vccd1 cell1.CB_1.config_dataA\[8\]
+ sky130_fd_sc_hd__dfstp_1
X_12243_ net417 net418 net822 vssd1 vssd1 vccd1 vccd1 _00676_ sky130_fd_sc_hd__mux2_1
XANTENNA_input78_A SBsouth_in[21] vssd1 vssd1 vccd1 vccd1 sky130_fd_sc_hd__diode_2
XANTENNA__08651__A net458 vssd1 vssd1 vccd1 vccd1 sky130_fd_sc_hd__diode_2
XANTENNA__10348__A2 _05128_ vssd1 vssd1 vccd1 vccd1 sky130_fd_sc_hd__diode_2
X_12174_ net1199 net1172 net852 vssd1 vssd1 vccd1 vccd1 _00607_ sky130_fd_sc_hd__mux2_1
X_11125_ _05847_ _05851_ net387 vssd1 vssd1 vccd1 vccd1 _06077_ sky130_fd_sc_hd__mux2_1
XANTENNA_input33_X net33 vssd1 vssd1 vccd1 vccd1 sky130_fd_sc_hd__diode_2
X_11056_ _05893_ _05890_ net373 vssd1 vssd1 vccd1 vccd1 _06010_ sky130_fd_sc_hd__mux2_1
XFILLER_3_69 vccd1 vssd1 vccd1 vssd1 sky130_ef_sc_hd__decap_40_12
XFILLER_1_573 vccd1 vssd1 vccd1 vssd1 sky130_ef_sc_hd__decap_40_12
X_10007_ _04260_ _04996_ _04997_ _04197_ cell2.CB_1.config_dataB\[12\] vssd1 vssd1
+ vccd1 vccd1 _05011_ sky130_fd_sc_hd__a221o_1
XANTENNA_output234_A net234 vssd1 vssd1 vccd1 vccd1 sky130_fd_sc_hd__diode_2
XANTENNA__08713__A2 _03533_ vssd1 vssd1 vccd1 vccd1 sky130_fd_sc_hd__diode_2
XFILLER_76_363 vssd1 vssd1 vccd1 vccd1 sky130_fd_sc_hd__fill_1
XTAP_TAPCELL_ROW_69_1337 vssd1 vccd1 sky130_fd_sc_hd__tapvpwrvgnd_1
XTAP_TAPCELL_ROW_69_1348 vssd1 vccd1 sky130_fd_sc_hd__tapvpwrvgnd_1
XFILLER_45_783 vssd1 vssd1 vccd1 vccd1 sky130_fd_sc_hd__fill_1
XTAP_TAPCELL_ROW_82_1537 vssd1 vccd1 sky130_fd_sc_hd__tapvpwrvgnd_1
XFILLER_17_485 vssd1 vssd1 vccd1 vccd1 sky130_fd_sc_hd__fill_1
X_11958_ cell0.SB0.route_sel\[64\] cell0.SB0.route_sel\[63\] net764 vssd1 vssd1 vccd1
+ vccd1 _00395_ sky130_fd_sc_hd__mux2_1
XANTENNA__10284__B2 _05136_ vssd1 vssd1 vccd1 vccd1 sky130_fd_sc_hd__diode_2
X_10909_ _05856_ _05857_ _05861_ _05862_ _01805_ vssd1 vssd1 vccd1 vccd1 _05863_ sky130_fd_sc_hd__a221o_1
X_11889_ cell1.CB_0.config_dataA\[20\] cell1.CB_0.config_dataA\[19\] net874 vssd1
+ vssd1 vccd1 vccd1 _00326_ sky130_fd_sc_hd__mux2_1
XTAP_TAPCELL_ROW_43_951 vssd1 vccd1 sky130_fd_sc_hd__tapvpwrvgnd_1
X_13628_ clknet_leaf_39_clk _00600_ net645 vssd1 vssd1 vccd1 vccd1 cell2.LE_1B.config_data\[0\]
+ sky130_fd_sc_hd__dfrtp_1
XFILLER_20_639 vssd1 vssd1 vccd1 vccd1 sky130_fd_sc_hd__fill_1
XANTENNA__08229__A1 bus1_0\[13\] vssd1 vssd1 vccd1 vccd1 sky130_fd_sc_hd__diode_2
X_13559_ clknet_leaf_117_clk _00531_ net669 vssd1 vssd1 vccd1 vccd1 cell1.LE_0A.config_data\[2\]
+ sky130_fd_sc_hd__dfrtp_1
XFILLER_9_651 vccd1 vssd1 vccd1 vssd1 sky130_ef_sc_hd__decap_40_12
XANTENNA__09657__A _02469_ vssd1 vssd1 vccd1 vccd1 sky130_fd_sc_hd__diode_2
XFILLER_9_673 vccd1 vssd1 vccd1 vssd1 sky130_ef_sc_hd__decap_40_12
XFILLER_8_150 vssd1 vssd1 vccd1 vccd1 sky130_fd_sc_hd__fill_1
X_07080_ _02047_ _02143_ vssd1 vssd1 vccd1 vccd1 _02144_ sky130_fd_sc_hd__nor2_1
XTAP_TAPCELL_ROW_113_2003 vssd1 vccd1 sky130_fd_sc_hd__tapvpwrvgnd_1
XFILLER_8_183 vccd1 vssd1 vccd1 vssd1 sky130_ef_sc_hd__decap_40_12
XANTENNA__10339__A2 net38 vssd1 vssd1 vccd1 vccd1 sky130_fd_sc_hd__diode_2
XANTENNA__12733__A0 cell3.CB_0.config_dataA\[0\] vssd1 vssd1 vccd1 vccd1 sky130_fd_sc_hd__diode_2
XANTENNA__10155__X _05156_ vssd1 vssd1 vccd1 vccd1 sky130_fd_sc_hd__diode_2
XANTENNA__08401__B2 bus1_0\[5\] vssd1 vssd1 vccd1 vccd1 sky130_fd_sc_hd__diode_2
XANTENNA__08401__A1 bus1_0\[4\] vssd1 vssd1 vccd1 vccd1 sky130_fd_sc_hd__diode_2
XFILLER_141_563 vssd1 vssd1 vccd1 vccd1 sky130_fd_sc_hd__fill_1
XTAP_TAPCELL_ROW_93_1699 vssd1 vccd1 sky130_fd_sc_hd__tapvpwrvgnd_1
X_07982_ cell0.LE_0A.dff0_out cell0.LE_0A.dff1_out cell0.LE_0A.reset_val vssd1 vssd1
+ vccd1 vccd1 cell0.LE_0A.dff_out sky130_fd_sc_hd__mux2_1
X_06933_ cell2.CB_0.config_dataB\[24\] cell2.CB_0.config_dataB\[21\] cell2.CB_0.config_dataB\[20\]
+ vssd1 vssd1 vccd1 vccd1 _02000_ sky130_fd_sc_hd__and3b_2
X_09721_ net381 net380 _04363_ vssd1 vssd1 vccd1 vccd1 _04734_ sky130_fd_sc_hd__and3_1
XANTENNA__08165__A0 bus1_0\[0\] vssd1 vssd1 vccd1 vccd1 sky130_fd_sc_hd__diode_2
XFILLER_103_15 vssd1 vssd1 vccd1 vccd1 sky130_fd_sc_hd__fill_8
XFILLER_55_503 vssd1 vssd1 vccd1 vccd1 sky130_fd_sc_hd__fill_1
X_09652_ net330 _02438_ _04666_ vssd1 vssd1 vccd1 vccd1 _04667_ sky130_fd_sc_hd__o21ai_1
XTAP_TAPCELL_ROW_2_337 vssd1 vccd1 sky130_fd_sc_hd__tapvpwrvgnd_1
X_06864_ cell0.CB_1.config_dataB\[24\] cell0.CB_1.config_dataB\[20\] cell0.CB_1.config_dataB\[21\]
+ vssd1 vssd1 vccd1 vccd1 _01932_ sky130_fd_sc_hd__and3b_1
XFILLER_94_193 vssd1 vssd1 vccd1 vccd1 sky130_fd_sc_hd__fill_2
XANTENNA__10050__B _04498_ vssd1 vssd1 vccd1 vccd1 sky130_fd_sc_hd__diode_2
X_09583_ _04590_ _04600_ net917 vssd1 vssd1 vccd1 vccd1 _04601_ sky130_fd_sc_hd__a21o_1
X_06795_ net343 _01862_ _01863_ vssd1 vssd1 vccd1 vccd1 _01865_ sky130_fd_sc_hd__or3_1
XANTENNA__08180__A3 bus1_0\[11\] vssd1 vssd1 vccd1 vccd1 sky130_fd_sc_hd__diode_2
X_08603_ net489 _03465_ _03638_ net487 vssd1 vssd1 vccd1 vccd1 _03639_ sky130_fd_sc_hd__o211a_1
XTAP_TAPCELL_ROW_124_2165 vssd1 vccd1 sky130_fd_sc_hd__tapvpwrvgnd_1
XANTENNA__09665__A0 net22 vssd1 vssd1 vccd1 vccd1 sky130_fd_sc_hd__diode_2
XFILLER_55_569 vssd1 vssd1 vccd1 vccd1 sky130_fd_sc_hd__fill_1
X_08534_ _03569_ _03568_ cell1.CB_1.config_dataA\[7\] vssd1 vssd1 vccd1 vccd1 _03570_
+ sky130_fd_sc_hd__mux2_1
XANTENNA__10814__A3 net11 vssd1 vssd1 vccd1 vccd1 sky130_fd_sc_hd__diode_2
X_08465_ _03480_ _03483_ _03500_ cell1.CB_1.config_dataA\[3\] vssd1 vssd1 vccd1 vccd1
+ _03501_ sky130_fd_sc_hd__or4b_1
XANTENNA__10988__A1_N _05879_ vssd1 vssd1 vccd1 vccd1 sky130_fd_sc_hd__diode_2
X_07416_ cell2.SB0.route_sel\[104\] _01641_ cell2.SB0.route_sel\[107\] _01642_ _02470_
+ vssd1 vssd1 vccd1 vccd1 _02471_ sky130_fd_sc_hd__a221o_1
X_08396_ net500 _02719_ _03433_ net499 vssd1 vssd1 vccd1 vccd1 _03434_ sky130_fd_sc_hd__o211a_1
X_07347_ _01637_ cell2.SB0.route_sel\[98\] cell2.SB0.route_sel\[102\] cell2.SB0.route_sel\[103\]
+ _02403_ vssd1 vssd1 vccd1 vccd1 _02404_ sky130_fd_sc_hd__o221a_1
XTAP_TAPCELL_ROW_21_623 vssd1 vccd1 sky130_fd_sc_hd__tapvpwrvgnd_1
XANTENNA_fanout318_X net318 vssd1 vssd1 vccd1 vccd1 sky130_fd_sc_hd__diode_2
XFILLER_6_109 vccd1 vssd1 vccd1 vssd1 sky130_ef_sc_hd__decap_40_12
X_09017_ _04042_ _04046_ cell1.CB_0.config_dataB\[9\] _04035_ vssd1 vssd1 vccd1 vccd1
+ _04047_ sky130_fd_sc_hd__a211o_1
X_07278_ cell0.CB_0.config_dataA\[22\] cell0.CB_0.config_dataA\[23\] vssd1 vssd1 vccd1
+ vccd1 _02336_ sky130_fd_sc_hd__nand2_2
XANTENNA_fanout899_A net907 vssd1 vssd1 vccd1 vccd1 sky130_fd_sc_hd__diode_2
XFILLER_88_27 vssd1 vssd1 vccd1 vccd1 sky130_fd_sc_hd__fill_1
XANTENNA__07994__A3 bus2_0\[15\] vssd1 vssd1 vccd1 vccd1 sky130_fd_sc_hd__diode_2
XFILLER_12_89 vssd1 vssd1 vccd1 vccd1 sky130_fd_sc_hd__fill_1
Xhold150 cell2.LE_1A.config_data\[6\] vssd1 vssd1 vccd1 vccd1 net1109 sky130_fd_sc_hd__dlygate4sd3_1
Xhold161 cell0.LEI0.config_data\[40\] vssd1 vssd1 vccd1 vccd1 net1120 sky130_fd_sc_hd__dlygate4sd3_1
Xhold172 _01397_ vssd1 vssd1 vccd1 vccd1 net1131 sky130_fd_sc_hd__dlygate4sd3_1
Xhold183 _00540_ vssd1 vssd1 vccd1 vccd1 net1142 sky130_fd_sc_hd__dlygate4sd3_1
XTAP_TAPCELL_ROW_53_1105 vssd1 vccd1 sky130_fd_sc_hd__tapvpwrvgnd_1
Xhold194 _00126_ vssd1 vssd1 vccd1 vccd1 net1153 sky130_fd_sc_hd__dlygate4sd3_1
Xfanout641 net649 vssd1 vssd1 vccd1 vccd1 net641 sky130_fd_sc_hd__clkbuf_4
Xfanout630 net631 vssd1 vssd1 vccd1 vccd1 net630 sky130_fd_sc_hd__clkbuf_2
XANTENNA_fanout854_X net854 vssd1 vssd1 vccd1 vccd1 sky130_fd_sc_hd__diode_2
X_09919_ net409 net408 vssd1 vssd1 vccd1 vccd1 _04923_ sky130_fd_sc_hd__or2_1
Xfanout674 net675 vssd1 vssd1 vccd1 vccd1 net674 sky130_fd_sc_hd__clkbuf_4
Xfanout685 net691 vssd1 vssd1 vccd1 vccd1 net685 sky130_fd_sc_hd__clkbuf_4
XANTENNA__08156__A0 net344 vssd1 vssd1 vccd1 vccd1 sky130_fd_sc_hd__diode_2
Xfanout652 net653 vssd1 vssd1 vccd1 vccd1 net652 sky130_fd_sc_hd__clkbuf_4
Xfanout663 net664 vssd1 vssd1 vccd1 vccd1 net663 sky130_fd_sc_hd__clkbuf_2
X_12930_ net1505 cell3.LE_1A.edge_mode net953 vssd1 vssd1 vccd1 vccd1 _01359_ sky130_fd_sc_hd__mux2_1
XTAP_TAPCELL_ROW_109_1938 vssd1 vccd1 sky130_fd_sc_hd__tapvpwrvgnd_1
Xfanout696 net700 vssd1 vssd1 vccd1 vccd1 net696 sky130_fd_sc_hd__clkbuf_4
XANTENNA_input132_A le_nrst vssd1 vssd1 vccd1 vccd1 sky130_fd_sc_hd__diode_2
XTAP_TAPCELL_ROW_109_1949 vssd1 vccd1 sky130_fd_sc_hd__tapvpwrvgnd_1
X_12861_ cell2.SB0.route_sel\[103\] cell2.SB0.route_sel\[102\] net821 vssd1 vssd1
+ vccd1 vccd1 _01290_ sky130_fd_sc_hd__mux2_1
XTAP_TAPCELL_ROW_29_745 vssd1 vccd1 sky130_fd_sc_hd__tapvpwrvgnd_1
X_11812_ net1525 cell1.LE_1B.config_data\[12\] net902 vssd1 vssd1 vccd1 vccd1 _00249_
+ sky130_fd_sc_hd__mux2_1
X_12792_ cell2.SB0.route_sel\[34\] cell2.SB0.route_sel\[33\] net820 vssd1 vssd1 vccd1
+ vccd1 _01221_ sky130_fd_sc_hd__mux2_1
XANTENNA__08646__A net458 vssd1 vssd1 vccd1 vccd1 sky130_fd_sc_hd__diode_2
XANTENNA__08459__A1 _02444_ vssd1 vssd1 vccd1 vccd1 sky130_fd_sc_hd__diode_2
X_11743_ cell0.LE_0A.config_data\[16\] net1085 net809 vssd1 vssd1 vccd1 vccd1 _00181_
+ sky130_fd_sc_hd__mux2_1
XTAP_TAPCELL_ROW_64_1267 vssd1 vccd1 sky130_fd_sc_hd__tapvpwrvgnd_1
XFILLER_53_30 vssd1 vssd1 vccd1 vccd1 sky130_fd_sc_hd__fill_1
XANTENNA__09120__A2 bus3_1\[10\] vssd1 vssd1 vccd1 vccd1 sky130_fd_sc_hd__diode_2
X_14462_ clknet_leaf_60_clk _01434_ net740 vssd1 vssd1 vccd1 vccd1 cell3.LEI0.config_data\[27\]
+ sky130_fd_sc_hd__dfrtp_1
XANTENNA__09408__B1 _04430_ vssd1 vssd1 vccd1 vccd1 sky130_fd_sc_hd__diode_2
XTAP_TAPCELL_ROW_40_910 vssd1 vccd1 sky130_fd_sc_hd__tapvpwrvgnd_1
X_11674_ cell0.CB_1.config_dataB\[20\] cell0.CB_1.config_dataB\[19\] net784 vssd1
+ vssd1 vccd1 vccd1 _00115_ sky130_fd_sc_hd__mux2_1
XANTENNA__11215__A0 _05871_ vssd1 vssd1 vccd1 vccd1 sky130_fd_sc_hd__diode_2
XANTENNA__09959__A1 bus3_2\[7\] vssd1 vssd1 vccd1 vccd1 sky130_fd_sc_hd__diode_2
X_10625_ _04419_ _05488_ _05566_ vssd1 vssd1 vccd1 vccd1 _05583_ sky130_fd_sc_hd__a21oi_1
X_13413_ clknet_leaf_134_clk _00385_ net555 vssd1 vssd1 vccd1 vccd1 cell0.SB0.route_sel\[54\]
+ sky130_fd_sc_hd__dfstp_1
X_14393_ clknet_leaf_57_clk net1016 net721 vssd1 vssd1 vccd1 vccd1 cell3.LE_0B.config_data\[2\]
+ sky130_fd_sc_hd__dfrtp_1
XANTENNA__09477__A _02008_ vssd1 vssd1 vccd1 vccd1 sky130_fd_sc_hd__diode_2
XFILLER_6_610 vccd1 vssd1 vccd1 vssd1 sky130_ef_sc_hd__decap_40_12
XANTENNA_output184_A net184 vssd1 vssd1 vccd1 vccd1 sky130_fd_sc_hd__diode_2
X_10556_ _05491_ _05513_ _01787_ vssd1 vssd1 vccd1 vccd1 _05514_ sky130_fd_sc_hd__o21ai_1
X_13344_ clknet_leaf_114_clk _00316_ net673 vssd1 vssd1 vccd1 vccd1 cell1.CB_0.config_dataA\[10\]
+ sky130_fd_sc_hd__dfstp_1
X_13275_ clknet_leaf_92_clk _00247_ net694 vssd1 vssd1 vccd1 vccd1 cell1.LE_1B.config_data\[11\]
+ sky130_fd_sc_hd__dfrtp_1
X_10487_ net320 _03505_ _02726_ vssd1 vssd1 vccd1 vccd1 _05459_ sky130_fd_sc_hd__mux2_1
XFILLER_135_390 vssd1 vssd1 vccd1 vccd1 sky130_fd_sc_hd__fill_2
X_12226_ cell2.CB_0.config_dataB\[14\] cell2.CB_0.config_dataB\[13\] net824 vssd1
+ vssd1 vccd1 vccd1 _00659_ sky130_fd_sc_hd__mux2_1
XANTENNA_clkbuf_4_12_0_clk_X clknet_4_12_0_clk vssd1 vssd1 vccd1 vccd1 sky130_fd_sc_hd__diode_2
XANTENNA__10135__B _04442_ vssd1 vssd1 vccd1 vccd1 sky130_fd_sc_hd__diode_2
X_12157_ net1270 net1238 net893 vssd1 vssd1 vccd1 vccd1 _00590_ sky130_fd_sc_hd__mux2_1
XANTENNA__09483__Y _04504_ vssd1 vssd1 vccd1 vccd1 sky130_fd_sc_hd__diode_2
XANTENNA__08934__A2 net336 vssd1 vssd1 vccd1 vccd1 sky130_fd_sc_hd__diode_2
X_11108_ cell3.CB_0.config_dataB\[0\] _05893_ net388 vssd1 vssd1 vccd1 vccd1 _06060_
+ sky130_fd_sc_hd__o21a_1
X_12088_ cell1.LE_0B.config_data\[16\] net1531 net906 vssd1 vssd1 vccd1 vccd1 _00523_
+ sky130_fd_sc_hd__mux2_1
XFILLER_49_341 vssd1 vssd1 vccd1 vccd1 sky130_fd_sc_hd__fill_2
X_11039_ cell3.CB_0.config_dataA\[14\] _05965_ _05981_ _05992_ vssd1 vssd1 vccd1 vccd1
+ _05993_ sky130_fd_sc_hd__a31o_1
XFILLER_49_352 vssd1 vssd1 vccd1 vccd1 sky130_fd_sc_hd__fill_2
XFILLER_94_81 vssd1 vssd1 vccd1 vccd1 sky130_fd_sc_hd__fill_2
XFILLER_92_642 vssd1 vssd1 vccd1 vccd1 sky130_fd_sc_hd__fill_2
XANTENNA__08185__A1_N _02040_ vssd1 vssd1 vccd1 vccd1 sky130_fd_sc_hd__diode_2
XANTENNA__11534__X net254 vssd1 vssd1 vccd1 vccd1 sky130_fd_sc_hd__diode_2
XANTENNA__11049__A3 net52 vssd1 vssd1 vccd1 vccd1 sky130_fd_sc_hd__diode_2
XANTENNA__10257__A1 net64 vssd1 vssd1 vccd1 vccd1 sky130_fd_sc_hd__diode_2
X_06580_ cell2.SB0.route_sel\[123\] vssd1 vssd1 vccd1 vccd1 _01650_ sky130_fd_sc_hd__inv_2
XANTENNA__09111__A2 _03885_ vssd1 vssd1 vccd1 vccd1 sky130_fd_sc_hd__diode_2
X_08250_ _03289_ vssd1 vssd1 vccd1 vccd1 _03290_ sky130_fd_sc_hd__inv_2
XANTENNA__10009__A1 bus3_2\[7\] vssd1 vssd1 vccd1 vccd1 sky130_fd_sc_hd__diode_2
XANTENNA__06881__B1 bus2_0\[7\] vssd1 vssd1 vccd1 vccd1 sky130_fd_sc_hd__diode_2
X_08181_ bus1_0\[12\] bus1_0\[13\] bus1_0\[14\] bus1_0\[15\] net543 net541 vssd1 vssd1
+ vccd1 vccd1 _03221_ sky130_fd_sc_hd__mux4_1
X_07201_ _01933_ net357 bus1_0\[11\] vssd1 vssd1 vccd1 vccd1 _02261_ sky130_fd_sc_hd__o21ai_1
XFILLER_20_469 vssd1 vssd1 vccd1 vccd1 sky130_fd_sc_hd__fill_2
X_07132_ net361 _02015_ bus1_0\[10\] vssd1 vssd1 vccd1 vccd1 _02194_ sky130_fd_sc_hd__o21ai_1
XFILLER_134_806 vssd1 vssd1 vccd1 vccd1 sky130_fd_sc_hd__fill_4
XTAP_TAPCELL_ROW_95_1728 vssd1 vccd1 sky130_fd_sc_hd__tapvpwrvgnd_1
XTAP_TAPCELL_ROW_95_1739 vssd1 vccd1 sky130_fd_sc_hd__tapvpwrvgnd_1
X_07063_ _02032_ net354 bus2_0\[9\] vssd1 vssd1 vccd1 vccd1 _02127_ sky130_fd_sc_hd__o21a_1
Xoutput200 net200 vssd1 vssd1 vccd1 vccd1 SBsouth_out[11] sky130_fd_sc_hd__buf_2
XFILLER_126_390 vssd1 vssd1 vccd1 vccd1 sky130_fd_sc_hd__fill_1
Xoutput244 net244 vssd1 vssd1 vccd1 vccd1 SBwest_out[22] sky130_fd_sc_hd__buf_2
Xoutput233 net233 vssd1 vssd1 vccd1 vccd1 SBwest_out[12] sky130_fd_sc_hd__buf_2
Xoutput211 net211 vssd1 vssd1 vccd1 vccd1 SBsouth_out[21] sky130_fd_sc_hd__buf_2
Xoutput222 net222 vssd1 vssd1 vccd1 vccd1 SBsouth_out[31] sky130_fd_sc_hd__buf_2
XANTENNA__07189__A1 cell2.CB_0.le_outB vssd1 vssd1 vccd1 vccd1 sky130_fd_sc_hd__diode_2
Xoutput255 net255 vssd1 vssd1 vccd1 vccd1 SBwest_out[3] sky130_fd_sc_hd__buf_2
XTAP_TAPCELL_ROW_7_418 vssd1 vccd1 sky130_fd_sc_hd__tapvpwrvgnd_1
XTAP_TAPCELL_ROW_7_407 vssd1 vccd1 sky130_fd_sc_hd__tapvpwrvgnd_1
XTAP_TAPCELL_ROW_126_2205 vssd1 vccd1 sky130_fd_sc_hd__tapvpwrvgnd_1
XFILLER_114_25 vssd1 vssd1 vccd1 vccd1 sky130_fd_sc_hd__fill_2
X_07965_ cell0.CB_0.config_dataA\[18\] cell0.CB_0.config_dataA\[17\] cell0.CB_0.config_dataA\[19\]
+ _02984_ vssd1 vssd1 vccd1 vccd1 _03009_ sky130_fd_sc_hd__or4bb_1
X_06916_ cell2.SB0.route_sel\[62\] cell2.SB0.route_sel\[63\] _01618_ _01982_ vssd1
+ vssd1 vccd1 vccd1 _01983_ sky130_fd_sc_hd__a211oi_1
X_09704_ _02574_ _02579_ _03819_ vssd1 vssd1 vccd1 vccd1 _04717_ sky130_fd_sc_hd__and3_1
XANTENNA__08689__A1 net30 vssd1 vssd1 vccd1 vccd1 sky130_fd_sc_hd__diode_2
XANTENNA__12485__A2 net549 vssd1 vssd1 vccd1 vccd1 sky130_fd_sc_hd__diode_2
X_09635_ _01826_ _04647_ _04650_ vssd1 vssd1 vccd1 vccd1 _04651_ sky130_fd_sc_hd__a21oi_1
X_07896_ bus2_0\[12\] bus2_0\[13\] bus2_0\[14\] bus2_0\[15\] net522 net520 vssd1 vssd1
+ vccd1 vccd1 _02940_ sky130_fd_sc_hd__mux4_1
XANTENNA_clkbuf_leaf_4_clk_A clknet_4_1_0_clk vssd1 vssd1 vccd1 vccd1 sky130_fd_sc_hd__diode_2
XFILLER_28_525 vssd1 vssd1 vccd1 vccd1 sky130_fd_sc_hd__fill_4
XANTENNA_fanout647_A net649 vssd1 vssd1 vccd1 vccd1 sky130_fd_sc_hd__diode_2
X_06847_ _01864_ _01914_ _01915_ _01865_ vssd1 vssd1 vccd1 vccd1 _01916_ sky130_fd_sc_hd__o211ai_2
XANTENNA__07361__A1 net354 vssd1 vssd1 vccd1 vccd1 sky130_fd_sc_hd__diode_2
XANTENNA__11444__X net206 vssd1 vssd1 vccd1 vccd1 sky130_fd_sc_hd__diode_2
XTAP_TAPCELL_ROW_26_704 vssd1 vccd1 sky130_fd_sc_hd__tapvpwrvgnd_1
X_09566_ _01904_ _02084_ _02253_ _04582_ vssd1 vssd1 vccd1 vccd1 _04584_ sky130_fd_sc_hd__o211a_1
XANTENNA__07900__A3 cell0.CB_1.le_outB vssd1 vssd1 vccd1 vccd1 sky130_fd_sc_hd__diode_2
XFILLER_15_219 vssd1 vssd1 vccd1 vccd1 sky130_fd_sc_hd__fill_1
X_06778_ cell0.CB_1.config_dataA\[23\] cell0.CB_1.config_dataA\[22\] vssd1 vssd1 vccd1
+ vccd1 _01848_ sky130_fd_sc_hd__and2b_1
X_09497_ _04517_ net281 _04515_ vssd1 vssd1 vccd1 vccd1 _04518_ sky130_fd_sc_hd__mux2_1
XTAP_TAPCELL_ROW_104_1868 vssd1 vccd1 sky130_fd_sc_hd__tapvpwrvgnd_1
XANTENNA_fanout814_A net828 vssd1 vssd1 vccd1 vccd1 sky130_fd_sc_hd__diode_2
X_08517_ _03552_ vssd1 vssd1 vccd1 vccd1 _03553_ sky130_fd_sc_hd__inv_2
X_08448_ cell1.SB0.route_sel\[112\] cell1.SB0.route_sel\[113\] vssd1 vssd1 vccd1 vccd1
+ _03484_ sky130_fd_sc_hd__nand2b_1
XFILLER_23_55 vssd1 vssd1 vccd1 vccd1 sky130_fd_sc_hd__fill_1
XFILLER_23_296 vssd1 vssd1 vccd1 vccd1 sky130_fd_sc_hd__fill_1
XFILLER_139_55 vssd1 vssd1 vccd1 vccd1 sky130_fd_sc_hd__fill_1
XTAP_TAPCELL_ROW_137_2367 vssd1 vccd1 sky130_fd_sc_hd__tapvpwrvgnd_1
XTAP_TAPCELL_ROW_137_2356 vssd1 vccd1 sky130_fd_sc_hd__tapvpwrvgnd_1
X_10410_ _05404_ _05407_ _05408_ _01761_ _05403_ vssd1 vssd1 vccd1 vccd1 _05409_ sky130_fd_sc_hd__a221o_1
XANTENNA_fanout602_X net602 vssd1 vssd1 vccd1 vccd1 sky130_fd_sc_hd__diode_2
X_08379_ _03381_ _03416_ _03347_ vssd1 vssd1 vccd1 vccd1 _03417_ sky130_fd_sc_hd__mux2_1
XFILLER_137_644 vssd1 vssd1 vccd1 vccd1 sky130_fd_sc_hd__fill_1
XANTENNA__11212__A3 net52 vssd1 vssd1 vccd1 vccd1 sky130_fd_sc_hd__diode_2
XFILLER_99_37 vssd1 vssd1 vccd1 vccd1 sky130_fd_sc_hd__fill_8
X_11390_ _06260_ net267 vssd1 vssd1 vccd1 vccd1 net259 sky130_fd_sc_hd__and2b_2
X_10341_ cell2.CB_0.config_dataB\[2\] _05337_ _05339_ cell2.CB_0.config_dataB\[3\]
+ vssd1 vssd1 vccd1 vccd1 _05340_ sky130_fd_sc_hd__o211a_1
X_10272_ cell2.LE_0A.config_data\[11\] cell2.LE_0A.config_data\[10\] _05196_ vssd1
+ vssd1 vccd1 vccd1 _05273_ sky130_fd_sc_hd__mux2_1
X_13060_ clknet_leaf_126_clk _00032_ net651 vssd1 vssd1 vccd1 vccd1 cell0.CB_1.config_dataA\[12\]
+ sky130_fd_sc_hd__dfstp_2
XFILLER_3_613 vssd1 vssd1 vccd1 vccd1 sky130_fd_sc_hd__fill_2
XFILLER_140_809 vssd1 vssd1 vccd1 vccd1 sky130_fd_sc_hd__fill_2
XANTENNA__08377__B1 _03414_ vssd1 vssd1 vccd1 vccd1 sky130_fd_sc_hd__diode_2
X_12011_ cell0.SB0.route_sel\[117\] cell0.SB0.route_sel\[116\] net774 vssd1 vssd1
+ vccd1 vccd1 _00448_ sky130_fd_sc_hd__mux2_1
XFILLER_3_3 vccd1 vssd1 vccd1 vssd1 sky130_ef_sc_hd__decap_40_12
XFILLER_2_189 vssd1 vssd1 vccd1 vccd1 sky130_fd_sc_hd__fill_4
X_13962_ clknet_leaf_37_clk _00934_ net645 vssd1 vssd1 vccd1 vccd1 cell2.LEI0.config_data\[19\]
+ sky130_fd_sc_hd__dfrtp_1
XFILLER_120_566 vssd1 vssd1 vccd1 vccd1 sky130_fd_sc_hd__fill_1
Xfanout482 cell1.CB_0.config_dataB\[5\] vssd1 vssd1 vccd1 vccd1 net482 sky130_fd_sc_hd__buf_2
Xfanout471 cell1.CB_0.config_dataA\[5\] vssd1 vssd1 vccd1 vccd1 net471 sky130_fd_sc_hd__clkbuf_2
XFILLER_48_63 vssd1 vssd1 vccd1 vccd1 sky130_fd_sc_hd__fill_1
XFILLER_19_503 vssd1 vssd1 vccd1 vccd1 sky130_fd_sc_hd__fill_1
Xfanout493 cell1.CB_1.config_dataA\[6\] vssd1 vssd1 vccd1 vccd1 net493 sky130_fd_sc_hd__buf_2
Xfanout460 cell1.CB_1.config_dataB\[1\] vssd1 vssd1 vccd1 vccd1 net460 sky130_fd_sc_hd__clkbuf_2
X_12913_ net1410 cell3.LE_1A.config_data\[0\] net954 vssd1 vssd1 vccd1 vccd1 _01342_
+ sky130_fd_sc_hd__mux2_1
XFILLER_59_694 vssd1 vssd1 vccd1 vccd1 sky130_fd_sc_hd__fill_1
XFILLER_0_15 vccd1 vssd1 vccd1 vssd1 sky130_ef_sc_hd__decap_40_12
X_13893_ clknet_leaf_40_clk _00865_ net644 vssd1 vssd1 vccd1 vccd1 cell2.LE_1A.config_data\[16\]
+ sky130_fd_sc_hd__dfrtp_1
XANTENNA__11354__X net187 vssd1 vssd1 vccd1 vccd1 sky130_fd_sc_hd__diode_2
XANTENNA__07352__A1 net355 vssd1 vssd1 vccd1 vccd1 sky130_fd_sc_hd__diode_2
X_12844_ cell2.SB0.route_sel\[86\] cell2.SB0.route_sel\[85\] net797 vssd1 vssd1 vccd1
+ vccd1 _01273_ sky130_fd_sc_hd__mux2_1
XFILLER_46_399 vssd1 vssd1 vccd1 vccd1 sky130_fd_sc_hd__fill_1
X_12775_ cell2.SB0.route_sel\[17\] cell2.SB0.route_sel\[16\] net816 vssd1 vssd1 vccd1
+ vccd1 _01204_ sky130_fd_sc_hd__mux2_1
XANTENNA__07104__A1 net301 vssd1 vssd1 vccd1 vccd1 sky130_fd_sc_hd__diode_2
XPHY_EDGE_ROW_14_Left_157 vssd1 vssd1 vccd1 vccd1 sky130_fd_sc_hd__decap_3
X_11726_ net982 net548 _06375_ vssd1 vssd1 vccd1 vccd1 _00164_ sky130_fd_sc_hd__a21bo_1
XFILLER_42_561 vssd1 vssd1 vccd1 vccd1 sky130_fd_sc_hd__fill_1
XFILLER_9_57 vccd1 vssd1 vccd1 vssd1 sky130_ef_sc_hd__decap_40_12
XANTENNA__07655__A2 net353 vssd1 vssd1 vccd1 vccd1 sky130_fd_sc_hd__diode_2
XANTENNA__14411__SET_B net753 vssd1 vssd1 vccd1 vccd1 sky130_fd_sc_hd__diode_2
XFILLER_128_611 vssd1 vssd1 vccd1 vccd1 sky130_fd_sc_hd__fill_1
X_14445_ clknet_leaf_67_clk net1398 net734 vssd1 vssd1 vccd1 vccd1 cell3.LEI0.config_data\[10\]
+ sky130_fd_sc_hd__dfrtp_1
XFILLER_80_83 vssd1 vssd1 vccd1 vccd1 sky130_fd_sc_hd__fill_1
X_11657_ cell0.CB_1.config_dataB\[3\] cell0.CB_1.config_dataB\[2\] net789 vssd1 vssd1
+ vccd1 vccd1 _00098_ sky130_fd_sc_hd__mux2_1
XFILLER_127_121 vssd1 vssd1 vccd1 vccd1 sky130_fd_sc_hd__fill_1
X_14376_ clknet_leaf_65_clk _01348_ net744 vssd1 vssd1 vccd1 vccd1 cell3.LE_1A.config_data\[7\]
+ sky130_fd_sc_hd__dfrtp_1
X_10608_ net398 net396 vssd1 vssd1 vccd1 vccd1 _05566_ sky130_fd_sc_hd__or2_1
XFILLER_80_94 vssd1 vssd1 vccd1 vccd1 sky130_fd_sc_hd__fill_1
X_11588_ cell0.CB_1.config_dataA\[9\] cell0.CB_1.config_dataA\[8\] net788 vssd1 vssd1
+ vccd1 vccd1 _00029_ sky130_fd_sc_hd__mux2_1
XTAP_TAPCELL_ROW_12_486 vssd1 vccd1 sky130_fd_sc_hd__tapvpwrvgnd_1
X_10539_ net8 net9 net10 net11 net395 net394 vssd1 vssd1 vccd1 vccd1 _05497_ sky130_fd_sc_hd__mux4_1
X_13327_ clknet_leaf_86_clk _00299_ net691 vssd1 vssd1 vccd1 vccd1 cell1.CB_0.config_dataB\[18\]
+ sky130_fd_sc_hd__dfstp_1
XTAP_TAPCELL_ROW_77_1469 vssd1 vccd1 sky130_fd_sc_hd__tapvpwrvgnd_1
XTAP_TAPCELL_ROW_77_1458 vssd1 vccd1 sky130_fd_sc_hd__tapvpwrvgnd_1
X_13258_ clknet_leaf_122_clk _00230_ net587 vssd1 vssd1 vccd1 vccd1 cell0.LEI0.config_data\[43\]
+ sky130_fd_sc_hd__dfrtp_1
XPHY_EDGE_ROW_23_Left_166 vssd1 vssd1 vccd1 vccd1 sky130_fd_sc_hd__decap_3
XANTENNA__10175__A0 net61 vssd1 vssd1 vccd1 vccd1 sky130_fd_sc_hd__diode_2
XTAP_TAPCELL_ROW_90_1658 vssd1 vccd1 sky130_fd_sc_hd__tapvpwrvgnd_1
X_12209_ cell2.CB_1.config_dataA\[22\] cell2.CB_1.config_dataA\[21\] net836 vssd1
+ vssd1 vccd1 vccd1 _00642_ sky130_fd_sc_hd__mux2_1
X_13189_ clknet_leaf_13_clk _00161_ net597 vssd1 vssd1 vccd1 vccd1 cell0.LE_0B.reset_val
+ sky130_fd_sc_hd__dfrtp_1
XFILLER_57_609 vssd1 vssd1 vccd1 vccd1 sky130_fd_sc_hd__fill_1
XANTENNA__07455__A net330 vssd1 vssd1 vccd1 vccd1 sky130_fd_sc_hd__diode_2
XANTENNA__10190__A3 net35 vssd1 vssd1 vccd1 vccd1 sky130_fd_sc_hd__diode_2
XFILLER_97_789 vssd1 vssd1 vccd1 vccd1 sky130_fd_sc_hd__fill_1
XANTENNA__07174__B _02234_ vssd1 vssd1 vccd1 vccd1 sky130_fd_sc_hd__diode_2
X_07750_ cell0.SB0.route_sel\[39\] cell0.SB0.route_sel\[38\] net123 vssd1 vssd1 vccd1
+ vccd1 _02796_ sky130_fd_sc_hd__a21boi_1
X_06701_ cell2.CB_0.config_dataA\[14\] vssd1 vssd1 vccd1 vccd1 _01771_ sky130_fd_sc_hd__inv_2
XANTENNA__08985__S _03968_ vssd1 vssd1 vccd1 vccd1 sky130_fd_sc_hd__diode_2
XANTENNA__08838__X _03870_ vssd1 vssd1 vccd1 vccd1 sky130_fd_sc_hd__diode_2
XANTENNA__11264__X net194 vssd1 vssd1 vccd1 vccd1 sky130_fd_sc_hd__diode_2
X_07681_ _02728_ net334 _02727_ vssd1 vssd1 vccd1 vccd1 _02729_ sky130_fd_sc_hd__mux2_1
XTAP_TAPCELL_ROW_121_2124 vssd1 vccd1 sky130_fd_sc_hd__tapvpwrvgnd_1
X_09420_ cell2.SB0.route_sel\[44\] cell2.SB0.route_sel\[45\] vssd1 vssd1 vccd1 vccd1
+ _04443_ sky130_fd_sc_hd__nor2_1
X_06632_ cell3.SB0.route_sel\[36\] vssd1 vssd1 vccd1 vccd1 _01702_ sky130_fd_sc_hd__inv_2
XFILLER_80_634 vssd1 vssd1 vccd1 vccd1 sky130_fd_sc_hd__fill_2
XPHY_EDGE_ROW_32_Left_175 vssd1 vssd1 vccd1 vccd1 sky130_fd_sc_hd__decap_3
X_06563_ cell2.SB0.route_sel\[85\] vssd1 vssd1 vccd1 vccd1 _01633_ sky130_fd_sc_hd__inv_2
X_09351_ _03891_ _03892_ _03893_ _02820_ _02816_ vssd1 vssd1 vccd1 vccd1 _04375_ sky130_fd_sc_hd__a311o_1
XFILLER_100_27 vssd1 vssd1 vccd1 vccd1 sky130_fd_sc_hd__fill_1
X_09282_ net363 net362 _04307_ vssd1 vssd1 vccd1 vccd1 _04308_ sky130_fd_sc_hd__or3_1
X_08302_ _03329_ _03330_ _03338_ _03339_ vssd1 vssd1 vccd1 vccd1 _03340_ sky130_fd_sc_hd__o22a_1
X_06494_ cell2.SB0.route_sel\[0\] vssd1 vssd1 vccd1 vccd1 _01564_ sky130_fd_sc_hd__inv_2
X_08233_ _02350_ _03268_ _03271_ _03272_ vssd1 vssd1 vccd1 vccd1 _03273_ sky130_fd_sc_hd__o211a_1
XTAP_TAPCELL_ROW_119_2086 vssd1 vccd1 sky130_fd_sc_hd__tapvpwrvgnd_1
XANTENNA__08225__S _03231_ vssd1 vssd1 vccd1 vccd1 sky130_fd_sc_hd__diode_2
X_08164_ _02807_ _03201_ _03203_ _02846_ _01499_ vssd1 vssd1 vccd1 vccd1 _03204_ sky130_fd_sc_hd__a221o_1
XFILLER_20_299 vssd1 vssd1 vccd1 vccd1 sky130_fd_sc_hd__fill_8
XTAP_TAPCELL_ROW_31_773 vssd1 vccd1 sky130_fd_sc_hd__tapvpwrvgnd_1
XTAP_TAPCELL_ROW_119_2097 vssd1 vccd1 sky130_fd_sc_hd__tapvpwrvgnd_1
X_07115_ cell2.CB_0.config_dataB\[24\] cell2.CB_0.config_dataB\[21\] cell2.CB_0.config_dataB\[20\]
+ vssd1 vssd1 vccd1 vccd1 _02178_ sky130_fd_sc_hd__or3b_2
X_08095_ _03132_ _03135_ _03136_ _01561_ vssd1 vssd1 vccd1 vccd1 _03137_ sky130_fd_sc_hd__a22o_1
XPHY_EDGE_ROW_41_Left_184 vssd1 vssd1 vccd1 vccd1 sky130_fd_sc_hd__decap_3
Xclkload70 clknet_leaf_105_clk vssd1 vssd1 vccd1 vccd1 clkload70/Y sky130_fd_sc_hd__clkinv_1
X_07046_ cell0.CB_1.config_dataB\[24\] cell0.CB_1.config_dataB\[21\] cell0.CB_1.config_dataB\[20\]
+ vssd1 vssd1 vccd1 vccd1 _02110_ sky130_fd_sc_hd__or3b_2
XTAP_TAPCELL_ROW_132_2286 vssd1 vccd1 sky130_fd_sc_hd__tapvpwrvgnd_1
Xclkload81 clknet_leaf_84_clk vssd1 vssd1 vccd1 vccd1 clkload81/Y sky130_fd_sc_hd__clkinv_8
Xclkload92 clknet_leaf_85_clk vssd1 vssd1 vccd1 vccd1 clkload92/Y sky130_fd_sc_hd__inv_12
XFILLER_125_57 vccd1 vssd1 vccd1 vssd1 sky130_ef_sc_hd__decap_40_12
XFILLER_87_222 vssd1 vssd1 vccd1 vccd1 sky130_fd_sc_hd__fill_2
XANTENNA__09571__A2 _04587_ vssd1 vssd1 vccd1 vccd1 sky130_fd_sc_hd__diode_2
X_08997_ bus3_1\[6\] bus3_1\[7\] net483 vssd1 vssd1 vccd1 vccd1 _04027_ sky130_fd_sc_hd__mux2_1
X_07948_ _02887_ _02983_ _02984_ _02890_ _01575_ vssd1 vssd1 vccd1 vccd1 _02992_ sky130_fd_sc_hd__a221o_1
XANTENNA__07652__X bus1_0\[1\] vssd1 vssd1 vccd1 vccd1 sky130_fd_sc_hd__diode_2
XFILLER_18_22 vssd1 vssd1 vccd1 vccd1 sky130_fd_sc_hd__fill_4
XANTENNA_fanout931_A net932 vssd1 vssd1 vccd1 vccd1 sky130_fd_sc_hd__diode_2
X_07879_ net521 _02897_ vssd1 vssd1 vccd1 vccd1 _02923_ sky130_fd_sc_hd__nand2_1
XPHY_EDGE_ROW_50_Left_193 vssd1 vssd1 vccd1 vccd1 sky130_fd_sc_hd__decap_3
X_10890_ cell3.LE_1B.config_data\[16\] _05843_ _05844_ net352 vssd1 vssd1 vccd1 vccd1
+ cell3.CB_1.le_outB sky130_fd_sc_hd__o211a_1
X_09618_ cell3.SB0.route_sel\[96\] cell3.SB0.route_sel\[97\] vssd1 vssd1 vccd1 vccd1
+ _04634_ sky130_fd_sc_hd__nand2_1
XANTENNA__09874__A3 bus3_2\[11\] vssd1 vssd1 vccd1 vccd1 sky130_fd_sc_hd__diode_2
XTAP_TAPCELL_ROW_48_1026 vssd1 vccd1 sky130_fd_sc_hd__tapvpwrvgnd_1
XTAP_TAPCELL_ROW_39_895 vssd1 vccd1 sky130_fd_sc_hd__tapvpwrvgnd_1
X_09549_ net293 _04567_ _04565_ vssd1 vssd1 vccd1 vccd1 _04568_ sky130_fd_sc_hd__mux2_1
XANTENNA__09087__A1 net327 vssd1 vssd1 vccd1 vccd1 sky130_fd_sc_hd__diode_2
XFILLER_34_10 vccd1 vssd1 vccd1 vssd1 sky130_ef_sc_hd__decap_40_12
XFILLER_12_701 vssd1 vssd1 vccd1 vccd1 sky130_fd_sc_hd__fill_8
XFILLER_140_3 vccd1 vssd1 vccd1 vssd1 sky130_ef_sc_hd__decap_40_12
X_12560_ cell3.SB0.route_sel\[25\] cell3.SB0.route_sel\[24\] net917 vssd1 vssd1 vccd1
+ vccd1 _00989_ sky130_fd_sc_hd__mux2_1
XTAP_TAPCELL_ROW_61_1226 vssd1 vccd1 sky130_fd_sc_hd__tapvpwrvgnd_1
XFILLER_34_65 vccd1 vssd1 vccd1 vssd1 sky130_ef_sc_hd__decap_40_12
XFILLER_34_98 vssd1 vssd1 vccd1 vccd1 sky130_fd_sc_hd__fill_2
X_12491_ cell2.LEI0.config_data\[5\] net1428 net841 vssd1 vssd1 vccd1 vccd1 _00920_
+ sky130_fd_sc_hd__mux2_1
X_11511_ _01620_ cell2.SB0.route_sel\[66\] vssd1 vssd1 vccd1 vccd1 _06341_ sky130_fd_sc_hd__nand2_1
XFILLER_7_204 vssd1 vssd1 vccd1 vccd1 sky130_fd_sc_hd__fill_4
XFILLER_11_244 vssd1 vssd1 vccd1 vccd1 sky130_fd_sc_hd__fill_2
XFILLER_137_441 vssd1 vssd1 vccd1 vccd1 sky130_fd_sc_hd__fill_1
X_14230_ clknet_leaf_16_clk _01202_ net624 vssd1 vssd1 vccd1 vccd1 cell2.SB0.route_sel\[15\]
+ sky130_fd_sc_hd__dfstp_1
X_11442_ _01503_ cell1.SB0.route_sel\[11\] vssd1 vssd1 vccd1 vccd1 _06295_ sky130_fd_sc_hd__nand2_1
XFILLER_11_277 vssd1 vssd1 vccd1 vccd1 sky130_fd_sc_hd__fill_1
XFILLER_109_143 vssd1 vssd1 vccd1 vccd1 sky130_fd_sc_hd__fill_1
X_14161_ clknet_leaf_72_clk _01133_ net729 vssd1 vssd1 vccd1 vccd1 cell3.CB_1.config_dataA\[21\]
+ sky130_fd_sc_hd__dfstp_1
X_11373_ cell0.SB0.route_sel\[41\] cell0.SB0.route_sel\[40\] vssd1 vssd1 vccd1 vccd1
+ _06249_ sky130_fd_sc_hd__nand2b_1
XANTENNA_input60_A CBnorth_in[5] vssd1 vssd1 vccd1 vccd1 sky130_fd_sc_hd__diode_2
X_10324_ net434 _05321_ _05322_ vssd1 vssd1 vccd1 vccd1 _05323_ sky130_fd_sc_hd__a21oi_1
X_13112_ clknet_leaf_5_clk _00084_ net567 vssd1 vssd1 vccd1 vccd1 cell0.CB_0.config_dataA\[14\]
+ sky130_fd_sc_hd__dfstp_1
X_14092_ clknet_leaf_76_clk _01064_ net712 vssd1 vssd1 vccd1 vccd1 cell3.SB0.route_sel\[100\]
+ sky130_fd_sc_hd__dfstp_2
XTAP_TAPCELL_ROW_59_1199 vssd1 vccd1 sky130_fd_sc_hd__tapvpwrvgnd_1
XTAP_TAPCELL_ROW_59_1188 vssd1 vccd1 sky130_fd_sc_hd__tapvpwrvgnd_1
X_10255_ _02106_ _05096_ _05236_ _05235_ _05093_ vssd1 vssd1 vccd1 vccd1 _05256_ sky130_fd_sc_hd__a32o_1
XFILLER_78_211 vssd1 vssd1 vccd1 vccd1 sky130_fd_sc_hd__fill_1
X_13043_ clknet_leaf_119_clk net1319 net594 vssd1 vssd1 vccd1 vccd1 cell0.LE_1B.config_data\[15\]
+ sky130_fd_sc_hd__dfrtp_1
X_10186_ net421 _05088_ _05186_ net420 vssd1 vssd1 vccd1 vccd1 _05187_ sky130_fd_sc_hd__o211a_1
XFILLER_59_84 vssd1 vssd1 vccd1 vccd1 sky130_fd_sc_hd__fill_1
XFILLER_120_363 vssd1 vssd1 vccd1 vccd1 sky130_fd_sc_hd__fill_1
XTAP_TAPCELL_ROW_72_1388 vssd1 vccd1 sky130_fd_sc_hd__tapvpwrvgnd_1
XANTENNA_output147_A net147 vssd1 vssd1 vccd1 vccd1 sky130_fd_sc_hd__diode_2
Xfanout290 net291 vssd1 vssd1 vccd1 vccd1 net290 sky130_fd_sc_hd__clkbuf_2
XFILLER_93_225 vssd1 vssd1 vccd1 vccd1 sky130_fd_sc_hd__fill_4
XFILLER_19_300 vssd1 vssd1 vccd1 vccd1 sky130_fd_sc_hd__fill_1
X_13945_ clknet_leaf_33_clk _00917_ net635 vssd1 vssd1 vccd1 vccd1 cell2.LEI0.config_data\[2\]
+ sky130_fd_sc_hd__dfrtp_1
XANTENNA__07325__A1 bus3_2\[12\] vssd1 vssd1 vccd1 vccd1 sky130_fd_sc_hd__diode_2
X_13876_ clknet_1_0__leaf_cell2.LE_1B.sel_clk _00848_ net752 vssd1 vssd1 vccd1 vccd1
+ cell2.LE_1B.dff0_out sky130_fd_sc_hd__dfrtp_1
XANTENNA_clkload6_A clknet_4_6_0_clk vssd1 vssd1 vccd1 vccd1 sky130_fd_sc_hd__diode_2
XFILLER_19_388 vssd1 vssd1 vccd1 vccd1 sky130_fd_sc_hd__fill_4
X_12827_ cell2.SB0.route_sel\[69\] cell2.SB0.route_sel\[68\] net815 vssd1 vssd1 vccd1
+ vccd1 _01256_ sky130_fd_sc_hd__mux2_1
XANTENNA__09078__A1 bus3_1\[7\] vssd1 vssd1 vccd1 vccd1 sky130_fd_sc_hd__diode_2
XTAP_TAPCELL_ROW_17_556 vssd1 vccd1 sky130_fd_sc_hd__tapvpwrvgnd_1
XTAP_TAPCELL_ROW_17_567 vssd1 vccd1 sky130_fd_sc_hd__tapvpwrvgnd_1
X_12758_ cell2.SB0.route_sel\[0\] cell2.CB_1.config_dataB\[24\] net830 vssd1 vssd1
+ vccd1 vccd1 _01187_ sky130_fd_sc_hd__mux2_1
X_12689_ net394 net395 net937 vssd1 vssd1 vccd1 vccd1 _01118_ sky130_fd_sc_hd__mux2_1
X_11709_ net1240 cell0.LE_0B.config_data\[4\] net804 vssd1 vssd1 vccd1 vccd1 _00148_
+ sky130_fd_sc_hd__mux2_1
X_14428_ clknet_leaf_55_clk net1307 net718 vssd1 vssd1 vccd1 vccd1 cell3.LE_0A.config_data\[15\]
+ sky130_fd_sc_hd__dfrtp_1
XANTENNA__08589__A0 net1 vssd1 vssd1 vccd1 vccd1 sky130_fd_sc_hd__diode_2
X_14359_ clknet_leaf_72_clk _01331_ net733 vssd1 vssd1 vccd1 vccd1 cell3.CB_1.config_dataB\[16\]
+ sky130_fd_sc_hd__dfstp_1
X_08920_ _03871_ _03940_ _03941_ _03868_ cell1.CB_0.config_dataA\[12\] vssd1 vssd1
+ vccd1 vccd1 _03952_ sky130_fd_sc_hd__a221o_1
XANTENNA__07013__B1 net113 vssd1 vssd1 vccd1 vccd1 sky130_fd_sc_hd__diode_2
XANTENNA__08356__A3 _02040_ vssd1 vssd1 vccd1 vccd1 sky130_fd_sc_hd__diode_2
X_08851_ _01520_ cell1.SB0.route_sel\[55\] vssd1 vssd1 vccd1 vccd1 _03883_ sky130_fd_sc_hd__nand2_1
X_07802_ _02843_ _02844_ _02845_ _02842_ _02823_ vssd1 vssd1 vccd1 vccd1 _02847_ sky130_fd_sc_hd__a311o_2
X_08782_ cell1.SB0.route_sel\[119\] _01549_ vssd1 vssd1 vccd1 vccd1 _03814_ sky130_fd_sc_hd__nand2_1
X_07733_ cell1.SB0.route_sel\[24\] cell1.SB0.route_sel\[25\] _02772_ _02779_ net864
+ vssd1 vssd1 vccd1 vccd1 _02780_ sky130_fd_sc_hd__a311oi_4
X_07664_ _01866_ _02623_ vssd1 vssd1 vccd1 vccd1 _02712_ sky130_fd_sc_hd__nand2_1
XANTENNA__10871__A1 net291 vssd1 vssd1 vccd1 vccd1 sky130_fd_sc_hd__diode_2
XFILLER_111_15 vccd1 vssd1 vccd1 vssd1 sky130_ef_sc_hd__decap_40_12
X_09403_ _01906_ _02164_ vssd1 vssd1 vccd1 vccd1 _04426_ sky130_fd_sc_hd__or2_1
X_06615_ cell3.SB0.route_sel\[9\] vssd1 vssd1 vccd1 vccd1 _01685_ sky130_fd_sc_hd__inv_2
XFILLER_41_807 vssd1 vssd1 vccd1 vccd1 sky130_fd_sc_hd__fill_1
XTAP_TAPCELL_ROW_36_843 vssd1 vccd1 sky130_fd_sc_hd__tapvpwrvgnd_1
XTAP_TAPCELL_ROW_36_854 vssd1 vccd1 sky130_fd_sc_hd__tapvpwrvgnd_1
XFILLER_111_59 vssd1 vssd1 vccd1 vccd1 sky130_fd_sc_hd__fill_4
XTAP_TAPCELL_ROW_101_1816 vssd1 vccd1 sky130_fd_sc_hd__tapvpwrvgnd_1
XANTENNA__09069__A1 _03830_ vssd1 vssd1 vccd1 vccd1 sky130_fd_sc_hd__diode_2
XANTENNA__09069__B2 _03826_ vssd1 vssd1 vccd1 vccd1 sky130_fd_sc_hd__diode_2
XANTENNA_fanout345_A net346 vssd1 vssd1 vccd1 vccd1 sky130_fd_sc_hd__diode_2
X_07595_ cell1.SB0.route_sel\[2\] cell1.SB0.route_sel\[3\] _02637_ _02638_ _02644_
+ vssd1 vssd1 vccd1 vccd1 _02645_ sky130_fd_sc_hd__a41o_1
XTAP_TAPCELL_ROW_101_1827 vssd1 vccd1 sky130_fd_sc_hd__tapvpwrvgnd_1
X_09334_ net363 net362 _04358_ vssd1 vssd1 vccd1 vccd1 _04359_ sky130_fd_sc_hd__or3b_1
X_06546_ cell2.SB0.route_sel\[59\] vssd1 vssd1 vccd1 vccd1 _01616_ sky130_fd_sc_hd__inv_2
XANTENNA__09399__X _04422_ vssd1 vssd1 vccd1 vccd1 sky130_fd_sc_hd__diode_2
XFILLER_139_739 vccd1 vssd1 vccd1 vssd1 sky130_ef_sc_hd__decap_40_12
X_09265_ _01922_ _04189_ vssd1 vssd1 vccd1 vccd1 _04291_ sky130_fd_sc_hd__nor2_1
XANTENNA__10623__A1 _05478_ vssd1 vssd1 vccd1 vccd1 sky130_fd_sc_hd__diode_2
X_06477_ cell1.SB0.route_sel\[114\] vssd1 vssd1 vccd1 vccd1 _01547_ sky130_fd_sc_hd__inv_2
XANTENNA__11441__Y net205 vssd1 vssd1 vccd1 vccd1 sky130_fd_sc_hd__diode_2
XANTENNA_clkbuf_4_0_0_clk_X clknet_4_0_0_clk vssd1 vssd1 vccd1 vccd1 sky130_fd_sc_hd__diode_2
XTAP_TAPCELL_ROW_134_2315 vssd1 vccd1 sky130_fd_sc_hd__tapvpwrvgnd_1
X_09196_ net935 _04223_ vssd1 vssd1 vccd1 vccd1 _04224_ sky130_fd_sc_hd__nor2_1
X_08216_ bus1_0\[2\] bus1_0\[3\] net540 vssd1 vssd1 vccd1 vccd1 _03256_ sky130_fd_sc_hd__mux2_1
X_08147_ cell0.CB_1.config_dataA\[3\] cell0.CB_1.config_dataA\[2\] _03186_ vssd1 vssd1
+ vccd1 vccd1 _03187_ sky130_fd_sc_hd__o21ai_1
XANTENNA_fanout881_A net883 vssd1 vssd1 vccd1 vccd1 sky130_fd_sc_hd__diode_2
X_08078_ cell0.LEI0.config_data\[29\] _03118_ _03119_ vssd1 vssd1 vccd1 vccd1 _03120_
+ sky130_fd_sc_hd__o21a_1
XANTENNA__07647__X _02696_ vssd1 vssd1 vccd1 vccd1 sky130_fd_sc_hd__diode_2
XANTENNA__10139__B1 _05139_ vssd1 vssd1 vccd1 vccd1 sky130_fd_sc_hd__diode_2
X_07029_ cell2.CB_0.config_dataB\[24\] cell2.CB_0.config_dataB\[21\] cell2.CB_0.config_dataB\[20\]
+ vssd1 vssd1 vccd1 vccd1 _02094_ sky130_fd_sc_hd__nor3_1
X_10040_ bus3_2\[12\] bus3_2\[14\] bus3_2\[13\] bus3_2\[15\] net399 net400 vssd1 vssd1
+ vccd1 vccd1 _05044_ sky130_fd_sc_hd__mux4_1
XFILLER_96_49 vssd1 vssd1 vccd1 vccd1 sky130_fd_sc_hd__fill_2
XFILLER_96_27 vssd1 vssd1 vccd1 vccd1 sky130_fd_sc_hd__fill_1
XANTENNA__10233__B _05148_ vssd1 vssd1 vccd1 vccd1 sky130_fd_sc_hd__diode_2
XTAP_TAPCELL_ROW_112_1989 vssd1 vccd1 sky130_fd_sc_hd__tapvpwrvgnd_1
Xhold21 cell2.LE_1A.config_data\[10\] vssd1 vssd1 vccd1 vccd1 net980 sky130_fd_sc_hd__dlygate4sd3_1
Xhold10 cell1.LE_1A.dff0_out vssd1 vssd1 vccd1 vccd1 net969 sky130_fd_sc_hd__dlygate4sd3_1
Xhold32 cell1.LE_1A.config_data\[13\] vssd1 vssd1 vccd1 vccd1 net991 sky130_fd_sc_hd__dlygate4sd3_1
XANTENNA__08752__A0 net1 vssd1 vssd1 vccd1 vccd1 sky130_fd_sc_hd__diode_2
Xhold65 cell3.LE_0B.config_data\[3\] vssd1 vssd1 vccd1 vccd1 net1024 sky130_fd_sc_hd__dlygate4sd3_1
Xhold54 cell3.LE_0B.config_data\[4\] vssd1 vssd1 vccd1 vccd1 net1013 sky130_fd_sc_hd__dlygate4sd3_1
Xhold43 _00488_ vssd1 vssd1 vccd1 vccd1 net1002 sky130_fd_sc_hd__dlygate4sd3_1
XANTENNA_fanout934_X net934 vssd1 vssd1 vccd1 vccd1 sky130_fd_sc_hd__diode_2
Xhold87 cell2.LE_1A.config_data\[7\] vssd1 vssd1 vccd1 vccd1 net1046 sky130_fd_sc_hd__dlygate4sd3_1
Xhold98 cell2.LE_0A.config_data\[3\] vssd1 vssd1 vccd1 vccd1 net1057 sky130_fd_sc_hd__dlygate4sd3_1
Xhold76 cell1.LEI0.config_data\[14\] vssd1 vssd1 vccd1 vccd1 net1035 sky130_fd_sc_hd__dlygate4sd3_1
X_11991_ cell0.SB0.route_sel\[97\] cell0.SB0.route_sel\[96\] net766 vssd1 vssd1 vccd1
+ vccd1 _00428_ sky130_fd_sc_hd__mux2_1
XANTENNA__11103__A2 _05871_ vssd1 vssd1 vccd1 vccd1 sky130_fd_sc_hd__diode_2
X_10942_ cell3.SB0.route_sel\[45\] cell3.SB0.route_sel\[44\] vssd1 vssd1 vccd1 vccd1
+ _05896_ sky130_fd_sc_hd__and2b_1
XFILLER_84_781 vssd1 vssd1 vccd1 vccd1 sky130_fd_sc_hd__fill_1
X_13730_ clknet_leaf_105_clk _00702_ net660 vssd1 vssd1 vccd1 vccd1 cell1.SB0.route_sel\[7\]
+ sky130_fd_sc_hd__dfstp_1
XFILLER_28_152 vssd1 vssd1 vccd1 vccd1 sky130_fd_sc_hd__fill_1
XFILLER_29_686 vssd1 vssd1 vccd1 vccd1 sky130_fd_sc_hd__fill_1
XFILLER_90_239 vssd1 vssd1 vccd1 vccd1 sky130_fd_sc_hd__fill_1
X_10873_ cell3.LEI0.config_data\[46\] _05828_ _05826_ cell3.CB_0.config_data_inA vssd1
+ vssd1 vccd1 vccd1 _05829_ sky130_fd_sc_hd__a211o_1
X_13661_ clknet_leaf_47_clk _00633_ net704 vssd1 vssd1 vccd1 vccd1 cell2.CB_1.config_dataA\[13\]
+ sky130_fd_sc_hd__dfstp_1
Xclkbuf_1_1__f_cell1.LE_0B.sel_clk clknet_0_cell1.LE_0B.sel_clk vssd1 vssd1 vccd1
+ vccd1 clknet_1_1__leaf_cell1.LE_0B.sel_clk sky130_fd_sc_hd__clkbuf_16
X_12612_ cell3.SB0.route_sel\[77\] cell3.SB0.route_sel\[76\] net834 vssd1 vssd1 vccd1
+ vccd1 _01041_ sky130_fd_sc_hd__mux2_1
X_13592_ clknet_leaf_89_clk net1359 net689 vssd1 vssd1 vccd1 vccd1 cell1.LEI0.config_data\[13\]
+ sky130_fd_sc_hd__dfrtp_1
XTAP_TAPCELL_ROW_14_515 vssd1 vccd1 sky130_fd_sc_hd__tapvpwrvgnd_1
XANTENNA__10614__A1 net18 vssd1 vssd1 vccd1 vccd1 sky130_fd_sc_hd__diode_2
X_12543_ cell3.SB0.route_sel\[8\] cell3.SB0.route_sel\[7\] net935 vssd1 vssd1 vccd1
+ vccd1 _00972_ sky130_fd_sc_hd__mux2_1
XANTENNA__07491__B1 bus1_0\[15\] vssd1 vssd1 vccd1 vccd1 sky130_fd_sc_hd__diode_2
X_14213_ clknet_leaf_58_clk _01185_ net723 vssd1 vssd1 vccd1 vccd1 cell3.CB_0.config_dataA\[23\]
+ sky130_fd_sc_hd__dfstp_1
X_12474_ net1198 net1076 net814 vssd1 vssd1 vccd1 vccd1 _00904_ sky130_fd_sc_hd__mux2_1
XANTENNA_clkbuf_leaf_91_clk_A clknet_4_11_0_clk vssd1 vssd1 vccd1 vccd1 sky130_fd_sc_hd__diode_2
XFILLER_125_422 vssd1 vssd1 vccd1 vccd1 sky130_fd_sc_hd__fill_1
XANTENNA_7 _03763_ vssd1 vssd1 vccd1 vccd1 sky130_fd_sc_hd__diode_2
X_11425_ cell0.SB0.route_sel\[109\] _01480_ _01481_ cell0.SB0.route_sel\[106\] _06283_
+ vssd1 vssd1 vccd1 vccd1 _06284_ sky130_fd_sc_hd__a221o_1
XANTENNA_input63_X net63 vssd1 vssd1 vccd1 vccd1 sky130_fd_sc_hd__diode_2
X_11356_ net283 _04709_ _04710_ _06243_ vssd1 vssd1 vccd1 vccd1 net189 sky130_fd_sc_hd__a22o_1
X_14144_ clknet_leaf_68_clk _01116_ net726 vssd1 vssd1 vccd1 vccd1 cell3.CB_1.config_dataA\[4\]
+ sky130_fd_sc_hd__dfstp_2
XFILLER_99_818 vssd1 vssd1 vccd1 vccd1 sky130_fd_sc_hd__fill_1
XTAP_TAPCELL_ROW_74_1417 vssd1 vccd1 sky130_fd_sc_hd__tapvpwrvgnd_1
XFILLER_140_403 vssd1 vssd1 vccd1 vccd1 sky130_fd_sc_hd__fill_1
X_10307_ _01756_ _05304_ _05305_ _05294_ vssd1 vssd1 vccd1 vccd1 _05306_ sky130_fd_sc_hd__o31a_1
X_14075_ clknet_leaf_82_clk _01047_ net672 vssd1 vssd1 vccd1 vccd1 cell3.SB0.route_sel\[83\]
+ sky130_fd_sc_hd__dfstp_1
X_11287_ clknet_leaf_39_clk cell2.LE_1A.edge_mode vssd1 vssd1 vccd1 vccd1 cell2.LE_1A.sel_clk
+ sky130_fd_sc_hd__xnor2_2
X_13026_ net1408 cell3.LEI0.config_data\[46\] net948 vssd1 vssd1 vccd1 vccd1 _01454_
+ sky130_fd_sc_hd__mux2_1
XFILLER_3_273 vssd1 vssd1 vccd1 vccd1 sky130_fd_sc_hd__fill_4
X_10238_ net412 _05128_ vssd1 vssd1 vccd1 vccd1 _05239_ sky130_fd_sc_hd__nand2_1
X_10169_ _05136_ _05167_ _05169_ _05166_ vssd1 vssd1 vccd1 vccd1 _05170_ sky130_fd_sc_hd__a211o_1
XFILLER_94_523 vssd1 vssd1 vccd1 vccd1 sky130_fd_sc_hd__fill_1
XANTENNA__07292__X _02350_ vssd1 vssd1 vccd1 vccd1 sky130_fd_sc_hd__diode_2
XANTENNA__10302__A0 net63 vssd1 vssd1 vccd1 vccd1 sky130_fd_sc_hd__diode_2
X_13928_ clknet_leaf_24_clk net1180 net607 vssd1 vssd1 vccd1 vccd1 cell2.LE_0A.config_data\[7\]
+ sky130_fd_sc_hd__dfrtp_1
XFILLER_74_280 vssd1 vssd1 vccd1 vccd1 sky130_fd_sc_hd__fill_1
X_13859_ clknet_leaf_41_clk _00831_ net643 vssd1 vssd1 vccd1 vccd1 cell2.CB_1.config_dataB\[8\]
+ sky130_fd_sc_hd__dfstp_1
XANTENNA_clkbuf_leaf_44_clk_A clknet_4_6_0_clk vssd1 vssd1 vccd1 vccd1 sky130_fd_sc_hd__diode_2
XTAP_TAPCELL_ROW_85_1579 vssd1 vccd1 sky130_fd_sc_hd__tapvpwrvgnd_1
XFILLER_62_475 vssd1 vssd1 vccd1 vccd1 sky130_fd_sc_hd__fill_1
X_06400_ cell0.SB0.route_sel\[75\] vssd1 vssd1 vccd1 vccd1 _01470_ sky130_fd_sc_hd__inv_2
XFILLER_34_155 vssd1 vssd1 vccd1 vccd1 sky130_fd_sc_hd__fill_1
XTAP_TAPCELL_ROW_33_802 vssd1 vccd1 sky130_fd_sc_hd__tapvpwrvgnd_1
XFILLER_50_626 vssd1 vssd1 vccd1 vccd1 sky130_fd_sc_hd__fill_1
XFILLER_22_317 vssd1 vssd1 vccd1 vccd1 sky130_fd_sc_hd__fill_2
X_07380_ _02430_ _02435_ vssd1 vssd1 vccd1 vccd1 _02436_ sky130_fd_sc_hd__nor2_1
XFILLER_15_391 vssd1 vssd1 vccd1 vccd1 sky130_fd_sc_hd__fill_1
X_09050_ net332 cell1.CB_0.le_outB cell1.LEI0.config_data\[3\] vssd1 vssd1 vccd1 vccd1
+ _04080_ sky130_fd_sc_hd__mux2_1
XFILLER_30_361 vssd1 vssd1 vccd1 vccd1 sky130_fd_sc_hd__fill_1
XANTENNA_clkbuf_leaf_59_clk_A clknet_4_15_0_clk vssd1 vssd1 vccd1 vccd1 sky130_fd_sc_hd__diode_2
X_08001_ net530 _02897_ vssd1 vssd1 vccd1 vccd1 _03043_ sky130_fd_sc_hd__nand2_1
XFILLER_129_783 vssd1 vssd1 vccd1 vccd1 sky130_fd_sc_hd__fill_1
XFILLER_128_282 vssd1 vssd1 vccd1 vccd1 sky130_fd_sc_hd__fill_1
XTAP_TAPCELL_ROW_116_2045 vssd1 vccd1 sky130_fd_sc_hd__tapvpwrvgnd_1
XANTENNA__08026__A2 bus2_0\[14\] vssd1 vssd1 vccd1 vccd1 sky130_fd_sc_hd__diode_2
Xhold502 _00552_ vssd1 vssd1 vccd1 vccd1 net1461 sky130_fd_sc_hd__dlygate4sd3_1
XANTENNA_clkbuf_leaf_102_clk_A clknet_4_10_0_clk vssd1 vssd1 vccd1 vccd1 sky130_fd_sc_hd__diode_2
Xhold513 cell3.LEI0.config_data\[16\] vssd1 vssd1 vccd1 vccd1 net1472 sky130_fd_sc_hd__dlygate4sd3_1
Xhold535 cell1.LEI0.config_data\[0\] vssd1 vssd1 vccd1 vccd1 net1494 sky130_fd_sc_hd__dlygate4sd3_1
Xhold524 cell1.LEI0.config_data\[27\] vssd1 vssd1 vccd1 vccd1 net1483 sky130_fd_sc_hd__dlygate4sd3_1
XFILLER_131_414 vssd1 vssd1 vccd1 vccd1 sky130_fd_sc_hd__fill_1
Xhold557 cell2.LEI0.config_data\[3\] vssd1 vssd1 vccd1 vccd1 net1516 sky130_fd_sc_hd__dlygate4sd3_1
Xhold546 cell3.LE_1A.reset_val vssd1 vssd1 vccd1 vccd1 net1505 sky130_fd_sc_hd__dlygate4sd3_1
Xhold579 cell2.LEI0.config_data\[34\] vssd1 vssd1 vccd1 vccd1 net1538 sky130_fd_sc_hd__dlygate4sd3_1
X_09952_ _04952_ _04955_ vssd1 vssd1 vccd1 vccd1 _04956_ sky130_fd_sc_hd__nand2_4
XFILLER_104_628 vssd1 vssd1 vccd1 vccd1 sky130_fd_sc_hd__fill_1
Xmax_cap276 _04273_ vssd1 vssd1 vccd1 vccd1 net276 sky130_fd_sc_hd__clkbuf_2
Xhold568 cell0.LE_0B.reset_val vssd1 vssd1 vccd1 vccd1 net1527 sky130_fd_sc_hd__dlygate4sd3_1
Xmax_cap265 _02716_ vssd1 vssd1 vccd1 vccd1 net265 sky130_fd_sc_hd__clkbuf_2
X_08903_ cell1.CB_0.config_dataA\[4\] _03905_ _03923_ _03934_ vssd1 vssd1 vccd1 vccd1
+ _03935_ sky130_fd_sc_hd__a31o_1
X_09883_ net438 _04298_ _04888_ cell2.CB_1.config_dataA\[16\] vssd1 vssd1 vccd1 vccd1
+ _04889_ sky130_fd_sc_hd__o211a_1
XANTENNA_clkbuf_leaf_117_clk_A clknet_4_9_0_clk vssd1 vssd1 vccd1 vccd1 sky130_fd_sc_hd__diode_2
XFILLER_57_225 vssd1 vssd1 vccd1 vccd1 sky130_fd_sc_hd__fill_1
X_08834_ cell1.SB0.route_sel\[2\] cell1.SB0.route_sel\[3\] cell1.SB0.route_sel\[5\]
+ _01497_ _03865_ vssd1 vssd1 vccd1 vccd1 _03866_ sky130_fd_sc_hd__o221a_1
X_08765_ cell1.CB_0.config_data_inA _03798_ vssd1 vssd1 vccd1 vccd1 _03799_ sky130_fd_sc_hd__and2b_1
XFILLER_122_25 vssd1 vssd1 vccd1 vccd1 sky130_fd_sc_hd__fill_2
XANTENNA__11097__A1 _05856_ vssd1 vssd1 vccd1 vccd1 sky130_fd_sc_hd__diode_2
XFILLER_72_206 vssd1 vssd1 vccd1 vccd1 sky130_fd_sc_hd__fill_1
XANTENNA__07362__B net354 vssd1 vssd1 vccd1 vccd1 sky130_fd_sc_hd__diode_2
XANTENNA_fanout462_A cell1.CB_1.config_dataB\[0\] vssd1 vssd1 vccd1 vccd1 sky130_fd_sc_hd__diode_2
X_07716_ cell1.SB0.route_sel\[29\] cell1.SB0.route_sel\[28\] vssd1 vssd1 vccd1 vccd1
+ _02763_ sky130_fd_sc_hd__nand2_1
XANTENNA__08458__B _03493_ vssd1 vssd1 vccd1 vccd1 sky130_fd_sc_hd__diode_2
XANTENNA__11097__B2 _05861_ vssd1 vssd1 vccd1 vccd1 sky130_fd_sc_hd__diode_2
XFILLER_82_29 vssd1 vssd1 vccd1 vccd1 sky130_fd_sc_hd__fill_4
X_08696_ _03719_ _03720_ _03728_ _03729_ vssd1 vssd1 vccd1 vccd1 _03730_ sky130_fd_sc_hd__o22a_1
XANTENNA_fanout727_A net749 vssd1 vssd1 vccd1 vccd1 sky130_fd_sc_hd__diode_2
XANTENNA__10844__A1 net22 vssd1 vssd1 vccd1 vccd1 sky130_fd_sc_hd__diode_2
X_07647_ net330 _02695_ _02692_ vssd1 vssd1 vccd1 vccd1 _02696_ sky130_fd_sc_hd__mux2_1
XFILLER_41_615 vssd1 vssd1 vccd1 vccd1 sky130_fd_sc_hd__fill_1
XTAP_TAPCELL_ROW_0_287 vssd1 vccd1 sky130_fd_sc_hd__tapvpwrvgnd_1
X_07578_ _02621_ _02625_ _02626_ vssd1 vssd1 vccd1 vccd1 _02628_ sky130_fd_sc_hd__or3_1
XTAP_TAPCELL_ROW_0_298 vssd1 vccd1 sky130_fd_sc_hd__tapvpwrvgnd_1
XANTENNA__08474__A _03509_ vssd1 vssd1 vccd1 vccd1 sky130_fd_sc_hd__diode_2
XFILLER_25_177 vssd1 vssd1 vccd1 vccd1 sky130_fd_sc_hd__fill_2
X_09317_ net306 _04339_ _04341_ vssd1 vssd1 vccd1 vccd1 _04342_ sky130_fd_sc_hd__o21ba_1
X_06529_ cell2.SB0.route_sel\[35\] vssd1 vssd1 vccd1 vccd1 _01599_ sky130_fd_sc_hd__inv_2
XFILLER_21_361 vssd1 vssd1 vccd1 vccd1 sky130_fd_sc_hd__fill_1
X_09248_ cell3.SB0.route_sel\[8\] _01685_ cell3.SB0.route_sel\[11\] _01687_ _04274_
+ vssd1 vssd1 vccd1 vccd1 _04275_ sky130_fd_sc_hd__a221o_1
X_09179_ cell3.CB_1.config_dataA\[24\] cell3.CB_1.config_dataA\[21\] cell3.CB_1.config_dataA\[20\]
+ vssd1 vssd1 vccd1 vccd1 _04207_ sky130_fd_sc_hd__or3_2
XANTENNA__08017__A2 _02235_ vssd1 vssd1 vccd1 vccd1 sky130_fd_sc_hd__diode_2
XFILLER_31_55 vssd1 vssd1 vccd1 vccd1 sky130_fd_sc_hd__fill_1
Xclkbuf_4_10_0_clk clknet_0_clk vssd1 vssd1 vccd1 vccd1 clknet_4_10_0_clk sky130_fd_sc_hd__clkbuf_8
X_11210_ net382 _06160_ _06161_ vssd1 vssd1 vccd1 vccd1 _06162_ sky130_fd_sc_hd__a21o_1
X_12190_ cell2.CB_1.config_dataA\[3\] cell2.CB_1.config_dataA\[2\] net846 vssd1 vssd1
+ vccd1 vccd1 _00623_ sky130_fd_sc_hd__mux2_1
XANTENNA__09765__A2 _04298_ vssd1 vssd1 vccd1 vccd1 sky130_fd_sc_hd__diode_2
XFILLER_5_549 vssd1 vssd1 vccd1 vccd1 sky130_fd_sc_hd__fill_8
XANTENNA__08568__A3 _03498_ vssd1 vssd1 vccd1 vccd1 sky130_fd_sc_hd__diode_2
XFILLER_135_797 vccd1 vssd1 vccd1 vssd1 sky130_ef_sc_hd__decap_40_12
XANTENNA__10375__A3 net35 vssd1 vssd1 vccd1 vccd1 sky130_fd_sc_hd__diode_2
X_11141_ net386 _06091_ _06092_ _01799_ vssd1 vssd1 vccd1 vccd1 _06093_ sky130_fd_sc_hd__a211o_1
XFILLER_103_3 vccd1 vssd1 vccd1 vssd1 sky130_ef_sc_hd__decap_40_12
XANTENNA_fanout884_X net884 vssd1 vssd1 vccd1 vccd1 sky130_fd_sc_hd__diode_2
XTAP_TAPCELL_ROW_56_1147 vssd1 vccd1 sky130_fd_sc_hd__tapvpwrvgnd_1
XANTENNA__07776__B2 cell1.SB0.route_sel\[35\] vssd1 vssd1 vccd1 vccd1 sky130_fd_sc_hd__diode_2
X_11072_ _06022_ _06023_ _06025_ vssd1 vssd1 vccd1 vccd1 _06026_ sky130_fd_sc_hd__o21bai_1
Xinput111 SBwest_in[22] vssd1 vssd1 vccd1 vccd1 net111 sky130_fd_sc_hd__buf_1
XFILLER_1_755 vccd1 vssd1 vccd1 vssd1 sky130_ef_sc_hd__decap_40_12
Xinput100 SBwest_in[12] vssd1 vssd1 vccd1 vccd1 net100 sky130_fd_sc_hd__buf_1
Xinput133 nrst vssd1 vssd1 vccd1 vccd1 net133 sky130_fd_sc_hd__clkbuf_2
X_10023_ cell2.LEI0.config_data\[33\] net304 vssd1 vssd1 vccd1 vccd1 _05027_ sky130_fd_sc_hd__nand2_1
XANTENNA__10531__X _05489_ vssd1 vssd1 vccd1 vccd1 sky130_fd_sc_hd__diode_2
Xinput122 SBwest_in[3] vssd1 vssd1 vccd1 vccd1 net122 sky130_fd_sc_hd__buf_1
XANTENNA__07824__Y bus1_0\[5\] vssd1 vssd1 vccd1 vccd1 sky130_fd_sc_hd__diode_2
XANTENNA__10898__B net272 vssd1 vssd1 vccd1 vccd1 sky130_fd_sc_hd__diode_2
XANTENNA_input23_A CBeast_in[2] vssd1 vssd1 vccd1 vccd1 sky130_fd_sc_hd__diode_2
XFILLER_29_472 vssd1 vssd1 vccd1 vccd1 sky130_fd_sc_hd__fill_1
XANTENNA__08936__X _03968_ vssd1 vssd1 vccd1 vccd1 sky130_fd_sc_hd__diode_2
X_11974_ cell0.SB0.route_sel\[80\] cell0.SB0.route_sel\[79\] net766 vssd1 vssd1 vccd1
+ vccd1 _00411_ sky130_fd_sc_hd__mux2_1
X_13713_ clknet_leaf_28_clk _00685_ net618 vssd1 vssd1 vccd1 vccd1 cell2.CB_0.config_dataA\[15\]
+ sky130_fd_sc_hd__dfstp_1
X_10925_ net274 _05878_ vssd1 vssd1 vccd1 vccd1 _05879_ sky130_fd_sc_hd__and2_2
X_13644_ clknet_leaf_38_clk _00616_ net646 vssd1 vssd1 vccd1 vccd1 cell2.LE_1B.config_data\[16\]
+ sky130_fd_sc_hd__dfrtp_1
X_10856_ cell3.CB_1.config_dataB\[16\] _05810_ _05811_ vssd1 vssd1 vccd1 vccd1 _05812_
+ sky130_fd_sc_hd__a21bo_1
X_10787_ net15 net16 net369 vssd1 vssd1 vccd1 vccd1 _05743_ sky130_fd_sc_hd__mux2_1
X_13575_ clknet_leaf_117_clk _00547_ net671 vssd1 vssd1 vccd1 vccd1 cell1.LE_0A.reset_val
+ sky130_fd_sc_hd__dfrtp_2
X_12526_ net1386 net1382 net840 vssd1 vssd1 vccd1 vccd1 _00955_ sky130_fd_sc_hd__mux2_1
X_12457_ cell2.LE_0B.edge_mode cell2.LE_0B.config_data\[16\] net844 vssd1 vssd1 vccd1
+ vccd1 _00888_ sky130_fd_sc_hd__mux2_1
XANTENNA__09205__A1 net9 vssd1 vssd1 vccd1 vccd1 sky130_fd_sc_hd__diode_2
XANTENNA__11012__B2 _05861_ vssd1 vssd1 vccd1 vccd1 sky130_fd_sc_hd__diode_2
XANTENNA__11012__A1 _05856_ vssd1 vssd1 vccd1 vccd1 sky130_fd_sc_hd__diode_2
XANTENNA__09756__A2 bus3_2\[13\] vssd1 vssd1 vccd1 vccd1 sky130_fd_sc_hd__diode_2
X_11408_ _06272_ _02208_ vssd1 vssd1 vccd1 vccd1 net231 sky130_fd_sc_hd__and2b_2
X_14127_ clknet_leaf_64_clk net1236 net744 vssd1 vssd1 vccd1 vccd1 cell3.LE_1B.config_data\[7\]
+ sky130_fd_sc_hd__dfrtp_1
XFILLER_99_626 vssd1 vssd1 vccd1 vccd1 sky130_fd_sc_hd__fill_2
XFILLER_99_615 vssd1 vssd1 vccd1 vccd1 sky130_fd_sc_hd__fill_1
X_12388_ cell1.SB0.route_sel\[126\] cell1.SB0.route_sel\[125\] net802 vssd1 vssd1
+ vccd1 vccd1 _00821_ sky130_fd_sc_hd__mux2_1
XFILLER_113_447 vssd1 vssd1 vccd1 vccd1 sky130_fd_sc_hd__fill_1
X_11339_ _04485_ _05893_ vssd1 vssd1 vccd1 vccd1 _06235_ sky130_fd_sc_hd__nand2b_1
XFILLER_99_659 vssd1 vssd1 vccd1 vccd1 sky130_fd_sc_hd__fill_1
XANTENNA__09508__A2 _02106_ vssd1 vssd1 vccd1 vccd1 sky130_fd_sc_hd__diode_2
XFILLER_79_361 vssd1 vssd1 vccd1 vccd1 sky130_fd_sc_hd__fill_1
X_14058_ clknet_leaf_81_clk _01030_ net702 vssd1 vssd1 vccd1 vccd1 cell3.SB0.route_sel\[66\]
+ sky130_fd_sc_hd__dfstp_1
X_13009_ cell3.LEI0.config_data\[30\] net1372 net951 vssd1 vssd1 vccd1 vccd1 _01437_
+ sky130_fd_sc_hd__mux2_1
XANTENNA__10118__A3 net35 vssd1 vssd1 vccd1 vccd1 sky130_fd_sc_hd__diode_2
XANTENNA__10441__X bus3_2\[4\] vssd1 vssd1 vccd1 vccd1 sky130_fd_sc_hd__diode_2
Xclkbuf_0_cell0.LE_0A.sel_clk cell0.LE_0A.sel_clk vssd1 vssd1 vccd1 vccd1 clknet_0_cell0.LE_0A.sel_clk
+ sky130_fd_sc_hd__clkbuf_16
X_06880_ _01868_ _01947_ vssd1 vssd1 vccd1 vccd1 _01948_ sky130_fd_sc_hd__or2_1
XANTENNA__10523__B1 cell3.SB0.route_sel\[44\] vssd1 vssd1 vccd1 vccd1 sky130_fd_sc_hd__diode_2
XTAP_TAPCELL_ROW_87_1608 vssd1 vccd1 sky130_fd_sc_hd__tapvpwrvgnd_1
XANTENNA__08731__A3 net323 vssd1 vssd1 vccd1 vccd1 sky130_fd_sc_hd__diode_2
XTAP_TAPCELL_ROW_87_1619 vssd1 vccd1 sky130_fd_sc_hd__tapvpwrvgnd_1
XPHY_EDGE_ROW_6_Left_149 vssd1 vssd1 vccd1 vccd1 sky130_fd_sc_hd__decap_3
X_08550_ net492 _03533_ _03585_ net490 vssd1 vssd1 vccd1 vccd1 _03586_ sky130_fd_sc_hd__o211a_1
X_07501_ cell0.CB_0.le_outB _01946_ _02339_ vssd1 vssd1 vccd1 vccd1 _02553_ sky130_fd_sc_hd__and3_1
X_08481_ _02655_ _03516_ vssd1 vssd1 vccd1 vccd1 _03517_ sky130_fd_sc_hd__or2_4
XANTENNA__11272__X net197 vssd1 vssd1 vccd1 vccd1 sky130_fd_sc_hd__diode_2
X_07432_ _01866_ _02339_ vssd1 vssd1 vccd1 vccd1 _02486_ sky130_fd_sc_hd__nand2_1
XTAP_TAPCELL_ROW_46_993 vssd1 vccd1 sky130_fd_sc_hd__tapvpwrvgnd_1
X_07363_ _02415_ _02417_ _02418_ _02416_ vssd1 vssd1 vccd1 vccd1 _02419_ sky130_fd_sc_hd__o31a_1
X_09102_ net476 _03862_ vssd1 vssd1 vccd1 vccd1 _04132_ sky130_fd_sc_hd__nand2_1
XANTENNA__11251__A1 _05156_ vssd1 vssd1 vccd1 vccd1 sky130_fd_sc_hd__diode_2
XFILLER_109_709 vssd1 vssd1 vccd1 vccd1 sky130_fd_sc_hd__fill_1
XANTENNA__10054__A2 bus3_2\[1\] vssd1 vssd1 vccd1 vccd1 sky130_fd_sc_hd__diode_2
XANTENNA__09677__X _04691_ vssd1 vssd1 vccd1 vccd1 sky130_fd_sc_hd__diode_2
X_07294_ cell1.SB0.route_sel\[101\] cell1.SB0.route_sel\[100\] vssd1 vssd1 vccd1 vccd1
+ _02352_ sky130_fd_sc_hd__nand2_1
X_09033_ net485 _03862_ vssd1 vssd1 vccd1 vccd1 _04063_ sky130_fd_sc_hd__nand2_1
XANTENNA__11859__S net897 vssd1 vssd1 vccd1 vccd1 sky130_fd_sc_hd__diode_2
XANTENNA__11003__A1 _05921_ vssd1 vssd1 vccd1 vccd1 sky130_fd_sc_hd__diode_2
XANTENNA_fanout308_A cell2.CB_0.le_outB vssd1 vssd1 vccd1 vccd1 sky130_fd_sc_hd__diode_2
Xhold310 _00157_ vssd1 vssd1 vccd1 vccd1 net1269 sky130_fd_sc_hd__dlygate4sd3_1
Xhold321 _00880_ vssd1 vssd1 vccd1 vccd1 net1280 sky130_fd_sc_hd__dlygate4sd3_1
Xhold332 cell1.LE_0A.config_data\[7\] vssd1 vssd1 vccd1 vccd1 net1291 sky130_fd_sc_hd__dlygate4sd3_1
Xhold343 cell1.LEI0.config_data\[40\] vssd1 vssd1 vccd1 vccd1 net1302 sky130_fd_sc_hd__dlygate4sd3_1
Xhold354 cell3.LE_1B.config_data\[4\] vssd1 vssd1 vccd1 vccd1 net1313 sky130_fd_sc_hd__dlygate4sd3_1
XFILLER_89_125 vssd1 vssd1 vccd1 vccd1 sky130_fd_sc_hd__fill_8
Xhold387 _00577_ vssd1 vssd1 vccd1 vccd1 net1346 sky130_fd_sc_hd__dlygate4sd3_1
Xhold365 _00582_ vssd1 vssd1 vccd1 vccd1 net1324 sky130_fd_sc_hd__dlygate4sd3_1
Xhold376 cell0.LEI0.config_data\[43\] vssd1 vssd1 vccd1 vccd1 net1335 sky130_fd_sc_hd__dlygate4sd3_1
Xhold398 cell2.LE_1B.config_data\[13\] vssd1 vssd1 vccd1 vccd1 net1357 sky130_fd_sc_hd__dlygate4sd3_1
Xfanout823 net824 vssd1 vssd1 vccd1 vccd1 net823 sky130_fd_sc_hd__clkbuf_2
XFILLER_104_469 vssd1 vssd1 vccd1 vccd1 sky130_fd_sc_hd__fill_4
Xfanout812 net814 vssd1 vssd1 vccd1 vccd1 net812 sky130_fd_sc_hd__clkbuf_4
X_09935_ net410 _04724_ vssd1 vssd1 vccd1 vccd1 _04939_ sky130_fd_sc_hd__nand2_1
XFILLER_89_169 vssd1 vssd1 vccd1 vccd1 sky130_fd_sc_hd__fill_2
Xfanout834 net836 vssd1 vssd1 vccd1 vccd1 net834 sky130_fd_sc_hd__clkbuf_4
Xfanout801 net802 vssd1 vssd1 vccd1 vccd1 net801 sky130_fd_sc_hd__clkbuf_4
Xfanout845 net855 vssd1 vssd1 vccd1 vccd1 net845 sky130_fd_sc_hd__clkbuf_2
XTAP_TAPCELL_ROW_129_2247 vssd1 vccd1 sky130_fd_sc_hd__tapvpwrvgnd_1
XTAP_TAPCELL_ROW_129_2236 vssd1 vccd1 sky130_fd_sc_hd__tapvpwrvgnd_1
XANTENNA_fanout298_X net298 vssd1 vssd1 vccd1 vccd1 sky130_fd_sc_hd__diode_2
X_09866_ _04832_ _04871_ _04791_ vssd1 vssd1 vccd1 vccd1 _04872_ sky130_fd_sc_hd__mux2_1
XANTENNA_fanout677_A net684 vssd1 vssd1 vccd1 vccd1 sky130_fd_sc_hd__diode_2
Xfanout856 net863 vssd1 vssd1 vccd1 vccd1 net856 sky130_fd_sc_hd__clkbuf_4
Xfanout867 net884 vssd1 vssd1 vccd1 vccd1 net867 sky130_fd_sc_hd__clkbuf_2
XFILLER_133_57 vccd1 vssd1 vccd1 vssd1 sky130_ef_sc_hd__decap_40_12
Xfanout878 net879 vssd1 vssd1 vccd1 vccd1 net878 sky130_fd_sc_hd__clkbuf_4
XTAP_TAPCELL_ROW_51_1077 vssd1 vccd1 sky130_fd_sc_hd__tapvpwrvgnd_1
XTAP_TAPCELL_ROW_51_1066 vssd1 vccd1 sky130_fd_sc_hd__tapvpwrvgnd_1
X_08817_ net270 _03848_ vssd1 vssd1 vccd1 vccd1 _03849_ sky130_fd_sc_hd__nand2_4
XTAP_TAPCELL_ROW_5_379 vssd1 vccd1 sky130_fd_sc_hd__tapvpwrvgnd_1
XANTENNA__08469__A _03504_ vssd1 vssd1 vccd1 vccd1 sky130_fd_sc_hd__diode_2
Xfanout889 net890 vssd1 vssd1 vccd1 vccd1 net889 sky130_fd_sc_hd__clkbuf_4
XTAP_TAPCELL_ROW_142_2436 vssd1 vccd1 sky130_fd_sc_hd__tapvpwrvgnd_1
XANTENNA_fanout844_A net845 vssd1 vssd1 vccd1 vccd1 sky130_fd_sc_hd__diode_2
X_09797_ cell2.CB_1.config_dataA\[1\] _04799_ _04800_ _04802_ vssd1 vssd1 vccd1 vccd1
+ _04803_ sky130_fd_sc_hd__a31o_1
XFILLER_93_39 vccd1 vssd1 vccd1 vssd1 sky130_ef_sc_hd__decap_40_12
XANTENNA__08722__A3 net7 vssd1 vssd1 vccd1 vccd1 sky130_fd_sc_hd__diode_2
XANTENNA__10511__B _03486_ vssd1 vssd1 vccd1 vccd1 sky130_fd_sc_hd__diode_2
XTAP_TAPCELL_ROW_142_2458 vssd1 vccd1 sky130_fd_sc_hd__tapvpwrvgnd_1
XTAP_TAPCELL_ROW_142_2447 vssd1 vccd1 sky130_fd_sc_hd__tapvpwrvgnd_1
X_08748_ _03771_ _03774_ _03779_ _03781_ vssd1 vssd1 vccd1 vccd1 _03782_ sky130_fd_sc_hd__a2bb2o_1
XANTENNA_fanout632_X net632 vssd1 vssd1 vccd1 vccd1 sky130_fd_sc_hd__diode_2
XANTENNA__10278__C1 net351 vssd1 vssd1 vccd1 vccd1 sky130_fd_sc_hd__diode_2
XANTENNA__10817__A1 _05504_ vssd1 vssd1 vccd1 vccd1 sky130_fd_sc_hd__diode_2
XFILLER_54_773 vssd1 vssd1 vccd1 vccd1 sky130_fd_sc_hd__fill_1
X_08679_ net4 net5 net6 net7 net462 cell1.CB_1.config_dataB\[1\] vssd1 vssd1 vccd1
+ vccd1 _03713_ sky130_fd_sc_hd__mux4_1
X_10710_ cell3.CB_1.config_dataA\[17\] _05666_ _05667_ _05657_ _05664_ vssd1 vssd1
+ vccd1 vccd1 _05668_ sky130_fd_sc_hd__o311a_1
X_11690_ net1155 net1147 net872 vssd1 vssd1 vccd1 vccd1 _00130_ sky130_fd_sc_hd__mux2_1
XFILLER_14_659 vssd1 vssd1 vccd1 vccd1 sky130_fd_sc_hd__fill_1
X_10641_ _01786_ _05569_ _05585_ _05598_ cell3.LEI0.config_data\[8\] vssd1 vssd1 vccd1
+ vccd1 _05599_ sky130_fd_sc_hd__o32a_2
XTAP_TAPCELL_ROW_24_665 vssd1 vccd1 sky130_fd_sc_hd__tapvpwrvgnd_1
X_10572_ _01742_ cell3.SB0.route_sel\[111\] cell3.SB0.route_sel\[108\] cell3.SB0.route_sel\[109\]
+ _05529_ vssd1 vssd1 vccd1 vccd1 _05530_ sky130_fd_sc_hd__o221a_1
XANTENNA__09587__X bus3_1\[10\] vssd1 vssd1 vccd1 vccd1 sky130_fd_sc_hd__diode_2
XFILLER_42_76 vssd1 vssd1 vccd1 vccd1 sky130_fd_sc_hd__fill_1
X_13360_ clknet_leaf_128_clk _00332_ net577 vssd1 vssd1 vccd1 vccd1 cell0.SB0.route_sel\[1\]
+ sky130_fd_sc_hd__dfstp_1
XFILLER_127_517 vssd1 vssd1 vccd1 vccd1 sky130_fd_sc_hd__fill_1
X_12311_ cell1.SB0.route_sel\[49\] cell1.SB0.route_sel\[48\] net858 vssd1 vssd1 vccd1
+ vccd1 _00744_ sky130_fd_sc_hd__mux2_1
X_13291_ clknet_leaf_99_clk _00263_ net679 vssd1 vssd1 vccd1 vccd1 cell1.CB_1.config_dataA\[7\]
+ sky130_fd_sc_hd__dfstp_2
XFILLER_142_509 vssd1 vssd1 vccd1 vccd1 sky130_fd_sc_hd__fill_1
X_12242_ net419 cell2.CB_0.config_dataA\[4\] net826 vssd1 vssd1 vccd1 vccd1 _00675_
+ sky130_fd_sc_hd__mux2_1
XANTENNA__08651__B _03468_ vssd1 vssd1 vccd1 vccd1 sky130_fd_sc_hd__diode_2
X_12173_ net1172 cell2.LE_1B.config_data\[5\] net852 vssd1 vssd1 vccd1 vccd1 _00606_
+ sky130_fd_sc_hd__mux2_1
X_11124_ _01797_ _06059_ _06073_ _06075_ vssd1 vssd1 vccd1 vccd1 _06076_ sky130_fd_sc_hd__a31o_4
XFILLER_3_15 vccd1 vssd1 vccd1 vssd1 sky130_ef_sc_hd__decap_40_12
XFILLER_1_541 vccd1 vssd1 vccd1 vssd1 sky130_ef_sc_hd__decap_40_12
X_11055_ _05996_ _06000_ _06008_ vssd1 vssd1 vccd1 vccd1 _06009_ sky130_fd_sc_hd__o21a_1
XFILLER_95_117 vssd1 vssd1 vccd1 vccd1 sky130_fd_sc_hd__fill_1
XFILLER_49_512 vssd1 vssd1 vccd1 vccd1 sky130_fd_sc_hd__fill_1
XANTENNA__09482__B _01979_ vssd1 vssd1 vccd1 vccd1 sky130_fd_sc_hd__diode_2
XFILLER_1_585 vccd1 vssd1 vccd1 vssd1 sky130_ef_sc_hd__decap_40_12
XANTENNA__10505__A0 net322 vssd1 vssd1 vccd1 vccd1 sky130_fd_sc_hd__diode_2
X_10006_ net403 _04298_ _05009_ net402 vssd1 vssd1 vccd1 vccd1 _05010_ sky130_fd_sc_hd__o211a_1
XANTENNA_input26_X net26 vssd1 vssd1 vccd1 vccd1 sky130_fd_sc_hd__diode_2
XFILLER_76_386 vccd1 vssd1 vccd1 vssd1 sky130_ef_sc_hd__decap_40_12
XTAP_TAPCELL_ROW_69_1349 vssd1 vccd1 sky130_fd_sc_hd__tapvpwrvgnd_1
XTAP_TAPCELL_ROW_69_1338 vssd1 vccd1 sky130_fd_sc_hd__tapvpwrvgnd_1
XFILLER_17_453 vssd1 vssd1 vccd1 vccd1 sky130_fd_sc_hd__fill_1
X_11957_ cell0.SB0.route_sel\[63\] cell0.SB0.route_sel\[62\] net764 vssd1 vssd1 vccd1
+ vccd1 _00394_ sky130_fd_sc_hd__mux2_1
X_10908_ _01806_ net378 vssd1 vssd1 vccd1 vccd1 _05862_ sky130_fd_sc_hd__nor2_1
XTAP_TAPCELL_ROW_82_1538 vssd1 vccd1 sky130_fd_sc_hd__tapvpwrvgnd_1
XANTENNA__08826__B _03857_ vssd1 vssd1 vccd1 vccd1 sky130_fd_sc_hd__diode_2
X_11888_ cell1.CB_0.config_dataA\[19\] cell1.CB_0.config_dataA\[18\] net879 vssd1
+ vssd1 vccd1 vccd1 _00325_ sky130_fd_sc_hd__mux2_1
XTAP_TAPCELL_ROW_43_952 vssd1 vccd1 sky130_fd_sc_hd__tapvpwrvgnd_1
XFILLER_32_445 vssd1 vssd1 vccd1 vccd1 sky130_fd_sc_hd__fill_1
X_10839_ _05759_ _05794_ _05758_ vssd1 vssd1 vccd1 vccd1 _05795_ sky130_fd_sc_hd__mux2_1
X_13627_ clknet_1_1__leaf_cell1.LE_0A.sel_clk _00599_ net751 vssd1 vssd1 vccd1 vccd1
+ cell1.LE_0A.dff1_out sky130_fd_sc_hd__dfstp_1
XANTENNA__08229__A2 bus1_0\[14\] vssd1 vssd1 vccd1 vccd1 sky130_fd_sc_hd__diode_2
XANTENNA__09497__X _04518_ vssd1 vssd1 vccd1 vccd1 sky130_fd_sc_hd__diode_2
X_13558_ clknet_leaf_118_clk _00530_ net669 vssd1 vssd1 vccd1 vccd1 cell1.LE_0A.config_data\[1\]
+ sky130_fd_sc_hd__dfrtp_1
XPHY_EDGE_ROW_132_Right_132 vssd1 vssd1 vccd1 vccd1 sky130_fd_sc_hd__decap_3
X_12509_ net1341 cell2.LEI0.config_data\[22\] net847 vssd1 vssd1 vccd1 vccd1 _00938_
+ sky130_fd_sc_hd__mux2_1
XANTENNA__09657__B _04670_ vssd1 vssd1 vccd1 vccd1 sky130_fd_sc_hd__diode_2
XFILLER_9_685 vccd1 vssd1 vccd1 vssd1 sky130_ef_sc_hd__decap_40_12
XFILLER_9_663 vssd1 vssd1 vccd1 vccd1 sky130_fd_sc_hd__fill_8
XTAP_TAPCELL_ROW_113_2004 vssd1 vccd1 sky130_fd_sc_hd__tapvpwrvgnd_1
XTAP_TAPCELL_ROW_97_1770 vssd1 vccd1 sky130_fd_sc_hd__tapvpwrvgnd_1
X_13489_ clknet_leaf_93_clk _00461_ net683 vssd1 vssd1 vccd1 vccd1 cell1.CB_1.config_dataB\[2\]
+ sky130_fd_sc_hd__dfstp_2
XFILLER_8_195 vssd1 vssd1 vccd1 vccd1 sky130_fd_sc_hd__fill_1
XANTENNA__08561__B _03509_ vssd1 vssd1 vccd1 vccd1 sky130_fd_sc_hd__diode_2
XANTENNA__10339__A3 net39 vssd1 vssd1 vccd1 vccd1 sky130_fd_sc_hd__diode_2
X_07981_ net631 net551 vssd1 vssd1 vccd1 vccd1 _03025_ sky130_fd_sc_hd__and2_2
Xclkbuf_0_cell2.LE_0B.sel_clk cell2.LE_0B.sel_clk vssd1 vssd1 vccd1 vccd1 clknet_0_cell2.LE_0B.sel_clk
+ sky130_fd_sc_hd__clkbuf_16
XANTENNA__11267__X net195 vssd1 vssd1 vccd1 vccd1 sky130_fd_sc_hd__diode_2
X_09720_ _04719_ _04720_ _04727_ _04732_ vssd1 vssd1 vccd1 vccd1 _04733_ sky130_fd_sc_hd__o31ai_1
X_06932_ net317 _01996_ _01998_ _01994_ _01989_ vssd1 vssd1 vccd1 vccd1 _01999_ sky130_fd_sc_hd__o221a_1
XANTENNA__07464__Y bus1_0\[14\] vssd1 vssd1 vccd1 vccd1 sky130_fd_sc_hd__diode_2
XANTENNA__09362__B1 bus3_2\[4\] vssd1 vssd1 vccd1 vccd1 sky130_fd_sc_hd__diode_2
XFILLER_86_139 vssd1 vssd1 vccd1 vccd1 sky130_fd_sc_hd__fill_1
XANTENNA__07905__B _02897_ vssd1 vssd1 vccd1 vccd1 sky130_fd_sc_hd__diode_2
XANTENNA__08165__A1 bus1_0\[1\] vssd1 vssd1 vccd1 vccd1 sky130_fd_sc_hd__diode_2
X_09651_ cell3.SB0.route_sel\[108\] cell3.SB0.route_sel\[109\] vssd1 vssd1 vccd1 vccd1
+ _04666_ sky130_fd_sc_hd__nand2_1
XFILLER_82_301 vssd1 vssd1 vccd1 vccd1 sky130_fd_sc_hd__fill_1
XANTENNA__14361__SET_B net733 vssd1 vssd1 vccd1 vccd1 sky130_fd_sc_hd__diode_2
XTAP_TAPCELL_ROW_2_338 vssd1 vccd1 sky130_fd_sc_hd__tapvpwrvgnd_1
X_06863_ cell0.CB_1.config_dataA\[24\] cell0.CB_1.config_dataA\[20\] cell0.CB_1.config_dataA\[21\]
+ vssd1 vssd1 vccd1 vccd1 _01931_ sky130_fd_sc_hd__and3b_2
X_09582_ net282 _04598_ _04599_ _04597_ vssd1 vssd1 vccd1 vccd1 _04600_ sky130_fd_sc_hd__a22oi_2
XFILLER_67_397 vssd1 vssd1 vccd1 vccd1 sky130_fd_sc_hd__fill_1
XANTENNA__07912__B2 _02890_ vssd1 vssd1 vccd1 vccd1 sky130_fd_sc_hd__diode_2
X_06794_ _01862_ _01863_ vssd1 vssd1 vccd1 vccd1 _01864_ sky130_fd_sc_hd__nor2_1
XFILLER_55_559 vssd1 vssd1 vccd1 vccd1 sky130_fd_sc_hd__fill_1
X_08602_ net489 _03468_ vssd1 vssd1 vccd1 vccd1 _03638_ sky130_fd_sc_hd__nand2_1
XTAP_TAPCELL_ROW_124_2166 vssd1 vccd1 sky130_fd_sc_hd__tapvpwrvgnd_1
X_08533_ net31 net32 net2 net3 net495 net493 vssd1 vssd1 vccd1 vccd1 _03569_ sky130_fd_sc_hd__mux4_1
XFILLER_70_529 vssd1 vssd1 vccd1 vccd1 sky130_fd_sc_hd__fill_1
XANTENNA__08736__B _03468_ vssd1 vssd1 vccd1 vccd1 sky130_fd_sc_hd__diode_2
XFILLER_36_784 vssd1 vssd1 vccd1 vccd1 sky130_fd_sc_hd__fill_1
X_08464_ _03491_ _03495_ _03499_ cell1.CB_1.config_dataA\[2\] vssd1 vssd1 vccd1 vccd1
+ _03500_ sky130_fd_sc_hd__and4b_1
X_07415_ cell2.SB0.route_sel\[110\] cell2.SB0.route_sel\[111\] vssd1 vssd1 vccd1 vccd1
+ _02470_ sky130_fd_sc_hd__nor2_1
X_08395_ net500 _02761_ vssd1 vssd1 vccd1 vccd1 _03433_ sky130_fd_sc_hd__nand2_1
X_07346_ cell2.SB0.route_sel\[97\] cell2.SB0.route_sel\[96\] vssd1 vssd1 vccd1 vccd1
+ _02403_ sky130_fd_sc_hd__nand2b_1
XFILLER_10_117 vssd1 vssd1 vccd1 vccd1 sky130_fd_sc_hd__fill_1
XFILLER_10_139 vssd1 vssd1 vccd1 vccd1 sky130_fd_sc_hd__fill_1
XTAP_TAPCELL_ROW_21_624 vssd1 vccd1 sky130_fd_sc_hd__tapvpwrvgnd_1
XANTENNA__09200__X bus3_1\[0\] vssd1 vssd1 vccd1 vccd1 sky130_fd_sc_hd__diode_2
XANTENNA__11589__S net790 vssd1 vssd1 vccd1 vccd1 sky130_fd_sc_hd__diode_2
XANTENNA__10983__A0 net53 vssd1 vssd1 vccd1 vccd1 sky130_fd_sc_hd__diode_2
X_09016_ _04037_ _04038_ _04044_ _04045_ vssd1 vssd1 vccd1 vccd1 _04046_ sky130_fd_sc_hd__o22a_1
X_07277_ _02333_ _02334_ _02330_ _02331_ vssd1 vssd1 vccd1 vccd1 _02335_ sky130_fd_sc_hd__a2bb2o_1
XFILLER_2_305 vssd1 vssd1 vccd1 vccd1 sky130_fd_sc_hd__fill_2
XFILLER_132_531 vssd1 vssd1 vccd1 vccd1 sky130_fd_sc_hd__fill_1
Xhold151 cell3.LEI0.config_data\[44\] vssd1 vssd1 vccd1 vccd1 net1110 sky130_fd_sc_hd__dlygate4sd3_1
Xhold140 cell0.LEI0.config_data\[2\] vssd1 vssd1 vccd1 vccd1 net1099 sky130_fd_sc_hd__dlygate4sd3_1
Xhold162 _00228_ vssd1 vssd1 vccd1 vccd1 net1121 sky130_fd_sc_hd__dlygate4sd3_1
Xhold173 cell3.LE_0B.config_data\[14\] vssd1 vssd1 vccd1 vccd1 net1132 sky130_fd_sc_hd__dlygate4sd3_1
XTAP_TAPCELL_ROW_53_1106 vssd1 vccd1 sky130_fd_sc_hd__tapvpwrvgnd_1
Xhold184 cell0.LE_1B.config_data\[11\] vssd1 vssd1 vccd1 vccd1 net1143 sky130_fd_sc_hd__dlygate4sd3_1
Xhold195 cell1.LE_1B.config_data\[2\] vssd1 vssd1 vccd1 vccd1 net1154 sky130_fd_sc_hd__dlygate4sd3_1
Xfanout620 net621 vssd1 vssd1 vccd1 vccd1 net620 sky130_fd_sc_hd__clkbuf_4
Xfanout642 net649 vssd1 vssd1 vccd1 vccd1 net642 sky130_fd_sc_hd__buf_2
X_09918_ net409 net408 vssd1 vssd1 vccd1 vccd1 _04922_ sky130_fd_sc_hd__nor2_1
Xfanout631 net632 vssd1 vssd1 vccd1 vccd1 net631 sky130_fd_sc_hd__buf_2
XFILLER_104_299 vssd1 vssd1 vccd1 vccd1 sky130_fd_sc_hd__fill_1
Xfanout675 net750 vssd1 vssd1 vccd1 vccd1 net675 sky130_fd_sc_hd__clkbuf_4
XANTENNA__08156__A1 net347 vssd1 vssd1 vccd1 vccd1 sky130_fd_sc_hd__diode_2
Xfanout653 net657 vssd1 vssd1 vccd1 vccd1 net653 sky130_fd_sc_hd__buf_2
Xfanout664 net675 vssd1 vssd1 vccd1 vccd1 net664 sky130_fd_sc_hd__clkbuf_2
XANTENNA__11160__A0 _05874_ vssd1 vssd1 vccd1 vccd1 sky130_fd_sc_hd__diode_2
X_09849_ cell2.CB_1.config_dataA\[11\] _04853_ _04854_ vssd1 vssd1 vccd1 vccd1 _04855_
+ sky130_fd_sc_hd__a21o_1
XFILLER_85_161 vssd1 vssd1 vccd1 vccd1 sky130_fd_sc_hd__fill_4
Xfanout697 net700 vssd1 vssd1 vccd1 vccd1 net697 sky130_fd_sc_hd__buf_2
Xfanout686 net687 vssd1 vssd1 vccd1 vccd1 net686 sky130_fd_sc_hd__clkbuf_4
XTAP_TAPCELL_ROW_109_1939 vssd1 vccd1 sky130_fd_sc_hd__tapvpwrvgnd_1
X_12860_ cell2.SB0.route_sel\[102\] cell2.SB0.route_sel\[101\] net821 vssd1 vssd1
+ vccd1 vccd1 _01289_ sky130_fd_sc_hd__mux2_1
XANTENNA_input125_A SBwest_in[6] vssd1 vssd1 vccd1 vccd1 sky130_fd_sc_hd__diode_2
XTAP_TAPCELL_ROW_29_746 vssd1 vccd1 sky130_fd_sc_hd__tapvpwrvgnd_1
XFILLER_37_65 vssd1 vssd1 vccd1 vccd1 sky130_fd_sc_hd__fill_1
X_11811_ cell1.LE_1B.config_data\[12\] cell1.LE_1B.config_data\[11\] net902 vssd1
+ vssd1 vccd1 vccd1 _00248_ sky130_fd_sc_hd__mux2_1
XFILLER_27_751 vssd1 vssd1 vccd1 vccd1 sky130_fd_sc_hd__fill_1
X_12791_ cell2.SB0.route_sel\[33\] cell2.SB0.route_sel\[32\] net820 vssd1 vssd1 vccd1
+ vccd1 _01220_ sky130_fd_sc_hd__mux2_1
XANTENNA__08646__B _03504_ vssd1 vssd1 vccd1 vccd1 sky130_fd_sc_hd__diode_2
XANTENNA__08459__A2 _03493_ vssd1 vssd1 vccd1 vccd1 sky130_fd_sc_hd__diode_2
X_11742_ net1085 net1082 net809 vssd1 vssd1 vccd1 vccd1 _00180_ sky130_fd_sc_hd__mux2_1
XANTENNA__09120__A3 bus3_1\[11\] vssd1 vssd1 vccd1 vccd1 sky130_fd_sc_hd__diode_2
XFILLER_42_765 vssd1 vssd1 vccd1 vccd1 sky130_fd_sc_hd__fill_1
XANTENNA__07667__B1 _02711_ vssd1 vssd1 vccd1 vccd1 sky130_fd_sc_hd__diode_2
X_14461_ clknet_leaf_60_clk _01433_ net740 vssd1 vssd1 vccd1 vccd1 cell3.LEI0.config_data\[26\]
+ sky130_fd_sc_hd__dfrtp_1
XTAP_TAPCELL_ROW_64_1268 vssd1 vccd1 sky130_fd_sc_hd__tapvpwrvgnd_1
XTAP_TAPCELL_ROW_40_911 vssd1 vccd1 sky130_fd_sc_hd__tapvpwrvgnd_1
X_11673_ cell0.CB_1.config_dataB\[19\] cell0.CB_1.config_dataB\[18\] net786 vssd1
+ vssd1 vccd1 vccd1 _00114_ sky130_fd_sc_hd__mux2_1
X_14392_ clknet_leaf_61_clk net1331 net738 vssd1 vssd1 vccd1 vccd1 cell3.LE_0B.config_data\[1\]
+ sky130_fd_sc_hd__dfrtp_1
XANTENNA__11215__A1 _05874_ vssd1 vssd1 vccd1 vccd1 sky130_fd_sc_hd__diode_2
X_10624_ net275 _05482_ _05569_ vssd1 vssd1 vccd1 vccd1 _05582_ sky130_fd_sc_hd__a21oi_1
XANTENNA_input90_A SBsouth_in[3] vssd1 vssd1 vccd1 vccd1 sky130_fd_sc_hd__diode_2
X_13412_ clknet_leaf_134_clk _00384_ net555 vssd1 vssd1 vccd1 vccd1 cell0.SB0.route_sel\[53\]
+ sky130_fd_sc_hd__dfstp_1
XFILLER_128_815 vssd1 vssd1 vccd1 vccd1 sky130_fd_sc_hd__fill_1
X_13343_ clknet_leaf_117_clk _00315_ net671 vssd1 vssd1 vccd1 vccd1 cell1.CB_0.config_dataA\[9\]
+ sky130_fd_sc_hd__dfstp_1
XANTENNA__10974__A0 net286 vssd1 vssd1 vccd1 vccd1 sky130_fd_sc_hd__diode_2
X_10555_ _04205_ _04214_ _04224_ _05512_ vssd1 vssd1 vccd1 vccd1 _05513_ sky130_fd_sc_hd__o211a_4
XFILLER_6_622 vccd1 vssd1 vccd1 vssd1 sky130_ef_sc_hd__decap_40_12
X_13274_ clknet_leaf_93_clk _00246_ net694 vssd1 vssd1 vccd1 vccd1 cell1.LE_1B.config_data\[10\]
+ sky130_fd_sc_hd__dfrtp_1
X_10486_ _05458_ net334 _02686_ vssd1 vssd1 vccd1 vccd1 net145 sky130_fd_sc_hd__mux2_1
XANTENNA_output177_A net177 vssd1 vssd1 vccd1 vccd1 sky130_fd_sc_hd__diode_2
X_12225_ cell2.CB_0.config_dataB\[13\] cell2.CB_0.config_dataB\[12\] net824 vssd1
+ vssd1 vccd1 vccd1 _00658_ sky130_fd_sc_hd__mux2_1
XFILLER_6_699 vssd1 vssd1 vccd1 vccd1 sky130_fd_sc_hd__fill_1
X_12156_ net1238 cell1.LEI0.config_data\[37\] net895 vssd1 vssd1 vccd1 vccd1 _00589_
+ sky130_fd_sc_hd__mux2_1
XANTENNA__08934__A3 net323 vssd1 vssd1 vccd1 vccd1 sky130_fd_sc_hd__diode_2
X_11107_ _06045_ _06049_ _06053_ _06058_ vssd1 vssd1 vccd1 vccd1 _06059_ sky130_fd_sc_hd__o211ai_1
XANTENNA__12479__A0 cell2.LE_0A.config_data\[16\] vssd1 vssd1 vccd1 vccd1 sky130_fd_sc_hd__diode_2
XANTENNA__11528__A _02469_ vssd1 vssd1 vccd1 vccd1 sky130_fd_sc_hd__diode_2
XFILLER_78_72 vssd1 vssd1 vccd1 vccd1 sky130_fd_sc_hd__fill_2
X_12087_ net1531 net1532 net906 vssd1 vssd1 vccd1 vccd1 _00522_ sky130_fd_sc_hd__mux2_1
XFILLER_1_393 vccd1 vssd1 vccd1 vssd1 sky130_ef_sc_hd__decap_40_12
X_11038_ cell3.LEI0.config_data\[26\] _05991_ vssd1 vssd1 vccd1 vccd1 _05992_ sky130_fd_sc_hd__and2b_1
XFILLER_77_684 vssd1 vssd1 vccd1 vccd1 sky130_fd_sc_hd__fill_1
XFILLER_77_662 vssd1 vssd1 vccd1 vccd1 sky130_fd_sc_hd__fill_1
XANTENNA__08698__A2 net336 vssd1 vssd1 vccd1 vccd1 sky130_fd_sc_hd__diode_2
XFILLER_49_397 vssd1 vssd1 vccd1 vccd1 sky130_fd_sc_hd__fill_1
XFILLER_92_654 vssd1 vssd1 vccd1 vccd1 sky130_fd_sc_hd__fill_2
XFILLER_37_559 vssd1 vssd1 vccd1 vccd1 sky130_fd_sc_hd__fill_1
X_12989_ net1397 cell3.LEI0.config_data\[9\] net945 vssd1 vssd1 vccd1 vccd1 _01417_
+ sky130_fd_sc_hd__mux2_1
XFILLER_92_687 vssd1 vssd1 vccd1 vccd1 sky130_fd_sc_hd__fill_1
XFILLER_91_164 vssd1 vssd1 vccd1 vccd1 sky130_fd_sc_hd__fill_4
XANTENNA__10257__A2 net34 vssd1 vssd1 vccd1 vccd1 sky130_fd_sc_hd__diode_2
XPHY_EDGE_ROW_96_Left_239 vssd1 vssd1 vccd1 vccd1 sky130_fd_sc_hd__decap_3
X_08180_ bus1_0\[8\] bus1_0\[9\] bus1_0\[10\] bus1_0\[11\] net543 net541 vssd1 vssd1
+ vccd1 vccd1 _03220_ sky130_fd_sc_hd__mux4_1
X_07200_ net349 _01931_ _02012_ vssd1 vssd1 vccd1 vccd1 _02260_ sky130_fd_sc_hd__and3_1
X_07131_ _01847_ _02012_ net348 vssd1 vssd1 vccd1 vccd1 _02193_ sky130_fd_sc_hd__and3b_1
XANTENNA__10607__A net398 vssd1 vssd1 vccd1 vccd1 sky130_fd_sc_hd__diode_2
XTAP_TAPCELL_ROW_95_1729 vssd1 vccd1 sky130_fd_sc_hd__tapvpwrvgnd_1
XFILLER_9_493 vssd1 vssd1 vccd1 vccd1 sky130_fd_sc_hd__fill_1
XFILLER_118_369 vssd1 vssd1 vccd1 vccd1 sky130_fd_sc_hd__fill_1
X_07062_ _02032_ net354 vssd1 vssd1 vccd1 vccd1 _02126_ sky130_fd_sc_hd__nor2_1
Xoutput201 net201 vssd1 vssd1 vccd1 vccd1 SBsouth_out[12] sky130_fd_sc_hd__buf_2
Xoutput234 net234 vssd1 vssd1 vccd1 vccd1 SBwest_out[13] sky130_fd_sc_hd__buf_2
Xoutput223 net223 vssd1 vssd1 vccd1 vccd1 SBsouth_out[3] sky130_fd_sc_hd__buf_2
Xoutput212 net212 vssd1 vssd1 vccd1 vccd1 SBsouth_out[22] sky130_fd_sc_hd__buf_2
Xoutput245 net245 vssd1 vssd1 vccd1 vccd1 SBwest_out[23] sky130_fd_sc_hd__buf_2
XFILLER_114_531 vssd1 vssd1 vccd1 vccd1 sky130_fd_sc_hd__fill_1
Xoutput256 net256 vssd1 vssd1 vccd1 vccd1 SBwest_out[4] sky130_fd_sc_hd__buf_2
XTAP_TAPCELL_ROW_7_419 vssd1 vccd1 sky130_fd_sc_hd__tapvpwrvgnd_1
XTAP_TAPCELL_ROW_7_408 vssd1 vccd1 sky130_fd_sc_hd__tapvpwrvgnd_1
XANTENNA__08386__A1 _02350_ vssd1 vssd1 vccd1 vccd1 sky130_fd_sc_hd__diode_2
XFILLER_141_361 vssd1 vssd1 vccd1 vccd1 sky130_fd_sc_hd__fill_1
XANTENNA__10193__A1 net308 vssd1 vssd1 vccd1 vccd1 sky130_fd_sc_hd__diode_2
X_07964_ cell0.CB_0.config_dataA\[18\] _03003_ _03007_ cell0.CB_0.config_dataA\[19\]
+ _02995_ vssd1 vssd1 vccd1 vccd1 _03008_ sky130_fd_sc_hd__a311o_1
X_09703_ _04714_ _04716_ vssd1 vssd1 vccd1 vccd1 bus3_1\[14\] sky130_fd_sc_hd__and2b_2
X_06915_ cell2.SB0.route_sel\[60\] cell2.SB0.route_sel\[61\] vssd1 vssd1 vccd1 vccd1
+ _01982_ sky130_fd_sc_hd__nand2_1
X_07895_ _02934_ _02935_ _02937_ _02938_ vssd1 vssd1 vccd1 vccd1 _02939_ sky130_fd_sc_hd__o22a_1
X_09634_ _04207_ _04649_ vssd1 vssd1 vccd1 vccd1 _04650_ sky130_fd_sc_hd__nor2_1
X_06846_ cell2.SB0.route_sel\[52\] cell2.SB0.route_sel\[53\] vssd1 vssd1 vccd1 vccd1
+ _01915_ sky130_fd_sc_hd__nand2_1
XANTENNA__11872__S net883 vssd1 vssd1 vccd1 vccd1 sky130_fd_sc_hd__diode_2
XANTENNA__07897__A0 bus2_0\[8\] vssd1 vssd1 vccd1 vccd1 sky130_fd_sc_hd__diode_2
XFILLER_130_25 vssd1 vssd1 vccd1 vccd1 sky130_fd_sc_hd__fill_2
XFILLER_83_698 vssd1 vssd1 vccd1 vccd1 sky130_fd_sc_hd__fill_2
X_09565_ _02253_ _04582_ vssd1 vssd1 vccd1 vccd1 _04583_ sky130_fd_sc_hd__nand2_4
XTAP_TAPCELL_ROW_26_705 vssd1 vccd1 sky130_fd_sc_hd__tapvpwrvgnd_1
X_06777_ cell0.CB_1.config_dataA\[24\] cell0.CB_1.config_dataA\[20\] cell0.CB_1.config_dataA\[21\]
+ vssd1 vssd1 vccd1 vccd1 _01847_ sky130_fd_sc_hd__or3b_2
XFILLER_130_69 vssd1 vssd1 vccd1 vccd1 sky130_fd_sc_hd__fill_1
X_09496_ net277 net48 _04514_ vssd1 vssd1 vccd1 vccd1 _04517_ sky130_fd_sc_hd__mux2_1
XFILLER_82_197 vssd1 vssd1 vccd1 vccd1 sky130_fd_sc_hd__fill_4
X_08516_ net1 net12 net23 net26 net494 net493 vssd1 vssd1 vccd1 vccd1 _03552_ sky130_fd_sc_hd__mux4_1
XANTENNA__07370__B _02422_ vssd1 vssd1 vccd1 vccd1 sky130_fd_sc_hd__diode_2
XTAP_TAPCELL_ROW_104_1869 vssd1 vccd1 sky130_fd_sc_hd__tapvpwrvgnd_1
XFILLER_90_29 vccd1 vssd1 vccd1 vssd1 sky130_ef_sc_hd__decap_40_12
XANTENNA_fanout330_X net330 vssd1 vssd1 vccd1 vccd1 sky130_fd_sc_hd__diode_2
X_08447_ _03481_ _03482_ _01664_ vssd1 vssd1 vccd1 vccd1 _03483_ sky130_fd_sc_hd__mux2_1
XFILLER_11_404 vssd1 vssd1 vccd1 vccd1 sky130_fd_sc_hd__fill_4
XANTENNA_fanout807_A net855 vssd1 vssd1 vccd1 vccd1 sky130_fd_sc_hd__diode_2
XTAP_TAPCELL_ROW_137_2368 vssd1 vccd1 sky130_fd_sc_hd__tapvpwrvgnd_1
XTAP_TAPCELL_ROW_137_2357 vssd1 vccd1 sky130_fd_sc_hd__tapvpwrvgnd_1
X_08378_ cell0.LE_1B.config_data\[7\] cell0.LE_1B.config_data\[6\] _03380_ vssd1 vssd1
+ vccd1 vccd1 _03416_ sky130_fd_sc_hd__mux2_1
XANTENNA__08482__A _03517_ vssd1 vssd1 vccd1 vccd1 sky130_fd_sc_hd__diode_2
XANTENNA__09810__A1 bus3_2\[5\] vssd1 vssd1 vccd1 vccd1 sky130_fd_sc_hd__diode_2
XANTENNA__09810__B2 bus3_2\[4\] vssd1 vssd1 vccd1 vccd1 sky130_fd_sc_hd__diode_2
X_07329_ cell0.SB0.route_sel\[101\] _01477_ cell0.SB0.route_sel\[99\] cell0.SB0.route_sel\[98\]
+ _02385_ vssd1 vssd1 vccd1 vccd1 _02386_ sky130_fd_sc_hd__o221a_1
X_10340_ cell2.CB_0.config_dataB\[2\] _05338_ vssd1 vssd1 vccd1 vccd1 _05339_ sky130_fd_sc_hd__nand2_1
X_10271_ cell2.LE_0A.config_data\[9\] cell2.LE_0A.config_data\[8\] _05196_ vssd1 vssd1
+ vccd1 vccd1 _05272_ sky130_fd_sc_hd__mux2_1
XFILLER_3_669 vssd1 vssd1 vccd1 vccd1 sky130_fd_sc_hd__fill_2
X_12010_ cell0.SB0.route_sel\[116\] cell0.SB0.route_sel\[115\] net765 vssd1 vssd1
+ vccd1 vccd1 _00447_ sky130_fd_sc_hd__mux2_1
XANTENNA__10184__A1 _05111_ vssd1 vssd1 vccd1 vccd1 sky130_fd_sc_hd__diode_2
XFILLER_78_415 vssd1 vssd1 vccd1 vccd1 sky130_fd_sc_hd__fill_4
XANTENNA__08421__S _03347_ vssd1 vssd1 vccd1 vccd1 sky130_fd_sc_hd__diode_2
Xfanout450 cell1.CB_1.config_dataB\[22\] vssd1 vssd1 vccd1 vccd1 net450 sky130_fd_sc_hd__clkbuf_2
X_13961_ clknet_leaf_36_clk _00933_ net645 vssd1 vssd1 vccd1 vccd1 cell2.LEI0.config_data\[18\]
+ sky130_fd_sc_hd__dfrtp_1
XFILLER_93_418 vssd1 vssd1 vccd1 vccd1 sky130_fd_sc_hd__fill_2
Xfanout483 cell1.CB_0.config_dataB\[5\] vssd1 vssd1 vccd1 vccd1 net483 sky130_fd_sc_hd__dlymetal6s2s_1
Xfanout472 cell1.CB_0.config_dataA\[1\] vssd1 vssd1 vccd1 vccd1 net472 sky130_fd_sc_hd__buf_2
Xfanout461 cell1.CB_1.config_dataB\[0\] vssd1 vssd1 vccd1 vccd1 net461 sky130_fd_sc_hd__clkbuf_2
XFILLER_19_515 vssd1 vssd1 vccd1 vccd1 sky130_fd_sc_hd__fill_1
X_12912_ net1510 cell3.LE_0B.reset_mode net956 vssd1 vssd1 vccd1 vccd1 _01341_ sky130_fd_sc_hd__mux2_1
Xfanout494 cell1.CB_1.config_dataA\[5\] vssd1 vssd1 vccd1 vccd1 net494 sky130_fd_sc_hd__buf_2
X_13892_ clknet_leaf_40_clk _00864_ net644 vssd1 vssd1 vccd1 vccd1 cell2.LE_1A.config_data\[15\]
+ sky130_fd_sc_hd__dfrtp_1
XFILLER_0_27 vssd1 vssd1 vccd1 vccd1 sky130_fd_sc_hd__fill_1
XANTENNA__07561__A net338 vssd1 vssd1 vccd1 vccd1 sky130_fd_sc_hd__diode_2
XFILLER_19_559 vssd1 vssd1 vccd1 vccd1 sky130_fd_sc_hd__fill_1
XANTENNA__08657__A net458 vssd1 vssd1 vccd1 vccd1 sky130_fd_sc_hd__diode_2
XANTENNA_input128_X net128 vssd1 vssd1 vccd1 vccd1 sky130_fd_sc_hd__diode_2
X_12843_ cell2.SB0.route_sel\[85\] cell2.SB0.route_sel\[84\] net797 vssd1 vssd1 vccd1
+ vccd1 _01272_ sky130_fd_sc_hd__mux2_1
XANTENNA__10239__A2 _05131_ vssd1 vssd1 vccd1 vccd1 sky130_fd_sc_hd__diode_2
X_12774_ cell2.SB0.route_sel\[16\] cell2.SB0.route_sel\[15\] net829 vssd1 vssd1 vccd1
+ vccd1 _01203_ sky130_fd_sc_hd__mux2_1
X_11725_ net755 _03163_ vssd1 vssd1 vccd1 vccd1 _06375_ sky130_fd_sc_hd__nand2_1
XANTENNA__08301__B2 _02807_ vssd1 vssd1 vccd1 vccd1 sky130_fd_sc_hd__diode_2
XANTENNA__08301__A1 _02846_ vssd1 vssd1 vccd1 vccd1 sky130_fd_sc_hd__diode_2
X_14444_ clknet_leaf_67_clk net1482 net734 vssd1 vssd1 vccd1 vccd1 cell3.LEI0.config_data\[9\]
+ sky130_fd_sc_hd__dfrtp_1
XFILLER_42_584 vssd1 vssd1 vccd1 vccd1 sky130_fd_sc_hd__fill_1
XFILLER_9_69 vccd1 vssd1 vccd1 vssd1 sky130_ef_sc_hd__decap_40_12
XANTENNA_input93_X net93 vssd1 vssd1 vccd1 vccd1 sky130_fd_sc_hd__diode_2
X_11656_ cell0.CB_1.config_dataB\[2\] cell0.CB_1.config_dataB\[1\] net789 vssd1 vssd1
+ vccd1 vccd1 _00097_ sky130_fd_sc_hd__mux2_1
X_14375_ clknet_leaf_65_clk _01347_ net744 vssd1 vssd1 vccd1 vccd1 cell3.LE_1A.config_data\[6\]
+ sky130_fd_sc_hd__dfrtp_1
X_10607_ net398 net396 vssd1 vssd1 vccd1 vccd1 _05565_ sky130_fd_sc_hd__nor2_1
X_11587_ cell0.CB_1.config_dataA\[8\] cell0.CB_1.config_dataA\[7\] net788 vssd1 vssd1
+ vccd1 vccd1 _00028_ sky130_fd_sc_hd__mux2_1
XANTENNA__08604__A2 _03486_ vssd1 vssd1 vccd1 vccd1 sky130_fd_sc_hd__diode_2
XTAP_TAPCELL_ROW_12_487 vssd1 vccd1 sky130_fd_sc_hd__tapvpwrvgnd_1
X_10538_ net394 _05494_ _05495_ vssd1 vssd1 vccd1 vccd1 _05496_ sky130_fd_sc_hd__a21o_1
X_13326_ clknet_leaf_86_clk _00298_ net685 vssd1 vssd1 vccd1 vccd1 cell1.CB_0.config_dataB\[17\]
+ sky130_fd_sc_hd__dfstp_2
XTAP_TAPCELL_ROW_77_1459 vssd1 vccd1 sky130_fd_sc_hd__tapvpwrvgnd_1
X_13257_ clknet_leaf_10_clk _00229_ net585 vssd1 vssd1 vccd1 vccd1 cell0.LEI0.config_data\[42\]
+ sky130_fd_sc_hd__dfrtp_1
X_10469_ cell3.SB0.route_sel\[116\] cell3.SB0.route_sel\[117\] vssd1 vssd1 vccd1 vccd1
+ _05453_ sky130_fd_sc_hd__nand2b_1
XANTENNA__09935__B _04724_ vssd1 vssd1 vccd1 vccd1 sky130_fd_sc_hd__diode_2
X_12208_ cell2.CB_1.config_dataA\[21\] cell2.CB_1.config_dataA\[20\] net834 vssd1
+ vssd1 vccd1 vccd1 _00641_ sky130_fd_sc_hd__mux2_1
XANTENNA__07736__A _02780_ vssd1 vssd1 vccd1 vccd1 sky130_fd_sc_hd__diode_2
XANTENNA__06911__Y _01979_ vssd1 vssd1 vccd1 vccd1 sky130_fd_sc_hd__diode_2
XFILLER_130_309 vssd1 vssd1 vccd1 vccd1 sky130_fd_sc_hd__fill_1
XANTENNA__10175__A1 net62 vssd1 vssd1 vccd1 vccd1 sky130_fd_sc_hd__diode_2
XTAP_TAPCELL_ROW_90_1659 vssd1 vccd1 sky130_fd_sc_hd__tapvpwrvgnd_1
X_13188_ clknet_leaf_13_clk _00160_ net589 vssd1 vssd1 vccd1 vccd1 cell0.LE_0B.edge_mode
+ sky130_fd_sc_hd__dfstp_1
XFILLER_123_383 vssd1 vssd1 vccd1 vccd1 sky130_fd_sc_hd__fill_1
X_12139_ cell1.LEI0.config_data\[21\] net1103 net903 vssd1 vssd1 vccd1 vccd1 _00572_
+ sky130_fd_sc_hd__mux2_1
XFILLER_97_779 vssd1 vssd1 vccd1 vccd1 sky130_fd_sc_hd__fill_1
XFILLER_84_418 vssd1 vssd1 vccd1 vccd1 sky130_fd_sc_hd__fill_2
XFILLER_29_3 vccd1 vssd1 vccd1 vssd1 sky130_ef_sc_hd__decap_40_12
X_06700_ cell2.CB_0.config_dataA\[12\] vssd1 vssd1 vccd1 vccd1 _01770_ sky130_fd_sc_hd__inv_2
X_07680_ net320 net23 _02726_ vssd1 vssd1 vccd1 vccd1 _02728_ sky130_fd_sc_hd__mux2_1
XTAP_TAPCELL_ROW_121_2125 vssd1 vccd1 sky130_fd_sc_hd__tapvpwrvgnd_1
X_06631_ cell3.SB0.route_sel\[38\] vssd1 vssd1 vccd1 vccd1 _01701_ sky130_fd_sc_hd__inv_2
X_09350_ cell3.SB0.route_sel\[32\] cell3.SB0.route_sel\[33\] vssd1 vssd1 vccd1 vccd1
+ _04374_ sky130_fd_sc_hd__and2_1
X_06562_ cell2.SB0.route_sel\[86\] vssd1 vssd1 vccd1 vccd1 _01632_ sky130_fd_sc_hd__inv_2
XFILLER_80_679 vssd1 vssd1 vccd1 vccd1 sky130_fd_sc_hd__fill_2
X_09281_ cell3.CB_1.config_dataB\[24\] cell3.CB_1.config_dataB\[20\] cell3.CB_1.config_dataB\[21\]
+ vssd1 vssd1 vccd1 vccd1 _04307_ sky130_fd_sc_hd__or3b_2
X_08301_ _02846_ _03315_ _03316_ _02807_ _01491_ vssd1 vssd1 vccd1 vccd1 _03339_ sky130_fd_sc_hd__a221o_1
XFILLER_138_409 vssd1 vssd1 vccd1 vccd1 sky130_fd_sc_hd__fill_2
XANTENNA__11280__X net170 vssd1 vssd1 vccd1 vccd1 sky130_fd_sc_hd__diode_2
X_06493_ cell0.LE_0B.config_data\[16\] vssd1 vssd1 vccd1 vccd1 _01563_ sky130_fd_sc_hd__inv_2
X_08232_ _02422_ _02424_ _03266_ vssd1 vssd1 vccd1 vccd1 _03272_ sky130_fd_sc_hd__o21ai_1
XFILLER_21_779 vssd1 vssd1 vccd1 vccd1 sky130_fd_sc_hd__fill_1
XTAP_TAPCELL_ROW_119_2087 vssd1 vccd1 sky130_fd_sc_hd__tapvpwrvgnd_1
XANTENNA__08056__A0 bus2_0\[12\] vssd1 vssd1 vccd1 vccd1 sky130_fd_sc_hd__diode_2
X_08163_ net541 net542 vssd1 vssd1 vccd1 vccd1 _03203_ sky130_fd_sc_hd__and2b_1
XTAP_TAPCELL_ROW_31_774 vssd1 vccd1 sky130_fd_sc_hd__tapvpwrvgnd_1
XANTENNA__10402__A2 _05148_ vssd1 vssd1 vccd1 vccd1 sky130_fd_sc_hd__diode_2
XTAP_TAPCELL_ROW_119_2098 vssd1 vccd1 sky130_fd_sc_hd__tapvpwrvgnd_1
XFILLER_118_144 vssd1 vssd1 vccd1 vccd1 sky130_fd_sc_hd__fill_1
XFILLER_109_15 vccd1 vssd1 vccd1 vssd1 sky130_ef_sc_hd__decap_40_12
X_07114_ cell2.SB0.route_sel\[75\] cell2.SB0.route_sel\[74\] _02174_ _02176_ _02169_
+ vssd1 vssd1 vccd1 vccd1 _02177_ sky130_fd_sc_hd__a41o_1
X_08094_ bus2_0\[0\] bus2_0\[1\] bus2_0\[2\] bus2_0\[3\] net525 net523 vssd1 vssd1
+ vccd1 vccd1 _03136_ sky130_fd_sc_hd__mux4_1
XFILLER_109_59 vssd1 vssd1 vccd1 vccd1 sky130_fd_sc_hd__fill_1
XFILLER_106_317 vssd1 vssd1 vccd1 vccd1 sky130_fd_sc_hd__fill_1
Xclkload60 clknet_leaf_45_clk vssd1 vssd1 vccd1 vccd1 clkload60/Y sky130_fd_sc_hd__clkinv_8
X_07045_ cell0.CB_1.config_dataA\[24\] cell0.CB_1.config_dataA\[21\] cell0.CB_1.config_dataA\[20\]
+ vssd1 vssd1 vccd1 vccd1 _02109_ sky130_fd_sc_hd__or3b_2
Xclkload71 clknet_leaf_106_clk vssd1 vssd1 vccd1 vccd1 clkload71/Y sky130_fd_sc_hd__inv_6
XTAP_TAPCELL_ROW_132_2287 vssd1 vccd1 sky130_fd_sc_hd__tapvpwrvgnd_1
Xclkload93 clknet_leaf_86_clk vssd1 vssd1 vccd1 vccd1 clkload93/Y sky130_fd_sc_hd__inv_6
Xclkload82 clknet_leaf_114_clk vssd1 vssd1 vccd1 vccd1 clkload82/Y sky130_fd_sc_hd__inv_6
XFILLER_0_606 vssd1 vssd1 vccd1 vccd1 sky130_fd_sc_hd__fill_2
XFILLER_0_617 vssd1 vssd1 vccd1 vccd1 sky130_fd_sc_hd__fill_2
XFILLER_0_628 vssd1 vssd1 vccd1 vccd1 sky130_fd_sc_hd__fill_4
X_08996_ _04024_ _04025_ _04022_ vssd1 vssd1 vccd1 vccd1 _04026_ sky130_fd_sc_hd__o21ba_1
XFILLER_125_69 vssd1 vssd1 vccd1 vccd1 sky130_fd_sc_hd__fill_4
XANTENNA__11115__A0 net40 vssd1 vssd1 vccd1 vccd1 sky130_fd_sc_hd__diode_2
XFILLER_102_578 vssd1 vssd1 vccd1 vccd1 sky130_fd_sc_hd__fill_8
X_07947_ bus2_0\[0\] bus2_0\[1\] bus2_0\[2\] bus2_0\[3\] net513 cell0.CB_0.config_dataA\[16\]
+ vssd1 vssd1 vccd1 vccd1 _02991_ sky130_fd_sc_hd__mux4_1
XFILLER_68_470 vssd1 vssd1 vccd1 vccd1 sky130_fd_sc_hd__fill_4
XANTENNA_hold168_A cell2.LE_0A.config_data\[16\] vssd1 vssd1 vccd1 vccd1 sky130_fd_sc_hd__diode_2
X_07878_ _02890_ _02920_ _02921_ _02887_ _01569_ vssd1 vssd1 vccd1 vccd1 _02922_ sky130_fd_sc_hd__a221o_1
XFILLER_141_57 vccd1 vssd1 vccd1 vssd1 sky130_ef_sc_hd__decap_40_12
X_09617_ _04633_ _04631_ vssd1 vssd1 vccd1 vccd1 bus3_1\[11\] sky130_fd_sc_hd__and2b_2
XTAP_TAPCELL_ROW_48_1027 vssd1 vccd1 sky130_fd_sc_hd__tapvpwrvgnd_1
XTAP_TAPCELL_ROW_39_896 vssd1 vccd1 sky130_fd_sc_hd__tapvpwrvgnd_1
X_06829_ cell1.SB0.route_sel\[50\] _01518_ cell1.SB0.route_sel\[53\] _01519_ _01898_
+ vssd1 vssd1 vccd1 vccd1 _01899_ sky130_fd_sc_hd__a221o_1
X_09548_ net18 net287 _04566_ vssd1 vssd1 vccd1 vccd1 _04567_ sky130_fd_sc_hd__mux2_1
XFILLER_34_22 vssd1 vssd1 vccd1 vccd1 sky130_fd_sc_hd__fill_4
XANTENNA__09087__A2 net337 vssd1 vssd1 vccd1 vccd1 sky130_fd_sc_hd__diode_2
XANTENNA__12091__A1 cell1.LE_0B.reset_val vssd1 vssd1 vccd1 vccd1 sky130_fd_sc_hd__diode_2
XANTENNA__08295__A0 bus1_0\[6\] vssd1 vssd1 vccd1 vccd1 sky130_fd_sc_hd__diode_2
X_11510_ _06340_ _02008_ vssd1 vssd1 vccd1 vccd1 net245 sky130_fd_sc_hd__and2b_1
X_09479_ cell3.SB0.route_sel\[60\] cell3.SB0.route_sel\[61\] vssd1 vssd1 vccd1 vccd1
+ _04500_ sky130_fd_sc_hd__nand2_2
XTAP_TAPCELL_ROW_61_1227 vssd1 vccd1 sky130_fd_sc_hd__tapvpwrvgnd_1
XTAP_TAPCELL_ROW_61_1216 vssd1 vccd1 sky130_fd_sc_hd__tapvpwrvgnd_1
XFILLER_24_584 vssd1 vssd1 vccd1 vccd1 sky130_fd_sc_hd__fill_1
XFILLER_34_77 vssd1 vssd1 vccd1 vccd1 sky130_fd_sc_hd__fill_4
XFILLER_133_3 vccd1 vssd1 vccd1 vssd1 sky130_ef_sc_hd__decap_40_12
X_12490_ net1428 cell2.LEI0.config_data\[3\] net841 vssd1 vssd1 vccd1 vccd1 _00919_
+ sky130_fd_sc_hd__mux2_1
X_11441_ _02655_ _06294_ vssd1 vssd1 vccd1 vccd1 net205 sky130_fd_sc_hd__nor2_2
XFILLER_109_133 vssd1 vssd1 vccd1 vccd1 sky130_fd_sc_hd__fill_1
X_14160_ clknet_leaf_72_clk _01132_ net728 vssd1 vssd1 vccd1 vccd1 cell3.CB_1.config_dataA\[20\]
+ sky130_fd_sc_hd__dfstp_1
X_11372_ _02804_ _06248_ vssd1 vssd1 vccd1 vccd1 net256 sky130_fd_sc_hd__and2_1
XANTENNA__08598__B2 _03537_ vssd1 vssd1 vccd1 vccd1 sky130_fd_sc_hd__diode_2
XANTENNA__08598__A1 _03540_ vssd1 vssd1 vccd1 vccd1 sky130_fd_sc_hd__diode_2
X_10323_ net59 _05312_ _05313_ net60 cell2.CB_0.config_dataB\[3\] vssd1 vssd1 vccd1
+ vccd1 _05322_ sky130_fd_sc_hd__a221o_1
X_13111_ clknet_leaf_5_clk _00083_ net567 vssd1 vssd1 vccd1 vccd1 cell0.CB_0.config_dataA\[13\]
+ sky130_fd_sc_hd__dfstp_1
X_14091_ clknet_leaf_76_clk _01063_ net726 vssd1 vssd1 vccd1 vccd1 cell3.SB0.route_sel\[99\]
+ sky130_fd_sc_hd__dfstp_1
XTAP_TAPCELL_ROW_59_1189 vssd1 vccd1 sky130_fd_sc_hd__tapvpwrvgnd_1
XANTENNA_input53_A CBnorth_in[28] vssd1 vssd1 vccd1 vccd1 sky130_fd_sc_hd__diode_2
X_10254_ net413 _05088_ _05254_ net411 vssd1 vssd1 vccd1 vccd1 _05255_ sky130_fd_sc_hd__o211a_1
XANTENNA__10157__A1 net33 vssd1 vssd1 vccd1 vccd1 sky130_fd_sc_hd__diode_2
X_13042_ clknet_leaf_119_clk _00014_ net594 vssd1 vssd1 vccd1 vccd1 cell0.LE_1B.config_data\[14\]
+ sky130_fd_sc_hd__dfrtp_1
X_10185_ net421 _05084_ vssd1 vssd1 vccd1 vccd1 _05186_ sky130_fd_sc_hd__nand2_1
XTAP_TAPCELL_ROW_72_1389 vssd1 vccd1 sky130_fd_sc_hd__tapvpwrvgnd_1
Xfanout280 cell3.CB_0.le_outB vssd1 vssd1 vccd1 vccd1 net280 sky130_fd_sc_hd__dlymetal6s2s_1
Xfanout291 cell3.CB_1.le_outB vssd1 vssd1 vccd1 vccd1 net291 sky130_fd_sc_hd__clkbuf_2
X_13944_ clknet_leaf_43_clk _00916_ net635 vssd1 vssd1 vccd1 vccd1 cell2.LEI0.config_data\[1\]
+ sky130_fd_sc_hd__dfrtp_1
XANTENNA__11525__B net319 vssd1 vssd1 vccd1 vccd1 sky130_fd_sc_hd__diode_2
X_13875_ clknet_leaf_15_clk _00847_ net625 vssd1 vssd1 vccd1 vccd1 cell2.CB_1.config_dataB\[24\]
+ sky130_fd_sc_hd__dfstp_2
X_12826_ cell2.SB0.route_sel\[68\] cell2.SB0.route_sel\[67\] net815 vssd1 vssd1 vccd1
+ vccd1 _01255_ sky130_fd_sc_hd__mux2_1
XTAP_TAPCELL_ROW_17_557 vssd1 vccd1 sky130_fd_sc_hd__tapvpwrvgnd_1
XTAP_TAPCELL_ROW_17_568 vssd1 vccd1 sky130_fd_sc_hd__tapvpwrvgnd_1
X_12757_ cell3.CB_0.config_dataA\[24\] cell3.CB_0.config_dataA\[23\] net930 vssd1
+ vssd1 vccd1 vccd1 _01186_ sky130_fd_sc_hd__mux2_1
XANTENNA__09483__C1 _04500_ vssd1 vssd1 vccd1 vccd1 sky130_fd_sc_hd__diode_2
X_12688_ cell3.CB_1.config_dataA\[5\] cell3.CB_1.config_dataA\[4\] net937 vssd1 vssd1
+ vccd1 vccd1 _01117_ sky130_fd_sc_hd__mux2_1
X_11708_ net1242 cell0.LE_0B.config_data\[3\] net804 vssd1 vssd1 vccd1 vccd1 _00147_
+ sky130_fd_sc_hd__mux2_1
X_14427_ clknet_leaf_55_clk _01399_ net718 vssd1 vssd1 vccd1 vccd1 cell3.LE_0A.config_data\[14\]
+ sky130_fd_sc_hd__dfrtp_1
XANTENNA__09235__C1 _04249_ vssd1 vssd1 vccd1 vccd1 sky130_fd_sc_hd__diode_2
X_11639_ net516 cell0.CB_0.config_dataA\[9\] net771 vssd1 vssd1 vccd1 vccd1 _00080_
+ sky130_fd_sc_hd__mux2_1
XFILLER_30_587 vssd1 vssd1 vccd1 vccd1 sky130_fd_sc_hd__fill_1
X_14358_ clknet_leaf_71_clk _01330_ net730 vssd1 vssd1 vccd1 vccd1 cell3.CB_1.config_dataB\[15\]
+ sky130_fd_sc_hd__dfstp_1
XANTENNA__08589__A1 net12 vssd1 vssd1 vccd1 vccd1 sky130_fd_sc_hd__diode_2
X_13309_ clknet_leaf_83_clk _00281_ net670 vssd1 vssd1 vccd1 vccd1 cell1.CB_0.config_dataB\[0\]
+ sky130_fd_sc_hd__dfstp_1
XANTENNA_clkbuf_leaf_3_clk_A clknet_4_1_0_clk vssd1 vssd1 vccd1 vccd1 sky130_fd_sc_hd__diode_2
XANTENNA__10444__X bus3_2\[5\] vssd1 vssd1 vccd1 vccd1 sky130_fd_sc_hd__diode_2
X_14289_ clknet_leaf_8_clk _01261_ net572 vssd1 vssd1 vccd1 vccd1 cell2.SB0.route_sel\[74\]
+ sky130_fd_sc_hd__dfstp_1
XANTENNA__11345__A0 _05883_ vssd1 vssd1 vccd1 vccd1 sky130_fd_sc_hd__diode_2
XFILLER_69_234 vssd1 vssd1 vccd1 vccd1 sky130_fd_sc_hd__fill_1
XFILLER_69_223 vssd1 vssd1 vccd1 vccd1 sky130_fd_sc_hd__fill_1
X_08850_ net470 _03881_ vssd1 vssd1 vccd1 vccd1 _03882_ sky130_fd_sc_hd__nand2_1
XFILLER_85_716 vccd1 vssd1 vccd1 vssd1 sky130_ef_sc_hd__decap_40_12
XANTENNA__08849__X _03881_ vssd1 vssd1 vccd1 vccd1 sky130_fd_sc_hd__diode_2
X_07801_ _02843_ _02844_ _02845_ _02842_ vssd1 vssd1 vccd1 vccd1 _02846_ sky130_fd_sc_hd__a31o_4
XFILLER_111_397 vssd1 vssd1 vccd1 vccd1 sky130_fd_sc_hd__fill_1
X_08781_ cell1.LE_1B.config_data\[16\] _03812_ _03813_ net352 vssd1 vssd1 vccd1 vccd1
+ cell1.CB_1.le_outB sky130_fd_sc_hd__o211a_1
XFILLER_38_643 vssd1 vssd1 vccd1 vccd1 sky130_fd_sc_hd__fill_1
X_07732_ cell1.SB0.route_sel\[24\] cell1.SB0.route_sel\[25\] _02778_ vssd1 vssd1 vccd1
+ vccd1 _02779_ sky130_fd_sc_hd__a21oi_1
XFILLER_93_793 vssd1 vssd1 vccd1 vccd1 sky130_fd_sc_hd__fill_1
X_07663_ net342 _02710_ vssd1 vssd1 vccd1 vccd1 _02711_ sky130_fd_sc_hd__nand2_1
XFILLER_1_81 vccd1 vssd1 vccd1 vssd1 sky130_ef_sc_hd__decap_40_12
XFILLER_111_27 vccd1 vssd1 vccd1 vssd1 sky130_ef_sc_hd__decap_40_12
X_09402_ _01901_ _02162_ vssd1 vssd1 vccd1 vccd1 _04425_ sky130_fd_sc_hd__or2_2
XFILLER_80_432 vssd1 vssd1 vccd1 vccd1 sky130_fd_sc_hd__fill_2
X_06614_ cell1.LE_0A.config_data\[16\] vssd1 vssd1 vccd1 vccd1 _01684_ sky130_fd_sc_hd__inv_2
XTAP_TAPCELL_ROW_36_844 vssd1 vccd1 sky130_fd_sc_hd__tapvpwrvgnd_1
X_09333_ cell3.CB_1.config_dataB\[24\] cell3.CB_1.config_dataB\[20\] cell3.CB_1.config_dataB\[21\]
+ vssd1 vssd1 vccd1 vccd1 _04358_ sky130_fd_sc_hd__and3b_1
X_07594_ cell1.SB0.route_sel\[2\] cell1.SB0.route_sel\[3\] _02643_ vssd1 vssd1 vccd1
+ vccd1 _02644_ sky130_fd_sc_hd__a21oi_1
XTAP_TAPCELL_ROW_36_855 vssd1 vccd1 sky130_fd_sc_hd__tapvpwrvgnd_1
XTAP_TAPCELL_ROW_101_1828 vssd1 vccd1 sky130_fd_sc_hd__tapvpwrvgnd_1
XTAP_TAPCELL_ROW_101_1817 vssd1 vccd1 sky130_fd_sc_hd__tapvpwrvgnd_1
X_06545_ cell2.SB0.route_sel\[52\] vssd1 vssd1 vccd1 vccd1 _01615_ sky130_fd_sc_hd__inv_2
Xclkbuf_leaf_126_clk clknet_4_2_0_clk vssd1 vssd1 vccd1 vccd1 clknet_leaf_126_clk
+ sky130_fd_sc_hd__clkbuf_8
XANTENNA_fanout338_A net340 vssd1 vssd1 vccd1 vccd1 sky130_fd_sc_hd__diode_2
XANTENNA__08744__B _03489_ vssd1 vssd1 vccd1 vccd1 sky130_fd_sc_hd__diode_2
X_09264_ cell2.CB_0.config_dataB\[22\] cell2.CB_0.config_dataB\[23\] _01919_ vssd1
+ vssd1 vccd1 vccd1 _04290_ sky130_fd_sc_hd__or3_1
X_06476_ cell1.SB0.route_sel\[110\] vssd1 vssd1 vccd1 vccd1 _01546_ sky130_fd_sc_hd__inv_2
XTAP_TAPCELL_ROW_134_2316 vssd1 vccd1 sky130_fd_sc_hd__tapvpwrvgnd_1
X_09195_ _04222_ _04206_ vssd1 vssd1 vccd1 vccd1 _04223_ sky130_fd_sc_hd__and2b_1
X_08215_ _02678_ _03233_ _03234_ _02633_ _03254_ vssd1 vssd1 vccd1 vccd1 _03255_ sky130_fd_sc_hd__a221o_1
XANTENNA__08463__C _03498_ vssd1 vssd1 vccd1 vccd1 sky130_fd_sc_hd__diode_2
XFILLER_5_709 vccd1 vssd1 vccd1 vssd1 sky130_ef_sc_hd__decap_40_12
X_08146_ net545 _03184_ _03185_ vssd1 vssd1 vccd1 vccd1 _03186_ sky130_fd_sc_hd__a21o_1
X_08077_ cell0.CB_0.config_dataB\[13\] cell0.CB_0.config_dataB\[12\] _03117_ _03116_
+ vssd1 vssd1 vccd1 vccd1 _03119_ sky130_fd_sc_hd__o31a_1
XFILLER_134_489 vssd1 vssd1 vccd1 vccd1 sky130_fd_sc_hd__fill_1
XANTENNA__09529__B1 _04548_ vssd1 vssd1 vccd1 vccd1 sky130_fd_sc_hd__diode_2
X_07028_ cell2.SB0.route_sel\[67\] cell2.SB0.route_sel\[66\] _02091_ _02092_ vssd1
+ vssd1 vccd1 vccd1 _02093_ sky130_fd_sc_hd__a211oi_1
XFILLER_0_436 vssd1 vssd1 vccd1 vccd1 sky130_fd_sc_hd__fill_4
Xhold11 cell3.LE_0A.dff0_out vssd1 vssd1 vccd1 vccd1 net970 sky130_fd_sc_hd__dlygate4sd3_1
Xhold22 _00860_ vssd1 vssd1 vccd1 vccd1 net981 sky130_fd_sc_hd__dlygate4sd3_1
XANTENNA__07617__B1_N net76 vssd1 vssd1 vccd1 vccd1 sky130_fd_sc_hd__diode_2
XANTENNA__08752__A1 net12 vssd1 vssd1 vccd1 vccd1 sky130_fd_sc_hd__diode_2
Xhold55 _01367_ vssd1 vssd1 vccd1 vccd1 net1014 sky130_fd_sc_hd__dlygate4sd3_1
X_08979_ cell1.LE_0A.config_data\[13\] cell1.LE_0A.config_data\[12\] _03936_ vssd1
+ vssd1 vccd1 vccd1 _04011_ sky130_fd_sc_hd__mux2_1
Xhold44 cell1.LE_0A.config_data\[15\] vssd1 vssd1 vccd1 vccd1 net1003 sky130_fd_sc_hd__dlygate4sd3_1
Xhold33 _00498_ vssd1 vssd1 vccd1 vccd1 net992 sky130_fd_sc_hd__dlygate4sd3_1
XANTENNA__08478__Y _03514_ vssd1 vssd1 vccd1 vccd1 sky130_fd_sc_hd__diode_2
XFILLER_29_55 vssd1 vssd1 vccd1 vccd1 sky130_fd_sc_hd__fill_1
Xhold88 _00856_ vssd1 vssd1 vccd1 vccd1 net1047 sky130_fd_sc_hd__dlygate4sd3_1
Xhold99 _00896_ vssd1 vssd1 vccd1 vccd1 net1058 sky130_fd_sc_hd__dlygate4sd3_1
Xhold66 cell1.LE_0B.config_data\[8\] vssd1 vssd1 vccd1 vccd1 net1025 sky130_fd_sc_hd__dlygate4sd3_1
Xhold77 _00565_ vssd1 vssd1 vccd1 vccd1 net1036 sky130_fd_sc_hd__dlygate4sd3_1
XFILLER_28_131 vssd1 vssd1 vccd1 vccd1 sky130_fd_sc_hd__fill_8
X_11990_ cell0.SB0.route_sel\[96\] cell0.SB0.route_sel\[95\] net785 vssd1 vssd1 vccd1
+ vccd1 _00427_ sky130_fd_sc_hd__mux2_1
X_10941_ _01806_ _05890_ _05894_ vssd1 vssd1 vccd1 vccd1 _05895_ sky130_fd_sc_hd__o21ai_1
XFILLER_90_218 vssd1 vssd1 vccd1 vccd1 sky130_fd_sc_hd__fill_8
XFILLER_45_10 vssd1 vssd1 vccd1 vccd1 sky130_fd_sc_hd__fill_1
XFILLER_16_315 vssd1 vssd1 vccd1 vccd1 sky130_fd_sc_hd__fill_1
X_13660_ clknet_leaf_48_clk _00632_ net704 vssd1 vssd1 vccd1 vccd1 cell2.CB_1.config_dataA\[12\]
+ sky130_fd_sc_hd__dfstp_2
XFILLER_83_281 vssd1 vssd1 vccd1 vccd1 sky130_fd_sc_hd__fill_4
X_10872_ _05827_ vssd1 vssd1 vccd1 vccd1 _05828_ sky130_fd_sc_hd__inv_2
X_12611_ cell3.SB0.route_sel\[76\] cell3.SB0.route_sel\[75\] net805 vssd1 vssd1 vccd1
+ vccd1 _01040_ sky130_fd_sc_hd__mux2_1
X_13591_ clknet_leaf_89_clk _00563_ net696 vssd1 vssd1 vccd1 vccd1 cell1.LEI0.config_data\[12\]
+ sky130_fd_sc_hd__dfrtp_1
Xclkbuf_leaf_117_clk clknet_4_9_0_clk vssd1 vssd1 vccd1 vccd1 clknet_leaf_117_clk
+ sky130_fd_sc_hd__clkbuf_8
XTAP_TAPCELL_ROW_14_516 vssd1 vccd1 sky130_fd_sc_hd__tapvpwrvgnd_1
XFILLER_24_370 vssd1 vssd1 vccd1 vccd1 sky130_fd_sc_hd__fill_1
XANTENNA__10614__A2 net19 vssd1 vssd1 vccd1 vccd1 sky130_fd_sc_hd__diode_2
X_12542_ cell3.SB0.route_sel\[7\] cell3.SB0.route_sel\[6\] net919 vssd1 vssd1 vccd1
+ vccd1 _00971_ sky130_fd_sc_hd__mux2_1
XFILLER_129_228 vssd1 vssd1 vccd1 vccd1 sky130_fd_sc_hd__fill_1
X_12473_ net1076 cell2.LE_0A.config_data\[9\] net814 vssd1 vssd1 vccd1 vccd1 _00903_
+ sky130_fd_sc_hd__mux2_1
XANTENNA__07491__A1 _01933_ vssd1 vssd1 vccd1 vccd1 sky130_fd_sc_hd__diode_2
XFILLER_138_740 vccd1 vssd1 vccd1 vssd1 sky130_ef_sc_hd__decap_40_12
X_14212_ clknet_leaf_58_clk _01184_ net723 vssd1 vssd1 vccd1 vccd1 cell3.CB_0.config_dataA\[22\]
+ sky130_fd_sc_hd__dfstp_1
XANTENNA__09768__A0 bus3_2\[6\] vssd1 vssd1 vccd1 vccd1 sky130_fd_sc_hd__diode_2
X_11424_ cell0.SB0.route_sel\[104\] cell0.SB0.route_sel\[105\] vssd1 vssd1 vccd1 vccd1
+ _06283_ sky130_fd_sc_hd__nor2_1
XFILLER_6_15 vccd1 vssd1 vccd1 vssd1 sky130_ef_sc_hd__decap_40_12
XANTENNA_8 _03764_ vssd1 vssd1 vccd1 vccd1 sky130_fd_sc_hd__diode_2
X_11355_ _04707_ _05847_ vssd1 vssd1 vccd1 vccd1 _06243_ sky130_fd_sc_hd__nand2b_1
X_14143_ clknet_leaf_68_clk _01115_ net726 vssd1 vssd1 vccd1 vccd1 cell3.CB_1.config_dataA\[3\]
+ sky130_fd_sc_hd__dfstp_1
XTAP_TAPCELL_ROW_74_1418 vssd1 vccd1 sky130_fd_sc_hd__tapvpwrvgnd_1
XFILLER_4_753 vssd1 vssd1 vccd1 vccd1 sky130_fd_sc_hd__fill_2
XANTENNA_input56_X net56 vssd1 vssd1 vccd1 vccd1 sky130_fd_sc_hd__diode_2
X_11286_ net638 cell2.LE_1B.reset_mode vssd1 vssd1 vccd1 vccd1 _11286_/X sky130_fd_sc_hd__xor2_2
X_10306_ _05295_ _05301_ _01757_ vssd1 vssd1 vccd1 vccd1 _05305_ sky130_fd_sc_hd__mux2_1
X_14074_ clknet_leaf_82_clk _01046_ net670 vssd1 vssd1 vccd1 vccd1 cell3.SB0.route_sel\[82\]
+ sky130_fd_sc_hd__dfstp_1
X_13025_ net1533 cell3.LEI0.config_data\[45\] net948 vssd1 vssd1 vccd1 vccd1 _01453_
+ sky130_fd_sc_hd__mux2_1
X_10237_ net411 _05233_ _05234_ _05237_ vssd1 vssd1 vccd1 vccd1 _05238_ sky130_fd_sc_hd__a31o_1
XANTENNA_output257_A net257 vssd1 vssd1 vccd1 vccd1 sky130_fd_sc_hd__diode_2
X_10168_ net421 net420 _05139_ cell2.CB_0.config_dataA\[2\] vssd1 vssd1 vccd1 vccd1
+ _05169_ sky130_fd_sc_hd__o31ai_1
XFILLER_67_727 vssd1 vssd1 vccd1 vccd1 sky130_fd_sc_hd__fill_1
X_10099_ _02106_ _05096_ _05098_ _05093_ _05094_ vssd1 vssd1 vccd1 vccd1 _05100_ sky130_fd_sc_hd__a32o_1
XTAP_TAPCELL_ROW_89_1650 vssd1 vccd1 sky130_fd_sc_hd__tapvpwrvgnd_1
XFILLER_82_719 vssd1 vssd1 vccd1 vccd1 sky130_fd_sc_hd__fill_4
XANTENNA__09299__A2 _02780_ vssd1 vssd1 vccd1 vccd1 sky130_fd_sc_hd__diode_2
X_13927_ clknet_leaf_24_clk net1044 net607 vssd1 vssd1 vccd1 vccd1 cell2.LE_0A.config_data\[6\]
+ sky130_fd_sc_hd__dfrtp_1
XANTENNA__10302__A1 net64 vssd1 vssd1 vccd1 vccd1 sky130_fd_sc_hd__diode_2
XFILLER_62_421 vssd1 vssd1 vccd1 vccd1 sky130_fd_sc_hd__fill_4
X_13858_ clknet_leaf_40_clk _00830_ net643 vssd1 vssd1 vccd1 vccd1 cell2.CB_1.config_dataB\[7\]
+ sky130_fd_sc_hd__dfstp_2
XTAP_TAPCELL_ROW_33_803 vssd1 vccd1 sky130_fd_sc_hd__tapvpwrvgnd_1
X_12809_ cell2.SB0.route_sel\[51\] cell2.SB0.route_sel\[50\] net810 vssd1 vssd1 vccd1
+ vccd1 _01238_ sky130_fd_sc_hd__mux2_1
Xclkbuf_leaf_108_clk clknet_4_8_0_clk vssd1 vssd1 vccd1 vccd1 clknet_leaf_108_clk
+ sky130_fd_sc_hd__clkbuf_8
X_13789_ clknet_leaf_104_clk _00761_ net662 vssd1 vssd1 vccd1 vccd1 cell1.SB0.route_sel\[66\]
+ sky130_fd_sc_hd__dfstp_1
X_08000_ _02887_ _03029_ _03030_ _02890_ _01558_ vssd1 vssd1 vccd1 vccd1 _03042_ sky130_fd_sc_hd__a221o_1
XTAP_TAPCELL_ROW_116_2046 vssd1 vccd1 sky130_fd_sc_hd__tapvpwrvgnd_1
XANTENNA__08026__A3 bus2_0\[15\] vssd1 vssd1 vccd1 vccd1 sky130_fd_sc_hd__diode_2
Xhold503 cell3.LEI0.config_data\[24\] vssd1 vssd1 vccd1 vccd1 net1462 sky130_fd_sc_hd__dlygate4sd3_1
Xhold514 cell3.LEI0.config_data\[22\] vssd1 vssd1 vccd1 vccd1 net1473 sky130_fd_sc_hd__dlygate4sd3_1
Xhold536 cell0.LEI0.config_data\[4\] vssd1 vssd1 vccd1 vccd1 net1495 sky130_fd_sc_hd__dlygate4sd3_1
Xhold525 _00578_ vssd1 vssd1 vccd1 vccd1 net1484 sky130_fd_sc_hd__dlygate4sd3_1
XANTENNA__12306__S net863 vssd1 vssd1 vccd1 vccd1 sky130_fd_sc_hd__diode_2
Xhold547 cell2.LEI0.config_data\[7\] vssd1 vssd1 vccd1 vccd1 net1506 sky130_fd_sc_hd__dlygate4sd3_1
X_09951_ _01750_ _04953_ _04954_ cell2.LEI0.config_data\[11\] vssd1 vssd1 vccd1 vccd1
+ _04955_ sky130_fd_sc_hd__o22a_1
Xhold569 cell0.LE_0B.dff1_out vssd1 vssd1 vccd1 vccd1 net1528 sky130_fd_sc_hd__dlygate4sd3_1
Xhold558 cell1.LE_0B.dff1_out vssd1 vssd1 vccd1 vccd1 net1517 sky130_fd_sc_hd__dlygate4sd3_1
Xmax_cap266 _02491_ vssd1 vssd1 vccd1 vccd1 net266 sky130_fd_sc_hd__clkbuf_2
XFILLER_106_27 vssd1 vssd1 vccd1 vccd1 sky130_fd_sc_hd__fill_1
XANTENNA__09682__Y _04696_ vssd1 vssd1 vccd1 vccd1 sky130_fd_sc_hd__diode_2
X_08902_ cell1.LEI0.config_data\[2\] _03933_ vssd1 vssd1 vccd1 vccd1 _03934_ sky130_fd_sc_hd__and2b_1
Xmax_cap299 _01874_ vssd1 vssd1 vccd1 vccd1 net299 sky130_fd_sc_hd__clkbuf_2
X_09882_ net438 _04348_ vssd1 vssd1 vccd1 vccd1 _04888_ sky130_fd_sc_hd__nand2_1
XFILLER_100_824 vssd1 vssd1 vccd1 vccd1 sky130_fd_sc_hd__fill_1
X_08833_ _01498_ cell1.SB0.route_sel\[7\] vssd1 vssd1 vccd1 vccd1 _03865_ sky130_fd_sc_hd__nand2_1
XANTENNA__10350__A _05136_ vssd1 vssd1 vccd1 vccd1 sky130_fd_sc_hd__diode_2
XFILLER_85_546 vssd1 vssd1 vccd1 vccd1 sky130_fd_sc_hd__fill_1
X_08764_ net332 net327 net336 net323 cell1.LEI0.config_data\[45\] cell1.LEI0.config_data\[46\]
+ vssd1 vssd1 vccd1 vccd1 _03798_ sky130_fd_sc_hd__mux4_1
X_07715_ _01933_ net353 _02758_ _02760_ vssd1 vssd1 vccd1 vccd1 _02762_ sky130_fd_sc_hd__o211a_1
X_08695_ _03514_ _03703_ _03705_ _03517_ cell1.CB_1.config_dataB\[2\] vssd1 vssd1
+ vccd1 vccd1 _03729_ sky130_fd_sc_hd__a221o_1
XANTENNA__10844__A2 net24 vssd1 vssd1 vccd1 vccd1 sky130_fd_sc_hd__diode_2
XFILLER_80_251 vssd1 vssd1 vccd1 vccd1 sky130_fd_sc_hd__fill_1
X_07646_ bus3_1\[1\] net327 _02693_ vssd1 vssd1 vccd1 vccd1 _02695_ sky130_fd_sc_hd__mux2_1
XTAP_TAPCELL_ROW_0_288 vssd1 vccd1 sky130_fd_sc_hd__tapvpwrvgnd_1
XANTENNA_fanout622_A net623 vssd1 vssd1 vccd1 vccd1 sky130_fd_sc_hd__diode_2
X_07577_ _02621_ _02626_ vssd1 vssd1 vccd1 vccd1 _02627_ sky130_fd_sc_hd__nor2_1
XTAP_TAPCELL_ROW_0_299 vssd1 vccd1 sky130_fd_sc_hd__tapvpwrvgnd_1
XFILLER_15_57 vccd1 vssd1 vccd1 vssd1 sky130_ef_sc_hd__decap_40_12
X_09316_ _02003_ _04189_ vssd1 vssd1 vccd1 vccd1 _04341_ sky130_fd_sc_hd__nor2_1
XANTENNA__09998__A0 bus3_2\[8\] vssd1 vssd1 vccd1 vccd1 sky130_fd_sc_hd__diode_2
XFILLER_40_137 vssd1 vssd1 vccd1 vccd1 sky130_fd_sc_hd__fill_1
X_06528_ cell0.SB0.route_sel\[31\] vssd1 vssd1 vccd1 vccd1 _01598_ sky130_fd_sc_hd__inv_2
X_09247_ cell3.SB0.route_sel\[14\] cell3.SB0.route_sel\[15\] vssd1 vssd1 vccd1 vccd1
+ _04274_ sky130_fd_sc_hd__nor2_1
X_06459_ cell1.SB0.route_sel\[74\] vssd1 vssd1 vccd1 vccd1 _01529_ sky130_fd_sc_hd__inv_2
X_09178_ cell3.SB0.route_sel\[0\] cell3.SB0.route_sel\[1\] vssd1 vssd1 vccd1 vccd1
+ _04206_ sky130_fd_sc_hd__nand2_1
XANTENNA__13905__RESET_B net622 vssd1 vssd1 vccd1 vccd1 sky130_fd_sc_hd__diode_2
X_08129_ net547 net544 vssd1 vssd1 vccd1 vccd1 _03169_ sky130_fd_sc_hd__nor2_1
XANTENNA__07225__A1 net3 vssd1 vssd1 vccd1 vccd1 sky130_fd_sc_hd__diode_2
X_11140_ _05901_ _06079_ _06080_ _05898_ vssd1 vssd1 vccd1 vccd1 _06092_ sky130_fd_sc_hd__a2bb2o_1
XFILLER_107_478 vssd1 vssd1 vccd1 vccd1 sky130_fd_sc_hd__fill_2
XTAP_TAPCELL_ROW_56_1148 vssd1 vccd1 sky130_fd_sc_hd__tapvpwrvgnd_1
XFILLER_89_841 vssd1 vssd1 vccd1 vccd1 sky130_fd_sc_hd__fill_1
XFILLER_1_723 vssd1 vssd1 vccd1 vccd1 sky130_fd_sc_hd__fill_1
X_11071_ cell3.CB_0.config_dataA\[19\] _05999_ _06014_ _06024_ _01811_ vssd1 vssd1
+ vccd1 vccd1 _06025_ sky130_fd_sc_hd__a32o_1
Xinput101 SBwest_in[13] vssd1 vssd1 vccd1 vccd1 net101 sky130_fd_sc_hd__buf_1
XFILLER_0_222 vssd1 vssd1 vccd1 vccd1 sky130_fd_sc_hd__fill_2
XFILLER_1_767 vccd1 vssd1 vccd1 vssd1 sky130_ef_sc_hd__decap_40_12
X_10022_ cell2.LEI0.config_data\[34\] _05025_ vssd1 vssd1 vccd1 vccd1 _05026_ sky130_fd_sc_hd__nor2_1
Xinput112 SBwest_in[23] vssd1 vssd1 vccd1 vccd1 net112 sky130_fd_sc_hd__buf_1
Xinput123 SBwest_in[4] vssd1 vssd1 vccd1 vccd1 net123 sky130_fd_sc_hd__clkbuf_1
XANTENNA_input16_A CBeast_in[23] vssd1 vssd1 vccd1 vccd1 sky130_fd_sc_hd__diode_2
XANTENNA__10296__A0 net36 vssd1 vssd1 vccd1 vccd1 sky130_fd_sc_hd__diode_2
XANTENNA__12886__S net940 vssd1 vssd1 vccd1 vccd1 sky130_fd_sc_hd__diode_2
X_11973_ cell0.SB0.route_sel\[79\] cell0.SB0.route_sel\[78\] net784 vssd1 vssd1 vccd1
+ vccd1 _00410_ sky130_fd_sc_hd__mux2_1
XPHY_EDGE_ROW_113_Right_113 vssd1 vssd1 vccd1 vccd1 sky130_fd_sc_hd__decap_3
X_13712_ clknet_leaf_28_clk _00684_ net617 vssd1 vssd1 vccd1 vccd1 cell2.CB_0.config_dataA\[14\]
+ sky130_fd_sc_hd__dfstp_1
X_10924_ _01718_ _01719_ _01720_ cell3.SB0.route_sel\[71\] _05877_ vssd1 vssd1 vccd1
+ vccd1 _05878_ sky130_fd_sc_hd__a221o_1
XANTENNA_input110_X net110 vssd1 vssd1 vccd1 vccd1 sky130_fd_sc_hd__diode_2
X_13643_ clknet_leaf_37_clk _00615_ net646 vssd1 vssd1 vccd1 vccd1 cell2.LE_1B.config_data\[15\]
+ sky130_fd_sc_hd__dfrtp_1
X_10855_ _05489_ _05797_ _05799_ _05483_ cell3.CB_1.config_dataB\[17\] vssd1 vssd1
+ vccd1 vccd1 _05811_ sky130_fd_sc_hd__o221a_1
X_13574_ clknet_leaf_117_clk _00546_ net669 vssd1 vssd1 vccd1 vccd1 cell1.LE_0A.edge_mode
+ sky130_fd_sc_hd__dfstp_1
X_12525_ net1382 net1349 net839 vssd1 vssd1 vccd1 vccd1 _00954_ sky130_fd_sc_hd__mux2_1
X_10786_ cell3.CB_1.config_dataB\[8\] cell3.CB_1.config_dataB\[7\] vssd1 vssd1 vccd1
+ vccd1 _05742_ sky130_fd_sc_hd__or2_1
XFILLER_82_9 vccd1 vssd1 vccd1 vssd1 sky130_ef_sc_hd__decap_40_12
X_12456_ cell2.LE_0B.config_data\[16\] net1138 net844 vssd1 vssd1 vccd1 vccd1 _00887_
+ sky130_fd_sc_hd__mux2_1
XANTENNA__09756__A3 bus3_2\[15\] vssd1 vssd1 vccd1 vccd1 sky130_fd_sc_hd__diode_2
XANTENNA__10709__A1_N _05513_ vssd1 vssd1 vccd1 vccd1 sky130_fd_sc_hd__diode_2
X_12387_ cell1.SB0.route_sel\[125\] cell1.SB0.route_sel\[124\] net872 vssd1 vssd1
+ vccd1 vccd1 _00820_ sky130_fd_sc_hd__mux2_1
X_11407_ cell0.SB0.route_sel\[80\] cell0.SB0.route_sel\[81\] _01471_ cell0.SB0.route_sel\[84\]
+ _06271_ vssd1 vssd1 vccd1 vccd1 _06272_ sky130_fd_sc_hd__o221a_1
X_14126_ clknet_leaf_64_clk _01098_ net744 vssd1 vssd1 vccd1 vccd1 cell3.LE_1B.config_data\[6\]
+ sky130_fd_sc_hd__dfrtp_1
XANTENNA__10220__A0 net61 vssd1 vssd1 vccd1 vccd1 sky130_fd_sc_hd__diode_2
X_11338_ net281 _04459_ _04460_ _06234_ vssd1 vssd1 vccd1 vccd1 net179 sky130_fd_sc_hd__a22o_1
XANTENNA__08964__B2 _03830_ vssd1 vssd1 vccd1 vccd1 sky130_fd_sc_hd__diode_2
XANTENNA__08964__A1 _03826_ vssd1 vssd1 vccd1 vccd1 sky130_fd_sc_hd__diode_2
XANTENNA__07767__A2 cell1.SB0.route_sel\[35\] vssd1 vssd1 vccd1 vccd1 sky130_fd_sc_hd__diode_2
Xclkbuf_1_0__f_cell3.LE_0A.sel_clk clknet_0_cell3.LE_0A.sel_clk vssd1 vssd1 vccd1
+ vccd1 clknet_1_0__leaf_cell3.LE_0A.sel_clk sky130_fd_sc_hd__clkbuf_16
X_11269_ _02102_ _06202_ vssd1 vssd1 vccd1 vccd1 _06203_ sky130_fd_sc_hd__nand2_1
XFILLER_98_148 vssd1 vssd1 vccd1 vccd1 sky130_fd_sc_hd__fill_8
X_14057_ clknet_leaf_81_clk _01029_ net702 vssd1 vssd1 vccd1 vccd1 cell3.SB0.route_sel\[65\]
+ sky130_fd_sc_hd__dfstp_1
X_13008_ net1372 cell3.LEI0.config_data\[28\] net952 vssd1 vssd1 vccd1 vccd1 _01436_
+ sky130_fd_sc_hd__mux2_1
XANTENNA__11537__Y net198 vssd1 vssd1 vccd1 vccd1 sky130_fd_sc_hd__diode_2
XANTENNA__10523__B2 cell3.SB0.route_sel\[45\] vssd1 vssd1 vccd1 vccd1 sky130_fd_sc_hd__diode_2
XTAP_TAPCELL_ROW_87_1609 vssd1 vccd1 sky130_fd_sc_hd__tapvpwrvgnd_1
XFILLER_11_3 vccd1 vssd1 vccd1 vssd1 sky130_ef_sc_hd__decap_40_12
XANTENNA__14434__RESET_B net752 vssd1 vssd1 vccd1 vccd1 sky130_fd_sc_hd__diode_2
X_07500_ _01947_ _02340_ bus2_0\[15\] vssd1 vssd1 vccd1 vccd1 _02552_ sky130_fd_sc_hd__o21a_1
XFILLER_47_281 vssd1 vssd1 vccd1 vccd1 sky130_fd_sc_hd__fill_1
X_08480_ cell1.SB0.route_sel\[5\] cell1.SB0.route_sel\[4\] _01498_ cell1.SB0.route_sel\[7\]
+ _03515_ vssd1 vssd1 vccd1 vccd1 _03516_ sky130_fd_sc_hd__o221a_1
XFILLER_63_785 vssd1 vssd1 vccd1 vccd1 sky130_fd_sc_hd__fill_4
X_07431_ net343 _01862_ _02336_ vssd1 vssd1 vccd1 vccd1 _02485_ sky130_fd_sc_hd__or3_1
XTAP_TAPCELL_ROW_46_994 vssd1 vccd1 sky130_fd_sc_hd__tapvpwrvgnd_1
X_07362_ net345 net354 _02340_ vssd1 vssd1 vccd1 vccd1 _02418_ sky130_fd_sc_hd__nor3_1
X_09101_ bus3_1\[0\] bus3_1\[1\] bus3_1\[2\] bus3_1\[3\] net476 net475 vssd1 vssd1
+ vccd1 vccd1 _04131_ sky130_fd_sc_hd__mux4_1
XANTENNA__08862__X _03894_ vssd1 vssd1 vccd1 vccd1 sky130_fd_sc_hd__diode_2
XANTENNA__10054__A3 bus3_2\[3\] vssd1 vssd1 vccd1 vccd1 sky130_fd_sc_hd__diode_2
XFILLER_31_682 vssd1 vssd1 vccd1 vccd1 sky130_fd_sc_hd__fill_1
X_07293_ net358 _02326_ _02346_ _02349_ vssd1 vssd1 vccd1 vccd1 _02351_ sky130_fd_sc_hd__o211a_1
X_09032_ _01669_ _04057_ _04058_ _04061_ vssd1 vssd1 vccd1 vccd1 _04062_ sky130_fd_sc_hd__o2bb2a_1
Xhold311 cell1.LEI0.config_data\[39\] vssd1 vssd1 vccd1 vccd1 net1270 sky130_fd_sc_hd__dlygate4sd3_1
Xhold300 cell0.LE_1B.config_data\[7\] vssd1 vssd1 vccd1 vccd1 net1259 sky130_fd_sc_hd__dlygate4sd3_1
XANTENNA__07197__Y _02257_ vssd1 vssd1 vccd1 vccd1 sky130_fd_sc_hd__diode_2
XFILLER_117_15 vccd1 vssd1 vccd1 vssd1 sky130_ef_sc_hd__decap_40_12
Xhold322 cell1.LE_0A.config_data\[12\] vssd1 vssd1 vccd1 vccd1 net1281 sky130_fd_sc_hd__dlygate4sd3_1
Xhold333 _00536_ vssd1 vssd1 vccd1 vccd1 net1292 sky130_fd_sc_hd__dlygate4sd3_1
Xhold344 cell1.LEI0.config_data\[45\] vssd1 vssd1 vccd1 vccd1 net1303 sky130_fd_sc_hd__dlygate4sd3_1
Xhold377 cell2.LEI0.config_data\[27\] vssd1 vssd1 vccd1 vccd1 net1336 sky130_fd_sc_hd__dlygate4sd3_1
Xhold366 cell3.LE_1B.config_data\[3\] vssd1 vssd1 vccd1 vccd1 net1325 sky130_fd_sc_hd__dlygate4sd3_1
Xhold355 _01096_ vssd1 vssd1 vccd1 vccd1 net1314 sky130_fd_sc_hd__dlygate4sd3_1
Xfanout824 net827 vssd1 vssd1 vccd1 vccd1 net824 sky130_fd_sc_hd__clkbuf_4
Xfanout813 net814 vssd1 vssd1 vccd1 vccd1 net813 sky130_fd_sc_hd__clkbuf_2
X_09934_ cell2.CB_1.config_dataB\[2\] _04929_ _04937_ vssd1 vssd1 vccd1 vccd1 _04938_
+ sky130_fd_sc_hd__o21ba_1
Xhold399 cell1.LEI0.config_data\[13\] vssd1 vssd1 vccd1 vccd1 net1358 sky130_fd_sc_hd__dlygate4sd3_1
Xfanout802 net806 vssd1 vssd1 vccd1 vccd1 net802 sky130_fd_sc_hd__clkbuf_4
Xhold388 cell1.LE_1B.config_data\[0\] vssd1 vssd1 vccd1 vccd1 net1347 sky130_fd_sc_hd__dlygate4sd3_1
XANTENNA_input8_A CBeast_in[16] vssd1 vssd1 vccd1 vccd1 sky130_fd_sc_hd__diode_2
XTAP_TAPCELL_ROW_129_2248 vssd1 vccd1 sky130_fd_sc_hd__tapvpwrvgnd_1
XTAP_TAPCELL_ROW_129_2237 vssd1 vccd1 sky130_fd_sc_hd__tapvpwrvgnd_1
X_09865_ cell2.LE_1A.config_data\[7\] cell2.LE_1A.config_data\[6\] _04831_ vssd1 vssd1
+ vccd1 vccd1 _04871_ sky130_fd_sc_hd__mux2_1
Xfanout846 net854 vssd1 vssd1 vccd1 vccd1 net846 sky130_fd_sc_hd__clkbuf_4
XFILLER_98_682 vssd1 vssd1 vccd1 vccd1 sky130_fd_sc_hd__fill_1
Xfanout835 net836 vssd1 vssd1 vccd1 vccd1 net835 sky130_fd_sc_hd__clkbuf_2
Xfanout857 net858 vssd1 vssd1 vccd1 vccd1 net857 sky130_fd_sc_hd__clkbuf_4
XANTENNA__11447__Y net207 vssd1 vssd1 vccd1 vccd1 sky130_fd_sc_hd__diode_2
XANTENNA__10514__A1 net337 vssd1 vssd1 vccd1 vccd1 sky130_fd_sc_hd__diode_2
XFILLER_97_181 vssd1 vssd1 vccd1 vccd1 sky130_fd_sc_hd__fill_1
Xfanout879 net880 vssd1 vssd1 vccd1 vccd1 net879 sky130_fd_sc_hd__clkbuf_4
XFILLER_58_568 vssd1 vssd1 vccd1 vccd1 sky130_fd_sc_hd__fill_1
XTAP_TAPCELL_ROW_51_1078 vssd1 vccd1 sky130_fd_sc_hd__tapvpwrvgnd_1
XTAP_TAPCELL_ROW_51_1067 vssd1 vccd1 sky130_fd_sc_hd__tapvpwrvgnd_1
X_08816_ cell1.SB0.route_sel\[78\] _01532_ _03847_ vssd1 vssd1 vccd1 vccd1 _03848_
+ sky130_fd_sc_hd__o21ai_2
Xfanout868 net871 vssd1 vssd1 vccd1 vccd1 net868 sky130_fd_sc_hd__clkbuf_4
XFILLER_133_69 vccd1 vssd1 vccd1 vssd1 sky130_ef_sc_hd__decap_40_12
X_09796_ _04555_ _04792_ _04801_ cell2.CB_1.config_dataA\[2\] vssd1 vssd1 vccd1 vccd1
+ _04802_ sky130_fd_sc_hd__a211o_1
XFILLER_85_354 vssd1 vssd1 vccd1 vccd1 sky130_fd_sc_hd__fill_1
XTAP_TAPCELL_ROW_142_2459 vssd1 vccd1 sky130_fd_sc_hd__tapvpwrvgnd_1
XTAP_TAPCELL_ROW_142_2448 vssd1 vccd1 sky130_fd_sc_hd__tapvpwrvgnd_1
XTAP_TAPCELL_ROW_142_2437 vssd1 vccd1 sky130_fd_sc_hd__tapvpwrvgnd_1
XPHY_EDGE_ROW_116_Left_259 vssd1 vssd1 vccd1 vccd1 sky130_fd_sc_hd__decap_3
XANTENNA_fanout837_A net855 vssd1 vssd1 vccd1 vccd1 sky130_fd_sc_hd__diode_2
XANTENNA_clkbuf_leaf_90_clk_A clknet_4_11_0_clk vssd1 vssd1 vccd1 vccd1 sky130_fd_sc_hd__diode_2
XANTENNA_fanout458_X net458 vssd1 vssd1 vccd1 vccd1 sky130_fd_sc_hd__diode_2
XANTENNA_fanout360_X net360 vssd1 vssd1 vccd1 vccd1 sky130_fd_sc_hd__diode_2
X_08747_ net452 net451 _03498_ _03780_ cell1.CB_1.config_dataB\[17\] vssd1 vssd1 vccd1
+ vccd1 _03781_ sky130_fd_sc_hd__o311a_1
X_08678_ _03494_ _03704_ _03708_ _03709_ cell1.CB_1.config_dataB\[2\] vssd1 vssd1
+ vccd1 vccd1 _03712_ sky130_fd_sc_hd__o2111a_1
X_07629_ _02675_ _02677_ vssd1 vssd1 vccd1 vccd1 _02678_ sky130_fd_sc_hd__or2_4
X_10640_ _05597_ vssd1 vssd1 vccd1 vccd1 _05598_ sky130_fd_sc_hd__inv_2
XTAP_TAPCELL_ROW_24_666 vssd1 vccd1 sky130_fd_sc_hd__tapvpwrvgnd_1
X_10571_ cell3.SB0.route_sel\[104\] cell3.SB0.route_sel\[105\] vssd1 vssd1 vccd1 vccd1
+ _05529_ sky130_fd_sc_hd__nand2b_1
XANTENNA__07446__A1 net88 vssd1 vssd1 vccd1 vccd1 sky130_fd_sc_hd__diode_2
XPHY_EDGE_ROW_125_Left_268 vssd1 vssd1 vccd1 vccd1 sky130_fd_sc_hd__decap_3
XANTENNA__07388__X _02444_ vssd1 vssd1 vccd1 vccd1 sky130_fd_sc_hd__diode_2
XFILLER_5_303 vssd1 vssd1 vccd1 vccd1 sky130_fd_sc_hd__fill_1
X_13290_ clknet_leaf_97_clk _00262_ net679 vssd1 vssd1 vccd1 vccd1 cell1.CB_1.config_dataA\[6\]
+ sky130_fd_sc_hd__dfstp_1
X_12310_ cell1.SB0.route_sel\[48\] cell1.SB0.route_sel\[47\] net861 vssd1 vssd1 vccd1
+ vccd1 _00743_ sky130_fd_sc_hd__mux2_1
X_12241_ cell2.CB_0.config_dataA\[4\] cell2.CB_0.config_dataA\[3\] net826 vssd1 vssd1
+ vccd1 vccd1 _00674_ sky130_fd_sc_hd__mux2_1
XFILLER_108_721 vssd1 vssd1 vccd1 vccd1 sky130_fd_sc_hd__fill_1
XANTENNA__07495__B1_N net71 vssd1 vssd1 vccd1 vccd1 sky130_fd_sc_hd__diode_2
X_12172_ net1343 net1274 net852 vssd1 vssd1 vccd1 vccd1 _00605_ sky130_fd_sc_hd__mux2_1
XFILLER_123_735 vssd1 vssd1 vccd1 vccd1 sky130_fd_sc_hd__fill_1
XANTENNA__10753__B2 net14 vssd1 vssd1 vccd1 vccd1 sky130_fd_sc_hd__diode_2
XANTENNA__10753__A1 net13 vssd1 vssd1 vccd1 vccd1 sky130_fd_sc_hd__diode_2
X_11123_ cell3.CB_0.config_dataB\[4\] _06048_ _06063_ _06074_ _01794_ vssd1 vssd1
+ vccd1 vccd1 _06075_ sky130_fd_sc_hd__a32o_1
XANTENNA_clkbuf_leaf_43_clk_A clknet_4_6_0_clk vssd1 vssd1 vccd1 vccd1 sky130_fd_sc_hd__diode_2
XFILLER_3_27 vccd1 vssd1 vccd1 vssd1 sky130_ef_sc_hd__decap_40_12
XFILLER_1_553 vssd1 vssd1 vccd1 vccd1 sky130_fd_sc_hd__fill_4
X_11054_ _05884_ _05999_ _06006_ _06007_ cell3.CB_0.config_dataA\[17\] vssd1 vssd1
+ vccd1 vccd1 _06008_ sky130_fd_sc_hd__a2111o_1
XANTENNA__09482__C _03880_ vssd1 vssd1 vccd1 vccd1 sky130_fd_sc_hd__diode_2
X_10005_ net403 _04348_ vssd1 vssd1 vccd1 vccd1 _05009_ sky130_fd_sc_hd__nand2_1
XFILLER_88_170 vssd1 vssd1 vccd1 vccd1 sky130_fd_sc_hd__fill_4
XFILLER_76_321 vssd1 vssd1 vccd1 vccd1 sky130_fd_sc_hd__fill_4
XFILLER_1_597 vccd1 vssd1 vccd1 vssd1 sky130_ef_sc_hd__decap_40_12
XANTENNA__10505__A1 _03468_ vssd1 vssd1 vccd1 vccd1 sky130_fd_sc_hd__diode_2
XPHY_EDGE_ROW_134_Left_277 vssd1 vssd1 vccd1 vccd1 sky130_fd_sc_hd__decap_3
XANTENNA_clkbuf_leaf_58_clk_A clknet_4_13_0_clk vssd1 vssd1 vccd1 vccd1 sky130_fd_sc_hd__diode_2
XFILLER_76_365 vssd1 vssd1 vccd1 vccd1 sky130_fd_sc_hd__fill_2
XFILLER_37_719 vssd1 vssd1 vccd1 vccd1 sky130_fd_sc_hd__fill_1
XANTENNA_input19_X net19 vssd1 vssd1 vccd1 vccd1 sky130_fd_sc_hd__diode_2
XFILLER_91_335 vssd1 vssd1 vccd1 vccd1 sky130_fd_sc_hd__fill_1
XTAP_TAPCELL_ROW_69_1339 vssd1 vccd1 sky130_fd_sc_hd__tapvpwrvgnd_1
XFILLER_29_281 vssd1 vssd1 vccd1 vccd1 sky130_fd_sc_hd__fill_1
XANTENNA__10003__A1_N _04527_ vssd1 vssd1 vccd1 vccd1 sky130_fd_sc_hd__diode_2
XANTENNA_clkbuf_leaf_101_clk_A clknet_4_10_0_clk vssd1 vssd1 vccd1 vccd1 sky130_fd_sc_hd__diode_2
X_11956_ cell0.SB0.route_sel\[62\] cell0.SB0.route_sel\[61\] net761 vssd1 vssd1 vccd1
+ vccd1 _00393_ sky130_fd_sc_hd__mux2_1
X_10907_ _04688_ _05860_ vssd1 vssd1 vccd1 vccd1 _05861_ sky130_fd_sc_hd__nand2_4
XTAP_TAPCELL_ROW_82_1539 vssd1 vccd1 sky130_fd_sc_hd__tapvpwrvgnd_1
XFILLER_60_755 vssd1 vssd1 vccd1 vccd1 sky130_fd_sc_hd__fill_1
X_11887_ cell1.CB_0.config_dataA\[18\] cell1.CB_0.config_dataA\[17\] net879 vssd1
+ vssd1 vccd1 vccd1 _00324_ sky130_fd_sc_hd__mux2_1
XTAP_TAPCELL_ROW_43_953 vssd1 vccd1 sky130_fd_sc_hd__tapvpwrvgnd_1
X_10838_ cell3.LE_1B.config_data\[4\] cell3.LE_1B.config_data\[5\] net292 vssd1 vssd1
+ vccd1 vccd1 _05794_ sky130_fd_sc_hd__mux2_1
XANTENNA__13898__RESET_B net752 vssd1 vssd1 vccd1 vccd1 sky130_fd_sc_hd__diode_2
XANTENNA_clkbuf_leaf_116_clk_A clknet_4_9_0_clk vssd1 vssd1 vccd1 vccd1 sky130_fd_sc_hd__diode_2
X_13626_ clknet_leaf_86_clk _00598_ net685 vssd1 vssd1 vccd1 vccd1 cell1.CB_0.config_data_inA
+ sky130_fd_sc_hd__dfrtp_1
XFILLER_13_660 vccd1 vssd1 vccd1 vssd1 sky130_ef_sc_hd__decap_40_12
XANTENNA__08229__A3 bus1_0\[15\] vssd1 vssd1 vccd1 vccd1 sky130_fd_sc_hd__diode_2
X_10769_ net369 net368 vssd1 vssd1 vccd1 vccd1 _05725_ sky130_fd_sc_hd__or2_1
X_13557_ clknet_leaf_118_clk _00529_ net598 vssd1 vssd1 vccd1 vccd1 cell1.LE_0A.config_data\[0\]
+ sky130_fd_sc_hd__dfrtp_1
X_12508_ net1522 cell2.LEI0.config_data\[21\] net847 vssd1 vssd1 vccd1 vccd1 _00937_
+ sky130_fd_sc_hd__mux2_1
X_13488_ clknet_leaf_98_clk _00460_ net683 vssd1 vssd1 vccd1 vccd1 cell1.CB_1.config_dataB\[1\]
+ sky130_fd_sc_hd__dfstp_1
X_12439_ net963 net549 _06382_ vssd1 vssd1 vccd1 vccd1 _00870_ sky130_fd_sc_hd__a21bo_1
XTAP_TAPCELL_ROW_113_2005 vssd1 vccd1 sky130_fd_sc_hd__tapvpwrvgnd_1
XTAP_TAPCELL_ROW_97_1760 vssd1 vccd1 sky130_fd_sc_hd__tapvpwrvgnd_1
XFILLER_9_697 vccd1 vssd1 vccd1 vssd1 sky130_ef_sc_hd__decap_40_12
XFILLER_141_532 vssd1 vssd1 vccd1 vccd1 sky130_fd_sc_hd__fill_1
X_14109_ clknet_leaf_80_clk _01081_ net707 vssd1 vssd1 vccd1 vccd1 cell3.SB0.route_sel\[117\]
+ sky130_fd_sc_hd__dfstp_1
X_07980_ _03023_ _03016_ _03012_ vssd1 vssd1 vccd1 vccd1 _03024_ sky130_fd_sc_hd__mux2_1
XFILLER_101_429 vssd1 vssd1 vccd1 vccd1 sky130_fd_sc_hd__fill_8
X_06931_ net303 _01905_ _01992_ _01997_ vssd1 vssd1 vccd1 vccd1 _01998_ sky130_fd_sc_hd__a31o_1
X_09650_ _02444_ _03824_ _02439_ vssd1 vssd1 vccd1 vccd1 _04665_ sky130_fd_sc_hd__or3b_1
XANTENNA__08165__A2 bus1_0\[2\] vssd1 vssd1 vccd1 vccd1 sky130_fd_sc_hd__diode_2
X_06862_ _01930_ _01928_ vssd1 vssd1 vccd1 vccd1 bus2_0\[6\] sky130_fd_sc_hd__and2b_2
X_08601_ net31 net32 net2 net3 net488 net487 vssd1 vssd1 vccd1 vccd1 _03637_ sky130_fd_sc_hd__mux4_1
X_09581_ _01825_ _04596_ _04598_ vssd1 vssd1 vccd1 vccd1 _04599_ sky130_fd_sc_hd__a21oi_1
XFILLER_94_195 vssd1 vssd1 vccd1 vccd1 sky130_fd_sc_hd__fill_1
X_06793_ cell0.CB_0.config_dataA\[23\] cell0.CB_0.config_dataA\[22\] vssd1 vssd1 vccd1
+ vccd1 _01863_ sky130_fd_sc_hd__nand2b_2
XTAP_TAPCELL_ROW_2_339 vssd1 vccd1 sky130_fd_sc_hd__tapvpwrvgnd_1
XTAP_TAPCELL_ROW_124_2167 vssd1 vccd1 sky130_fd_sc_hd__tapvpwrvgnd_1
XANTENNA__07921__B _02585_ vssd1 vssd1 vccd1 vccd1 sky130_fd_sc_hd__diode_2
X_08532_ net4 net5 net6 net7 net495 cell1.CB_1.config_dataA\[6\] vssd1 vssd1 vccd1
+ vccd1 _03568_ sky130_fd_sc_hd__mux4_1
XFILLER_23_402 vssd1 vssd1 vccd1 vccd1 sky130_fd_sc_hd__fill_1
X_08463_ net497 net496 _03498_ vssd1 vssd1 vccd1 vccd1 _03499_ sky130_fd_sc_hd__or3_1
X_07414_ cell2.SB0.route_sel\[104\] cell2.SB0.route_sel\[105\] _02462_ _02468_ vssd1
+ vssd1 vccd1 vccd1 _02469_ sky130_fd_sc_hd__a31o_2
X_08394_ _03424_ _03427_ _03431_ cell0.CB_1.config_dataB\[18\] vssd1 vssd1 vccd1 vccd1
+ _03432_ sky130_fd_sc_hd__or4b_1
X_07345_ cell2.SB0.route_sel\[96\] cell2.SB0.route_sel\[97\] _02393_ _02401_ net832
+ vssd1 vssd1 vccd1 vccd1 _02402_ sky130_fd_sc_hd__a311oi_4
XTAP_TAPCELL_ROW_21_625 vssd1 vccd1 sky130_fd_sc_hd__tapvpwrvgnd_1
XANTENNA_fanout320_A net322 vssd1 vssd1 vccd1 vccd1 sky130_fd_sc_hd__diode_2
XANTENNA__07428__A1 net70 vssd1 vssd1 vccd1 vccd1 sky130_fd_sc_hd__diode_2
Xclkbuf_leaf_30_clk clknet_4_5_0_clk vssd1 vssd1 vccd1 vccd1 clknet_leaf_30_clk sky130_fd_sc_hd__clkbuf_8
X_07276_ cell0.SB0.route_sel\[101\] cell0.SB0.route_sel\[100\] net100 _02332_ _02331_
+ vssd1 vssd1 vccd1 vccd1 _02334_ sky130_fd_sc_hd__a41o_1
XFILLER_128_25 vssd1 vssd1 vccd1 vccd1 sky130_fd_sc_hd__fill_2
XANTENNA__10983__A1 net54 vssd1 vssd1 vccd1 vccd1 sky130_fd_sc_hd__diode_2
X_09015_ _03853_ _04020_ _04021_ _03849_ cell1.CB_0.config_dataB\[7\] vssd1 vssd1
+ vccd1 vccd1 _04045_ sky130_fd_sc_hd__a221o_1
Xhold152 cell2.LE_1B.config_data\[12\] vssd1 vssd1 vccd1 vccd1 net1111 sky130_fd_sc_hd__dlygate4sd3_1
XANTENNA__06840__X _01909_ vssd1 vssd1 vccd1 vccd1 sky130_fd_sc_hd__diode_2
XFILLER_88_29 vccd1 vssd1 vccd1 vssd1 sky130_ef_sc_hd__decap_40_12
Xhold141 _00190_ vssd1 vssd1 vccd1 vccd1 net1100 sky130_fd_sc_hd__dlygate4sd3_1
Xhold130 cell0.LE_1B.config_data\[5\] vssd1 vssd1 vccd1 vccd1 net1089 sky130_fd_sc_hd__dlygate4sd3_1
Xhold174 _01377_ vssd1 vssd1 vccd1 vccd1 net1133 sky130_fd_sc_hd__dlygate4sd3_1
XFILLER_132_543 vssd1 vssd1 vccd1 vccd1 sky130_fd_sc_hd__fill_1
XFILLER_78_619 vssd1 vssd1 vccd1 vccd1 sky130_fd_sc_hd__fill_1
Xhold163 cell0.LE_1A.config_data\[13\] vssd1 vssd1 vccd1 vccd1 net1122 sky130_fd_sc_hd__dlygate4sd3_1
XTAP_TAPCELL_ROW_53_1107 vssd1 vccd1 sky130_fd_sc_hd__tapvpwrvgnd_1
Xhold185 _00012_ vssd1 vssd1 vccd1 vccd1 net1144 sky130_fd_sc_hd__dlygate4sd3_1
XANTENNA_fanout787_A net807 vssd1 vssd1 vccd1 vccd1 sky130_fd_sc_hd__diode_2
Xfanout621 net622 vssd1 vssd1 vccd1 vccd1 net621 sky130_fd_sc_hd__clkbuf_4
XFILLER_132_587 vssd1 vssd1 vccd1 vccd1 sky130_fd_sc_hd__fill_1
X_09917_ cell2.LE_1A.config_data\[16\] _04920_ _04921_ net351 vssd1 vssd1 vccd1 vccd1
+ cell2.CB_1.le_outA sky130_fd_sc_hd__o211a_1
Xfanout632 net650 vssd1 vssd1 vccd1 vccd1 net632 sky130_fd_sc_hd__clkbuf_2
Xfanout610 net612 vssd1 vssd1 vccd1 vccd1 net610 sky130_fd_sc_hd__clkbuf_4
XANTENNA_hold198_A cell0.LE_0A.config_data\[16\] vssd1 vssd1 vccd1 vccd1 sky130_fd_sc_hd__diode_2
Xhold196 cell0.LE_1A.config_data\[9\] vssd1 vssd1 vccd1 vccd1 net1155 sky130_fd_sc_hd__dlygate4sd3_1
Xfanout643 net649 vssd1 vssd1 vccd1 vccd1 net643 sky130_fd_sc_hd__clkbuf_4
XANTENNA_fanout575_X net575 vssd1 vssd1 vccd1 vccd1 sky130_fd_sc_hd__diode_2
Xfanout665 net667 vssd1 vssd1 vccd1 vccd1 net665 sky130_fd_sc_hd__clkbuf_4
XANTENNA__08156__A2 cell0.CB_1.le_outA vssd1 vssd1 vccd1 vccd1 sky130_fd_sc_hd__diode_2
Xfanout654 net657 vssd1 vssd1 vccd1 vccd1 net654 sky130_fd_sc_hd__clkbuf_4
Xfanout676 net684 vssd1 vssd1 vccd1 vccd1 net676 sky130_fd_sc_hd__clkbuf_4
Xclkbuf_leaf_97_clk clknet_4_10_0_clk vssd1 vssd1 vccd1 vccd1 clknet_leaf_97_clk sky130_fd_sc_hd__clkbuf_8
XANTENNA__11160__A1 _05871_ vssd1 vssd1 vccd1 vccd1 sky130_fd_sc_hd__diode_2
X_09848_ bus3_2\[5\] _04835_ _04836_ bus3_2\[4\] cell2.CB_1.config_dataA\[13\] vssd1
+ vssd1 vccd1 vccd1 _04854_ sky130_fd_sc_hd__a221o_1
Xfanout698 net700 vssd1 vssd1 vccd1 vccd1 net698 sky130_fd_sc_hd__buf_4
Xfanout687 net691 vssd1 vssd1 vccd1 vccd1 net687 sky130_fd_sc_hd__buf_2
XANTENNA_fanout742_X net742 vssd1 vssd1 vccd1 vccd1 sky130_fd_sc_hd__diode_2
X_09779_ cell2.CB_1.config_dataA\[9\] _04769_ _04784_ vssd1 vssd1 vccd1 vccd1 _04785_
+ sky130_fd_sc_hd__and3b_1
XTAP_TAPCELL_ROW_29_736 vssd1 vccd1 sky130_fd_sc_hd__tapvpwrvgnd_1
XFILLER_37_55 vssd1 vssd1 vccd1 vccd1 sky130_fd_sc_hd__fill_1
X_12790_ cell2.SB0.route_sel\[32\] cell2.SB0.route_sel\[31\] net820 vssd1 vssd1 vccd1
+ vccd1 _01219_ sky130_fd_sc_hd__mux2_1
XANTENNA__07831__B _02301_ vssd1 vssd1 vccd1 vccd1 sky130_fd_sc_hd__diode_2
XANTENNA__11558__A_N _06372_ vssd1 vssd1 vccd1 vccd1 sky130_fd_sc_hd__diode_2
XTAP_TAPCELL_ROW_29_747 vssd1 vccd1 sky130_fd_sc_hd__tapvpwrvgnd_1
X_11810_ cell1.LE_1B.config_data\[11\] cell1.LE_1B.config_data\[10\] net902 vssd1
+ vssd1 vccd1 vccd1 _00247_ sky130_fd_sc_hd__mux2_1
XANTENNA_input118_A SBwest_in[29] vssd1 vssd1 vccd1 vccd1 sky130_fd_sc_hd__diode_2
X_11741_ net1082 net1018 net809 vssd1 vssd1 vccd1 vccd1 _00179_ sky130_fd_sc_hd__mux2_1
X_14460_ clknet_leaf_60_clk _01432_ net740 vssd1 vssd1 vccd1 vccd1 cell3.LEI0.config_data\[25\]
+ sky130_fd_sc_hd__dfrtp_1
XTAP_TAPCELL_ROW_64_1269 vssd1 vccd1 sky130_fd_sc_hd__tapvpwrvgnd_1
XTAP_TAPCELL_ROW_40_912 vssd1 vccd1 sky130_fd_sc_hd__tapvpwrvgnd_1
XTAP_TAPCELL_ROW_40_901 vssd1 vccd1 sky130_fd_sc_hd__tapvpwrvgnd_1
X_11672_ cell0.CB_1.config_dataB\[18\] cell0.CB_1.config_dataB\[17\] net786 vssd1
+ vssd1 vccd1 vccd1 _00113_ sky130_fd_sc_hd__mux2_1
XANTENNA__13920__RESET_B net752 vssd1 vssd1 vccd1 vccd1 sky130_fd_sc_hd__diode_2
X_14391_ clknet_leaf_63_clk _01363_ net747 vssd1 vssd1 vccd1 vccd1 cell3.LE_0B.config_data\[0\]
+ sky130_fd_sc_hd__dfrtp_1
X_10623_ _05475_ _05478_ _01785_ vssd1 vssd1 vccd1 vccd1 _05581_ sky130_fd_sc_hd__mux2_1
X_13411_ clknet_leaf_134_clk _00383_ net555 vssd1 vssd1 vccd1 vccd1 cell0.SB0.route_sel\[52\]
+ sky130_fd_sc_hd__dfstp_1
Xclkbuf_leaf_21_clk clknet_4_4_0_clk vssd1 vssd1 vccd1 vccd1 clknet_leaf_21_clk sky130_fd_sc_hd__clkbuf_8
X_10554_ _01676_ cell3.SB0.route_sel\[7\] _05511_ vssd1 vssd1 vccd1 vccd1 _05512_
+ sky130_fd_sc_hd__o21ai_1
X_13342_ clknet_leaf_83_clk _00314_ net671 vssd1 vssd1 vccd1 vccd1 cell1.CB_0.config_dataA\[8\]
+ sky130_fd_sc_hd__dfstp_1
XANTENNA__08092__A1 bus2_0\[4\] vssd1 vssd1 vccd1 vccd1 sky130_fd_sc_hd__diode_2
XANTENNA_input83_A SBsouth_in[26] vssd1 vssd1 vccd1 vccd1 sky130_fd_sc_hd__diode_2
XANTENNA__10974__A1 net279 vssd1 vssd1 vccd1 vccd1 sky130_fd_sc_hd__diode_2
XANTENNA__08092__B2 bus2_0\[5\] vssd1 vssd1 vccd1 vccd1 sky130_fd_sc_hd__diode_2
XFILLER_6_645 vccd1 vssd1 vccd1 vssd1 sky130_ef_sc_hd__decap_40_12
XFILLER_6_634 vssd1 vssd1 vccd1 vccd1 sky130_fd_sc_hd__fill_8
XFILLER_5_111 vssd1 vssd1 vccd1 vccd1 sky130_fd_sc_hd__fill_1
X_13273_ clknet_leaf_93_clk _00245_ net694 vssd1 vssd1 vccd1 vccd1 cell1.LE_1B.config_data\[9\]
+ sky130_fd_sc_hd__dfrtp_1
X_10485_ _02685_ _03514_ _02687_ vssd1 vssd1 vccd1 vccd1 _05458_ sky130_fd_sc_hd__a21boi_1
X_12224_ cell2.CB_0.config_dataB\[12\] net426 net824 vssd1 vssd1 vccd1 vccd1 _00657_
+ sky130_fd_sc_hd__mux2_1
XTAP_TAPCELL_ROW_79_1490 vssd1 vccd1 sky130_fd_sc_hd__tapvpwrvgnd_1
XANTENNA__09041__A0 bus3_1\[12\] vssd1 vssd1 vccd1 vccd1 sky130_fd_sc_hd__diode_2
XFILLER_5_166 vssd1 vssd1 vccd1 vccd1 sky130_fd_sc_hd__fill_2
X_12155_ net1513 cell1.LEI0.config_data\[36\] net895 vssd1 vssd1 vccd1 vccd1 _00588_
+ sky130_fd_sc_hd__mux2_1
XTAP_TAPCELL_ROW_9_450 vssd1 vccd1 sky130_fd_sc_hd__tapvpwrvgnd_1
XFILLER_2_840 vssd1 vssd1 vccd1 vccd1 sky130_fd_sc_hd__fill_1
X_11106_ _06054_ _06055_ _06056_ _06057_ vssd1 vssd1 vccd1 vccd1 _06058_ sky130_fd_sc_hd__o211ai_1
XTAP_TAPCELL_ROW_92_1690 vssd1 vccd1 sky130_fd_sc_hd__tapvpwrvgnd_1
XFILLER_38_8 vccd1 vssd1 vccd1 vssd1 sky130_ef_sc_hd__decap_40_12
XFILLER_1_361 vccd1 vssd1 vccd1 vssd1 sky130_ef_sc_hd__decap_40_12
X_12086_ cell1.LE_0B.config_data\[14\] net1519 net906 vssd1 vssd1 vccd1 vccd1 _00521_
+ sky130_fd_sc_hd__mux2_1
Xclkbuf_leaf_88_clk clknet_4_11_0_clk vssd1 vssd1 vccd1 vccd1 clknet_leaf_88_clk sky130_fd_sc_hd__clkbuf_8
XANTENNA__11151__A1 _05921_ vssd1 vssd1 vccd1 vccd1 sky130_fd_sc_hd__diode_2
X_11037_ net285 net280 net297 net290 cell3.LEI0.config_data\[24\] cell3.LEI0.config_data\[25\]
+ vssd1 vssd1 vccd1 vccd1 _05991_ sky130_fd_sc_hd__mux4_1
XFILLER_49_354 vssd1 vssd1 vccd1 vccd1 sky130_fd_sc_hd__fill_1
XANTENNA__08698__A3 net323 vssd1 vssd1 vccd1 vccd1 sky130_fd_sc_hd__diode_2
XFILLER_37_527 vssd1 vssd1 vccd1 vccd1 sky130_fd_sc_hd__fill_8
XFILLER_94_83 vssd1 vssd1 vccd1 vccd1 sky130_fd_sc_hd__fill_1
XFILLER_91_154 vssd1 vssd1 vccd1 vccd1 sky130_fd_sc_hd__fill_1
X_12988_ cell3.LEI0.config_data\[9\] net1481 net945 vssd1 vssd1 vccd1 vccd1 _01416_
+ sky130_fd_sc_hd__mux2_1
XANTENNA__06638__A cell3.SB0.route_sel\[44\] vssd1 vssd1 vccd1 vccd1 sky130_fd_sc_hd__diode_2
XANTENNA__07233__S _02289_ vssd1 vssd1 vccd1 vccd1 sky130_fd_sc_hd__diode_2
XANTENNA__10257__A3 net35 vssd1 vssd1 vccd1 vccd1 sky130_fd_sc_hd__diode_2
XANTENNA__10662__A0 net15 vssd1 vssd1 vccd1 vccd1 sky130_fd_sc_hd__diode_2
X_11939_ cell0.SB0.route_sel\[45\] cell0.SB0.route_sel\[44\] net757 vssd1 vssd1 vccd1
+ vccd1 _00376_ sky130_fd_sc_hd__mux2_1
XFILLER_60_563 vssd1 vssd1 vccd1 vccd1 sky130_fd_sc_hd__fill_1
XTAP_TAPCELL_ROW_99_1800 vssd1 vccd1 sky130_fd_sc_hd__tapvpwrvgnd_1
XANTENNA__10447__X bus3_2\[6\] vssd1 vssd1 vccd1 vccd1 sky130_fd_sc_hd__diode_2
X_13609_ clknet_leaf_87_clk _00581_ net692 vssd1 vssd1 vccd1 vccd1 cell1.LEI0.config_data\[30\]
+ sky130_fd_sc_hd__dfrtp_1
XFILLER_20_427 vssd1 vssd1 vccd1 vccd1 sky130_fd_sc_hd__fill_1
Xclkbuf_leaf_12_clk clknet_4_3_0_clk vssd1 vssd1 vccd1 vccd1 clknet_leaf_12_clk sky130_fd_sc_hd__clkbuf_8
XANTENNA__08572__B _03468_ vssd1 vssd1 vccd1 vccd1 sky130_fd_sc_hd__diode_2
X_07130_ _02190_ _02191_ vssd1 vssd1 vccd1 vccd1 _02192_ sky130_fd_sc_hd__and2_1
XFILLER_9_472 vssd1 vssd1 vccd1 vccd1 sky130_fd_sc_hd__fill_2
XANTENNA__07830__A1 _02388_ vssd1 vssd1 vccd1 vccd1 sky130_fd_sc_hd__diode_2
XANTENNA__07830__B2 _02456_ vssd1 vssd1 vccd1 vccd1 sky130_fd_sc_hd__diode_2
X_07061_ cell0.CB_0.config_dataB\[24\] cell0.CB_0.config_dataB\[21\] cell0.CB_0.config_dataB\[20\]
+ vssd1 vssd1 vccd1 vccd1 _02125_ sky130_fd_sc_hd__or3b_1
XFILLER_142_830 vssd1 vssd1 vccd1 vccd1 sky130_fd_sc_hd__fill_8
XFILLER_133_318 vssd1 vssd1 vccd1 vccd1 sky130_fd_sc_hd__fill_1
Xoutput235 net235 vssd1 vssd1 vccd1 vccd1 SBwest_out[14] sky130_fd_sc_hd__buf_2
Xoutput202 net202 vssd1 vssd1 vccd1 vccd1 SBsouth_out[13] sky130_fd_sc_hd__buf_2
Xoutput224 net224 vssd1 vssd1 vccd1 vccd1 SBsouth_out[4] sky130_fd_sc_hd__buf_2
Xoutput213 net213 vssd1 vssd1 vccd1 vccd1 SBsouth_out[23] sky130_fd_sc_hd__buf_2
XFILLER_142_841 vssd1 vssd1 vccd1 vccd1 sky130_fd_sc_hd__fill_4
Xoutput246 net246 vssd1 vssd1 vccd1 vccd1 SBwest_out[24] sky130_fd_sc_hd__buf_2
XFILLER_114_554 vssd1 vssd1 vccd1 vccd1 sky130_fd_sc_hd__fill_1
XANTENNA__11278__X net169 vssd1 vssd1 vccd1 vccd1 sky130_fd_sc_hd__diode_2
Xoutput257 net257 vssd1 vssd1 vccd1 vccd1 SBwest_out[5] sky130_fd_sc_hd__buf_2
XTAP_TAPCELL_ROW_7_409 vssd1 vccd1 sky130_fd_sc_hd__tapvpwrvgnd_1
XANTENNA__10193__A2 net318 vssd1 vssd1 vccd1 vccd1 sky130_fd_sc_hd__diode_2
XFILLER_141_395 vssd1 vssd1 vccd1 vccd1 sky130_fd_sc_hd__fill_1
XANTENNA__09335__A1 net11 vssd1 vssd1 vccd1 vccd1 sky130_fd_sc_hd__diode_2
Xclkbuf_leaf_79_clk clknet_4_12_0_clk vssd1 vssd1 vccd1 vccd1 clknet_leaf_79_clk sky130_fd_sc_hd__clkbuf_8
X_07963_ _03006_ vssd1 vssd1 vccd1 vccd1 _03007_ sky130_fd_sc_hd__inv_2
XFILLER_4_81 vssd1 vssd1 vccd1 vccd1 sky130_fd_sc_hd__fill_2
XFILLER_114_49 vssd1 vssd1 vccd1 vccd1 sky130_fd_sc_hd__fill_2
XFILLER_114_27 vssd1 vssd1 vccd1 vccd1 sky130_fd_sc_hd__fill_1
X_09702_ cell3.SB0.route_sel\[112\] _01744_ cell3.SB0.route_sel\[115\] _01745_ _04715_
+ vssd1 vssd1 vccd1 vccd1 _04716_ sky130_fd_sc_hd__a221o_1
X_07894_ _02172_ _02920_ _02921_ _02074_ cell0.CB_0.config_dataA\[2\] vssd1 vssd1
+ vccd1 vccd1 _02938_ sky130_fd_sc_hd__a221o_1
X_06914_ _01980_ _01981_ _01979_ vssd1 vssd1 vccd1 vccd1 bus1_0\[7\] sky130_fd_sc_hd__a21boi_4
X_09633_ cell3.CB_1.config_dataA\[22\] cell3.CB_1.config_dataA\[23\] vssd1 vssd1 vccd1
+ vccd1 _04649_ sky130_fd_sc_hd__nand2_1
XANTENNA__07897__A1 bus2_0\[9\] vssd1 vssd1 vccd1 vccd1 sky130_fd_sc_hd__diode_2
X_06845_ _01869_ _01874_ _01912_ _01871_ vssd1 vssd1 vccd1 vccd1 _01914_ sky130_fd_sc_hd__a31o_1
XFILLER_28_538 vssd1 vssd1 vccd1 vccd1 sky130_fd_sc_hd__fill_2
X_09564_ _01629_ cell2.SB0.route_sel\[81\] _01631_ cell2.SB0.route_sel\[86\] _04581_
+ vssd1 vssd1 vccd1 vccd1 _04582_ sky130_fd_sc_hd__a221o_1
XFILLER_71_839 vssd1 vssd1 vccd1 vccd1 sky130_fd_sc_hd__fill_1
X_06776_ net333 _01843_ _01844_ _01840_ vssd1 vssd1 vccd1 vccd1 _01846_ sky130_fd_sc_hd__a22oi_2
X_08515_ _03517_ _03549_ _03550_ _03514_ cell1.CB_1.config_dataA\[7\] vssd1 vssd1
+ vccd1 vccd1 _03551_ sky130_fd_sc_hd__a221o_1
X_09495_ net277 _04514_ vssd1 vssd1 vccd1 vccd1 _04516_ sky130_fd_sc_hd__nor2_1
XANTENNA__07370__C _02424_ vssd1 vssd1 vccd1 vccd1 sky130_fd_sc_hd__diode_2
XANTENNA__10653__A0 net17 vssd1 vssd1 vccd1 vccd1 sky130_fd_sc_hd__diode_2
X_08446_ net31 net32 net2 net3 net498 cell1.CB_1.config_dataA\[1\] vssd1 vssd1 vccd1
+ vccd1 _03482_ sky130_fd_sc_hd__mux4_1
X_08377_ cell0.LEI0.config_data\[35\] _03413_ _03414_ vssd1 vssd1 vccd1 vccd1 _03415_
+ sky130_fd_sc_hd__o21a_1
XTAP_TAPCELL_ROW_137_2358 vssd1 vccd1 sky130_fd_sc_hd__tapvpwrvgnd_1
XFILLER_11_449 vssd1 vssd1 vccd1 vccd1 sky130_fd_sc_hd__fill_1
XANTENNA_fanout323_X net323 vssd1 vssd1 vccd1 vccd1 sky130_fd_sc_hd__diode_2
XFILLER_23_57 vssd1 vssd1 vccd1 vccd1 sky130_fd_sc_hd__fill_2
X_07328_ cell0.SB0.route_sel\[102\] cell0.SB0.route_sel\[103\] vssd1 vssd1 vccd1 vccd1
+ _02385_ sky130_fd_sc_hd__nand2b_1
XFILLER_139_57 vccd1 vssd1 vccd1 vssd1 sky130_ef_sc_hd__decap_40_12
XTAP_TAPCELL_ROW_137_2369 vssd1 vccd1 sky130_fd_sc_hd__tapvpwrvgnd_1
XFILLER_124_307 vssd1 vssd1 vccd1 vccd1 sky130_fd_sc_hd__fill_1
X_07259_ net312 _02316_ _02309_ vssd1 vssd1 vccd1 vccd1 _02318_ sky130_fd_sc_hd__a21bo_1
XFILLER_124_329 vssd1 vssd1 vccd1 vccd1 sky130_fd_sc_hd__fill_1
X_10270_ _05270_ _05269_ _05164_ vssd1 vssd1 vccd1 vccd1 _05271_ sky130_fd_sc_hd__mux2_1
XFILLER_3_615 vssd1 vssd1 vccd1 vccd1 sky130_fd_sc_hd__fill_1
XANTENNA__12224__S net824 vssd1 vssd1 vccd1 vccd1 sky130_fd_sc_hd__diode_2
Xfanout440 cell2.CB_1.config_dataA\[11\] vssd1 vssd1 vccd1 vccd1 net440 sky130_fd_sc_hd__buf_2
XANTENNA__09326__A1 net318 vssd1 vssd1 vccd1 vccd1 sky130_fd_sc_hd__diode_2
X_13960_ clknet_leaf_36_clk _00932_ net638 vssd1 vssd1 vccd1 vccd1 cell2.LEI0.config_data\[17\]
+ sky130_fd_sc_hd__dfrtp_1
Xfanout484 cell1.CB_0.config_dataB\[1\] vssd1 vssd1 vccd1 vccd1 net484 sky130_fd_sc_hd__clkbuf_2
XFILLER_74_600 vssd1 vssd1 vccd1 vccd1 sky130_fd_sc_hd__fill_1
Xfanout473 net474 vssd1 vssd1 vccd1 vccd1 net473 sky130_fd_sc_hd__buf_2
Xfanout462 cell1.CB_1.config_dataB\[0\] vssd1 vssd1 vccd1 vccd1 net462 sky130_fd_sc_hd__clkbuf_2
XANTENNA__08497__X _03533_ vssd1 vssd1 vccd1 vccd1 sky130_fd_sc_hd__diode_2
Xfanout451 cell1.CB_1.config_dataB\[16\] vssd1 vssd1 vccd1 vccd1 net451 sky130_fd_sc_hd__buf_2
X_12911_ net971 _05843_ net756 vssd1 vssd1 vccd1 vccd1 _01340_ sky130_fd_sc_hd__mux2_1
Xfanout495 cell1.CB_1.config_dataA\[5\] vssd1 vssd1 vccd1 vccd1 net495 sky130_fd_sc_hd__clkbuf_2
X_13891_ clknet_leaf_40_clk _00863_ net643 vssd1 vssd1 vccd1 vccd1 cell2.LE_1A.config_data\[14\]
+ sky130_fd_sc_hd__dfrtp_1
XFILLER_100_281 vssd1 vssd1 vccd1 vccd1 sky130_fd_sc_hd__fill_1
XANTENNA__07561__B net358 vssd1 vssd1 vccd1 vccd1 sky130_fd_sc_hd__diode_2
XANTENNA__08657__B _03489_ vssd1 vssd1 vccd1 vccd1 sky130_fd_sc_hd__diode_2
XFILLER_104_82 vssd1 vssd1 vccd1 vccd1 sky130_fd_sc_hd__fill_2
XANTENNA__09629__A2 _04642_ vssd1 vssd1 vccd1 vccd1 sky130_fd_sc_hd__diode_2
X_12842_ cell2.SB0.route_sel\[84\] cell2.SB0.route_sel\[83\] net797 vssd1 vssd1 vccd1
+ vccd1 _01271_ sky130_fd_sc_hd__mux2_1
X_12773_ cell2.SB0.route_sel\[15\] cell2.SB0.route_sel\[14\] net829 vssd1 vssd1 vccd1
+ vccd1 _01202_ sky130_fd_sc_hd__mux2_1
XFILLER_14_210 vssd1 vssd1 vccd1 vccd1 sky130_fd_sc_hd__fill_2
XFILLER_15_755 vssd1 vssd1 vccd1 vccd1 sky130_fd_sc_hd__fill_1
XANTENNA__06848__C1 _01915_ vssd1 vssd1 vccd1 vccd1 sky130_fd_sc_hd__diode_2
X_11724_ net1456 net548 _06374_ vssd1 vssd1 vccd1 vccd1 _00163_ sky130_fd_sc_hd__a21bo_1
XFILLER_9_15 vccd1 vssd1 vccd1 vssd1 sky130_ef_sc_hd__decap_40_12
XFILLER_15_777 vssd1 vssd1 vccd1 vccd1 sky130_fd_sc_hd__fill_1
X_14443_ clknet_leaf_67_clk net1432 net734 vssd1 vssd1 vccd1 vccd1 cell3.LEI0.config_data\[8\]
+ sky130_fd_sc_hd__dfrtp_1
X_11655_ cell0.CB_1.config_dataB\[1\] net510 net789 vssd1 vssd1 vccd1 vccd1 _00096_
+ sky130_fd_sc_hd__mux2_1
XFILLER_128_635 vssd1 vssd1 vccd1 vccd1 sky130_fd_sc_hd__fill_1
X_14374_ clknet_leaf_65_clk _01346_ net744 vssd1 vssd1 vccd1 vccd1 cell3.LE_1A.config_data\[5\]
+ sky130_fd_sc_hd__dfrtp_1
X_10606_ _01785_ net272 _05521_ net396 vssd1 vssd1 vccd1 vccd1 _05564_ sky130_fd_sc_hd__o31a_1
XANTENNA__09262__B1 _01589_ vssd1 vssd1 vccd1 vccd1 sky130_fd_sc_hd__diode_2
X_11586_ cell0.CB_1.config_dataA\[7\] net541 net788 vssd1 vssd1 vccd1 vccd1 _00027_
+ sky130_fd_sc_hd__mux2_1
XANTENNA_input86_X net86 vssd1 vssd1 vccd1 vccd1 sky130_fd_sc_hd__diode_2
XTAP_TAPCELL_ROW_12_488 vssd1 vccd1 sky130_fd_sc_hd__tapvpwrvgnd_1
X_10537_ net14 _05485_ _05490_ net13 cell3.CB_1.config_dataA\[8\] vssd1 vssd1 vccd1
+ vccd1 _05495_ sky130_fd_sc_hd__a221o_1
X_13325_ clknet_leaf_87_clk _00297_ net690 vssd1 vssd1 vccd1 vccd1 cell1.CB_0.config_dataB\[16\]
+ sky130_fd_sc_hd__dfstp_1
X_10468_ _05452_ _04688_ vssd1 vssd1 vccd1 vccd1 bus3_2\[13\] sky130_fd_sc_hd__and2b_2
X_13256_ clknet_leaf_10_clk net1121 net570 vssd1 vssd1 vccd1 vccd1 cell0.LEI0.config_data\[41\]
+ sky130_fd_sc_hd__dfrtp_1
XFILLER_142_148 vssd1 vssd1 vccd1 vccd1 sky130_fd_sc_hd__fill_2
XANTENNA__10714__Y _05672_ vssd1 vssd1 vccd1 vccd1 sky130_fd_sc_hd__diode_2
X_12207_ cell2.CB_1.config_dataA\[20\] cell2.CB_1.config_dataA\[19\] net835 vssd1
+ vssd1 vccd1 vccd1 _00640_ sky130_fd_sc_hd__mux2_1
X_10399_ _05136_ _05385_ vssd1 vssd1 vccd1 vccd1 _05398_ sky130_fd_sc_hd__nand2_1
X_13187_ clknet_leaf_13_clk _00159_ net590 vssd1 vssd1 vccd1 vccd1 cell0.LE_0B.config_data\[16\]
+ sky130_fd_sc_hd__dfrtp_1
X_12138_ net1103 cell1.LEI0.config_data\[19\] net903 vssd1 vssd1 vccd1 vccd1 _00571_
+ sky130_fd_sc_hd__mux2_1
XFILLER_2_681 vccd1 vssd1 vccd1 vssd1 sky130_ef_sc_hd__decap_40_12
X_12069_ net1543 net550 _06377_ vssd1 vssd1 vccd1 vccd1 _00505_ sky130_fd_sc_hd__a21bo_1
Xclkbuf_leaf_1_clk clknet_4_0_0_clk vssd1 vssd1 vccd1 vccd1 clknet_leaf_1_clk sky130_fd_sc_hd__clkbuf_8
XANTENNA__09868__A2 _04583_ vssd1 vssd1 vccd1 vccd1 sky130_fd_sc_hd__diode_2
XFILLER_38_847 vssd1 vssd1 vccd1 vccd1 sky130_fd_sc_hd__fill_1
X_06630_ cell3.SB0.route_sel\[34\] vssd1 vssd1 vccd1 vccd1 _01700_ sky130_fd_sc_hd__inv_2
XTAP_TAPCELL_ROW_121_2126 vssd1 vccd1 sky130_fd_sc_hd__tapvpwrvgnd_1
X_06561_ cell2.SB0.route_sel\[87\] vssd1 vssd1 vccd1 vccd1 _01631_ sky130_fd_sc_hd__inv_2
XFILLER_18_582 vssd1 vssd1 vccd1 vccd1 sky130_fd_sc_hd__fill_1
XANTENNA__13262__Q cell0.CB_0.config_data_inA vssd1 vssd1 vccd1 vccd1 sky130_fd_sc_hd__diode_2
X_09280_ _04208_ _04304_ vssd1 vssd1 vccd1 vccd1 _04306_ sky130_fd_sc_hd__or2_1
X_06492_ cell0.CB_0.config_dataB\[19\] vssd1 vssd1 vccd1 vccd1 _01562_ sky130_fd_sc_hd__inv_2
X_08300_ net506 _01877_ _03337_ net505 vssd1 vssd1 vccd1 vccd1 _03338_ sky130_fd_sc_hd__o211a_1
XFILLER_100_29 vssd1 vssd1 vccd1 vccd1 sky130_fd_sc_hd__fill_4
XANTENNA__07500__B1 bus2_0\[15\] vssd1 vssd1 vccd1 vccd1 sky130_fd_sc_hd__diode_2
X_08231_ net537 _02560_ _03270_ vssd1 vssd1 vccd1 vccd1 _03271_ sky130_fd_sc_hd__a21o_1
XANTENNA__08056__A1 bus2_0\[13\] vssd1 vssd1 vccd1 vccd1 sky130_fd_sc_hd__diode_2
X_08162_ net541 net542 vssd1 vssd1 vccd1 vccd1 _03202_ sky130_fd_sc_hd__or2_1
XANTENNA__07199__A net338 vssd1 vssd1 vccd1 vccd1 sky130_fd_sc_hd__diode_2
XTAP_TAPCELL_ROW_31_775 vssd1 vccd1 sky130_fd_sc_hd__tapvpwrvgnd_1
XTAP_TAPCELL_ROW_119_2099 vssd1 vccd1 sky130_fd_sc_hd__tapvpwrvgnd_1
XTAP_TAPCELL_ROW_119_2088 vssd1 vccd1 sky130_fd_sc_hd__tapvpwrvgnd_1
XFILLER_109_27 vccd1 vssd1 vccd1 vssd1 sky130_ef_sc_hd__decap_40_12
XANTENNA__14093__Q cell3.SB0.route_sel\[101\] vssd1 vssd1 vccd1 vccd1 sky130_fd_sc_hd__diode_2
X_07113_ cell2.SB0.route_sel\[79\] cell2.SB0.route_sel\[78\] _02175_ vssd1 vssd1 vccd1
+ vccd1 _02176_ sky130_fd_sc_hd__a21bo_1
X_08093_ cell0.CB_0.config_dataB\[16\] _03133_ _03134_ vssd1 vssd1 vccd1 vccd1 _03135_
+ sky130_fd_sc_hd__a21o_1
Xclkload61 clknet_leaf_31_clk vssd1 vssd1 vccd1 vccd1 clkload61/Y sky130_fd_sc_hd__inv_16
Xclkload50 clknet_leaf_27_clk vssd1 vssd1 vccd1 vccd1 clkload50/Y sky130_fd_sc_hd__inv_6
X_07044_ _02108_ _02106_ vssd1 vssd1 vccd1 vccd1 bus2_0\[8\] sky130_fd_sc_hd__and2b_2
XTAP_TAPCELL_ROW_132_2288 vssd1 vccd1 sky130_fd_sc_hd__tapvpwrvgnd_1
XFILLER_115_841 vssd1 vssd1 vccd1 vccd1 sky130_fd_sc_hd__fill_1
Xclkload94 clknet_leaf_87_clk vssd1 vssd1 vccd1 vccd1 clkload94/Y sky130_fd_sc_hd__inv_8
Xclkload83 clknet_leaf_115_clk vssd1 vssd1 vccd1 vccd1 clkload83/Y sky130_fd_sc_hd__clkinvlp_4
Xclkload72 clknet_leaf_107_clk vssd1 vssd1 vccd1 vccd1 clkload72/Y sky130_fd_sc_hd__clkinv_1
XFILLER_125_15 vccd1 vssd1 vccd1 vssd1 sky130_ef_sc_hd__decap_40_12
XFILLER_88_714 vssd1 vssd1 vccd1 vccd1 sky130_fd_sc_hd__fill_1
X_08995_ _03868_ _04020_ _04021_ _03871_ vssd1 vssd1 vccd1 vccd1 _04025_ sky130_fd_sc_hd__a22o_1
X_07946_ net512 _02894_ _02989_ net511 vssd1 vssd1 vccd1 vccd1 _02990_ sky130_fd_sc_hd__o211a_1
XANTENNA__07933__Y _02977_ vssd1 vssd1 vccd1 vccd1 sky130_fd_sc_hd__diode_2
XANTENNA__11115__A1 net41 vssd1 vssd1 vccd1 vccd1 sky130_fd_sc_hd__diode_2
XANTENNA__06790__A1 net93 vssd1 vssd1 vccd1 vccd1 sky130_fd_sc_hd__diode_2
XFILLER_29_847 vssd1 vssd1 vccd1 vccd1 sky130_fd_sc_hd__fill_1
X_07877_ net520 net521 vssd1 vssd1 vccd1 vccd1 _02921_ sky130_fd_sc_hd__nor2_1
XFILLER_141_69 vccd1 vssd1 vccd1 vssd1 sky130_ef_sc_hd__decap_40_12
X_09616_ _01733_ cell3.SB0.route_sel\[90\] cell3.SB0.route_sel\[95\] cell3.SB0.route_sel\[94\]
+ _04632_ vssd1 vssd1 vccd1 vccd1 _04633_ sky130_fd_sc_hd__o221a_1
XTAP_TAPCELL_ROW_48_1028 vssd1 vccd1 sky130_fd_sc_hd__tapvpwrvgnd_1
XTAP_TAPCELL_ROW_39_886 vssd1 vccd1 sky130_fd_sc_hd__tapvpwrvgnd_1
X_06828_ cell1.SB0.route_sel\[48\] cell1.SB0.route_sel\[49\] vssd1 vssd1 vccd1 vccd1
+ _01898_ sky130_fd_sc_hd__nor2_1
X_09547_ _04228_ _04534_ vssd1 vssd1 vccd1 vccd1 _04566_ sky130_fd_sc_hd__nor2_1
XTAP_TAPCELL_ROW_39_897 vssd1 vccd1 sky130_fd_sc_hd__tapvpwrvgnd_1
X_06759_ cell0.CB_1.le_outA vssd1 vssd1 vccd1 vccd1 _01829_ sky130_fd_sc_hd__inv_2
XANTENNA__13512__RESET_B net753 vssd1 vssd1 vccd1 vccd1 sky130_fd_sc_hd__diode_2
X_09478_ _01906_ _01993_ _02008_ _04497_ vssd1 vssd1 vccd1 vccd1 _04499_ sky130_fd_sc_hd__o211a_1
XTAP_TAPCELL_ROW_61_1228 vssd1 vccd1 sky130_fd_sc_hd__tapvpwrvgnd_1
XTAP_TAPCELL_ROW_61_1217 vssd1 vccd1 sky130_fd_sc_hd__tapvpwrvgnd_1
XANTENNA__10087__X _05088_ vssd1 vssd1 vccd1 vccd1 sky130_fd_sc_hd__diode_2
XANTENNA__06845__A2 _01874_ vssd1 vssd1 vccd1 vccd1 sky130_fd_sc_hd__diode_2
XFILLER_11_246 vssd1 vssd1 vccd1 vccd1 sky130_fd_sc_hd__fill_1
X_08429_ _02230_ _03464_ vssd1 vssd1 vccd1 vccd1 _03465_ sky130_fd_sc_hd__or2_4
XFILLER_11_268 vssd1 vssd1 vccd1 vccd1 sky130_fd_sc_hd__fill_1
X_11440_ cell1.SB0.route_sel\[2\] _01496_ cell1.SB0.route_sel\[6\] cell1.SB0.route_sel\[7\]
+ _06293_ vssd1 vssd1 vccd1 vccd1 _06294_ sky130_fd_sc_hd__o221a_1
Xclkload0 clknet_4_0_0_clk vssd1 vssd1 vccd1 vccd1 clkload0/Y sky130_fd_sc_hd__inv_6
XANTENNA__11051__A0 _05874_ vssd1 vssd1 vccd1 vccd1 sky130_fd_sc_hd__diode_2
XANTENNA__09595__Y _04612_ vssd1 vssd1 vccd1 vccd1 sky130_fd_sc_hd__diode_2
X_11371_ _01603_ cell0.SB0.route_sel\[34\] _01604_ cell0.SB0.route_sel\[37\] _06247_
+ vssd1 vssd1 vccd1 vccd1 _06248_ sky130_fd_sc_hd__a221o_1
X_10322_ net61 net62 net436 vssd1 vssd1 vccd1 vccd1 _05321_ sky130_fd_sc_hd__mux2_1
X_14090_ clknet_leaf_77_clk _01062_ net712 vssd1 vssd1 vccd1 vccd1 cell3.SB0.route_sel\[98\]
+ sky130_fd_sc_hd__dfstp_1
X_13110_ clknet_leaf_5_clk _00082_ net566 vssd1 vssd1 vccd1 vccd1 cell0.CB_0.config_dataA\[12\]
+ sky130_fd_sc_hd__dfstp_2
X_13041_ clknet_leaf_119_clk net1263 net594 vssd1 vssd1 vccd1 vccd1 cell0.LE_1B.config_data\[13\]
+ sky130_fd_sc_hd__dfrtp_1
XFILLER_3_445 vssd1 vssd1 vccd1 vccd1 sky130_fd_sc_hd__fill_2
X_10253_ net412 _05084_ vssd1 vssd1 vccd1 vccd1 _05254_ sky130_fd_sc_hd__nand2_1
XANTENNA_input46_A CBnorth_in[21] vssd1 vssd1 vccd1 vccd1 sky130_fd_sc_hd__diode_2
X_10184_ _05111_ _05167_ _05183_ _05184_ vssd1 vssd1 vccd1 vccd1 _05185_ sky130_fd_sc_hd__a211o_1
Xfanout281 net282 vssd1 vssd1 vccd1 vccd1 net281 sky130_fd_sc_hd__buf_2
XANTENNA__07572__A net342 vssd1 vssd1 vccd1 vccd1 sky130_fd_sc_hd__diode_2
X_13943_ clknet_leaf_40_clk _00915_ net642 vssd1 vssd1 vccd1 vccd1 cell2.LEI0.config_data\[0\]
+ sky130_fd_sc_hd__dfrtp_1
XFILLER_19_335 vssd1 vssd1 vccd1 vccd1 sky130_fd_sc_hd__fill_1
X_13874_ clknet_leaf_15_clk _00846_ net625 vssd1 vssd1 vccd1 vccd1 cell2.CB_1.config_dataB\[23\]
+ sky130_fd_sc_hd__dfstp_1
XFILLER_75_96 vssd1 vssd1 vccd1 vccd1 sky130_fd_sc_hd__fill_2
X_12825_ cell2.SB0.route_sel\[67\] cell2.SB0.route_sel\[66\] net815 vssd1 vssd1 vccd1
+ vccd1 _01254_ sky130_fd_sc_hd__mux2_1
XFILLER_91_51 vssd1 vssd1 vccd1 vccd1 sky130_fd_sc_hd__fill_2
XFILLER_61_146 vssd1 vssd1 vccd1 vccd1 sky130_fd_sc_hd__fill_1
XANTENNA__08286__A1 _02350_ vssd1 vssd1 vccd1 vccd1 sky130_fd_sc_hd__diode_2
XTAP_TAPCELL_ROW_17_558 vssd1 vccd1 sky130_fd_sc_hd__tapvpwrvgnd_1
XTAP_TAPCELL_ROW_17_569 vssd1 vccd1 sky130_fd_sc_hd__tapvpwrvgnd_1
X_12756_ cell3.CB_0.config_dataA\[23\] cell3.CB_0.config_dataA\[22\] net933 vssd1
+ vssd1 vccd1 vccd1 _01185_ sky130_fd_sc_hd__mux2_1
XFILLER_91_73 vssd1 vssd1 vccd1 vccd1 sky130_fd_sc_hd__fill_1
XFILLER_91_62 vssd1 vssd1 vccd1 vccd1 sky130_fd_sc_hd__fill_1
XFILLER_15_585 vssd1 vssd1 vccd1 vccd1 sky130_fd_sc_hd__fill_4
X_12687_ cell3.CB_1.config_dataA\[4\] cell3.CB_1.config_dataA\[3\] net937 vssd1 vssd1
+ vccd1 vccd1 _01116_ sky130_fd_sc_hd__mux2_1
X_11707_ net1249 net1169 net804 vssd1 vssd1 vccd1 vccd1 _00146_ sky130_fd_sc_hd__mux2_1
XFILLER_30_555 vssd1 vssd1 vccd1 vccd1 sky130_fd_sc_hd__fill_8
X_14426_ clknet_leaf_55_clk _01398_ net718 vssd1 vssd1 vccd1 vccd1 cell3.LE_0A.config_data\[13\]
+ sky130_fd_sc_hd__dfrtp_1
XANTENNA__08038__A1 bus2_0\[4\] vssd1 vssd1 vccd1 vccd1 sky130_fd_sc_hd__diode_2
XANTENNA__08038__B2 bus2_0\[5\] vssd1 vssd1 vccd1 vccd1 sky130_fd_sc_hd__diode_2
X_11638_ cell0.CB_0.config_dataA\[9\] cell0.CB_0.config_dataA\[8\] net771 vssd1 vssd1
+ vccd1 vccd1 _00079_ sky130_fd_sc_hd__mux2_1
X_14357_ clknet_leaf_71_clk _01329_ net730 vssd1 vssd1 vccd1 vccd1 cell3.CB_1.config_dataB\[14\]
+ sky130_fd_sc_hd__dfstp_1
XANTENNA__08589__A2 net23 vssd1 vssd1 vccd1 vccd1 sky130_fd_sc_hd__diode_2
XANTENNA__06922__Y _01989_ vssd1 vssd1 vccd1 vccd1 sky130_fd_sc_hd__diode_2
XANTENNA__08850__B _03881_ vssd1 vssd1 vccd1 vccd1 sky130_fd_sc_hd__diode_2
X_11569_ net1164 net1265 net799 vssd1 vssd1 vccd1 vccd1 _00010_ sky130_fd_sc_hd__mux2_1
X_13308_ clknet_leaf_102_clk _00280_ net677 vssd1 vssd1 vccd1 vccd1 cell1.CB_1.config_dataA\[24\]
+ sky130_fd_sc_hd__dfstp_1
XANTENNA__07261__A2 _02309_ vssd1 vssd1 vccd1 vccd1 sky130_fd_sc_hd__diode_2
XANTENNA__06651__A cell3.SB0.route_sel\[69\] vssd1 vssd1 vccd1 vccd1 sky130_fd_sc_hd__diode_2
X_14288_ clknet_leaf_8_clk _01260_ net572 vssd1 vssd1 vccd1 vccd1 cell2.SB0.route_sel\[73\]
+ sky130_fd_sc_hd__dfstp_1
XANTENNA__11345__A1 cell3.CB_0.le_outB vssd1 vssd1 vccd1 vccd1 sky130_fd_sc_hd__diode_2
XANTENNA__10148__A2 _05148_ vssd1 vssd1 vccd1 vccd1 sky130_fd_sc_hd__diode_2
X_13239_ clknet_leaf_11_clk net1227 net585 vssd1 vssd1 vccd1 vccd1 cell0.LEI0.config_data\[24\]
+ sky130_fd_sc_hd__dfrtp_1
XFILLER_41_3 vccd1 vssd1 vccd1 vssd1 sky130_ef_sc_hd__decap_40_12
XFILLER_97_577 vssd1 vssd1 vccd1 vccd1 sky130_fd_sc_hd__fill_8
X_08780_ _01662_ cell1.LE_1B.dff_out vssd1 vssd1 vccd1 vccd1 _03813_ sky130_fd_sc_hd__or2_1
XANTENNA__07753__Y _02799_ vssd1 vssd1 vccd1 vccd1 sky130_fd_sc_hd__diode_2
X_07800_ cell0.SB0.route_sel\[40\] cell0.SB0.route_sel\[41\] vssd1 vssd1 vccd1 vccd1
+ _02845_ sky130_fd_sc_hd__nand2b_1
XPHY_EDGE_ROW_127_Right_127 vssd1 vssd1 vccd1 vccd1 sky130_fd_sc_hd__decap_3
XFILLER_111_376 vssd1 vssd1 vccd1 vccd1 sky130_fd_sc_hd__fill_1
X_07731_ net329 _02777_ _02773_ vssd1 vssd1 vccd1 vccd1 _02778_ sky130_fd_sc_hd__mux2_1
X_07662_ _01862_ _02620_ vssd1 vssd1 vccd1 vccd1 _02710_ sky130_fd_sc_hd__nor2_1
X_09401_ _01705_ _01706_ vssd1 vssd1 vccd1 vccd1 _04424_ sky130_fd_sc_hd__nor2_1
X_06613_ cell1.CB_0.config_dataA\[17\] vssd1 vssd1 vccd1 vccd1 _01683_ sky130_fd_sc_hd__inv_2
XFILLER_1_93 vccd1 vssd1 vccd1 vssd1 sky130_ef_sc_hd__decap_40_12
X_07593_ _02642_ net334 _02641_ vssd1 vssd1 vccd1 vccd1 _02643_ sky130_fd_sc_hd__mux2_1
XTAP_TAPCELL_ROW_36_845 vssd1 vccd1 sky130_fd_sc_hd__tapvpwrvgnd_1
XFILLER_111_39 vccd1 vssd1 vccd1 vssd1 sky130_ef_sc_hd__decap_40_12
X_06544_ net111 vssd1 vssd1 vccd1 vccd1 _01614_ sky130_fd_sc_hd__inv_2
X_09332_ _04208_ _04356_ vssd1 vssd1 vccd1 vccd1 _04357_ sky130_fd_sc_hd__or2_1
XANTENNA__11281__A0 _05107_ vssd1 vssd1 vccd1 vccd1 sky130_fd_sc_hd__diode_2
XTAP_TAPCELL_ROW_101_1829 vssd1 vccd1 sky130_fd_sc_hd__tapvpwrvgnd_1
XTAP_TAPCELL_ROW_101_1818 vssd1 vccd1 sky130_fd_sc_hd__tapvpwrvgnd_1
X_09263_ cell2.SB0.route_sel\[19\] cell2.SB0.route_sel\[18\] _04287_ _04288_ _04284_
+ vssd1 vssd1 vccd1 vccd1 _04289_ sky130_fd_sc_hd__a41o_1
X_06475_ cell1.SB0.route_sel\[108\] vssd1 vssd1 vccd1 vccd1 _01545_ sky130_fd_sc_hd__inv_2
X_09194_ _04221_ net286 _04220_ vssd1 vssd1 vccd1 vccd1 _04222_ sky130_fd_sc_hd__mux2_1
X_08214_ net539 _02719_ _03253_ net538 vssd1 vssd1 vccd1 vccd1 _03254_ sky130_fd_sc_hd__o211a_1
XTAP_TAPCELL_ROW_134_2317 vssd1 vccd1 sky130_fd_sc_hd__tapvpwrvgnd_1
X_08145_ bus1_0\[5\] _03167_ _03169_ bus1_0\[4\] cell0.CB_1.config_dataA\[3\] vssd1
+ vssd1 vccd1 vccd1 _03185_ sky130_fd_sc_hd__a221o_1
XFILLER_112_9 vccd1 vssd1 vccd1 vssd1 sky130_ef_sc_hd__decap_40_12
XFILLER_136_25 vssd1 vssd1 vccd1 vccd1 sky130_fd_sc_hd__fill_2
X_08076_ _01827_ net346 net350 net340 cell0.LEI0.config_data\[27\] cell0.LEI0.config_data\[28\]
+ vssd1 vssd1 vccd1 vccd1 _03118_ sky130_fd_sc_hd__mux4_1
X_07027_ cell2.CB_1.le_outA _02089_ vssd1 vssd1 vccd1 vccd1 _02092_ sky130_fd_sc_hd__nor2_2
XFILLER_0_404 vssd1 vssd1 vccd1 vccd1 sky130_fd_sc_hd__fill_2
XFILLER_96_29 vccd1 vssd1 vccd1 vssd1 sky130_ef_sc_hd__decap_40_12
XANTENNA__08201__A1 _02136_ vssd1 vssd1 vccd1 vccd1 sky130_fd_sc_hd__diode_2
Xhold12 cell3.LE_1B.dff0_out vssd1 vssd1 vccd1 vccd1 net971 sky130_fd_sc_hd__dlygate4sd3_1
Xhold23 cell0.LE_0B.dff0_out vssd1 vssd1 vccd1 vccd1 net982 sky130_fd_sc_hd__dlygate4sd3_1
XFILLER_0_459 vssd1 vssd1 vccd1 vccd1 sky130_fd_sc_hd__fill_4
XANTENNA_fanout867_A net884 vssd1 vssd1 vccd1 vccd1 sky130_fd_sc_hd__diode_2
XANTENNA__08752__A2 net23 vssd1 vssd1 vccd1 vccd1 sky130_fd_sc_hd__diode_2
XANTENNA__07663__Y _02711_ vssd1 vssd1 vccd1 vccd1 sky130_fd_sc_hd__diode_2
Xhold56 cell3.LE_0B.config_data\[2\] vssd1 vssd1 vccd1 vccd1 net1015 sky130_fd_sc_hd__dlygate4sd3_1
XFILLER_102_365 vssd1 vssd1 vccd1 vccd1 sky130_fd_sc_hd__fill_1
Xhold34 cell0.LE_0A.config_data\[5\] vssd1 vssd1 vccd1 vccd1 net993 sky130_fd_sc_hd__dlygate4sd3_1
Xhold45 _00544_ vssd1 vssd1 vccd1 vccd1 net1004 sky130_fd_sc_hd__dlygate4sd3_1
X_08978_ _04009_ _03970_ _03968_ vssd1 vssd1 vccd1 vccd1 _04010_ sky130_fd_sc_hd__mux2_1
XANTENNA__07960__A0 bus2_0\[8\] vssd1 vssd1 vccd1 vccd1 sky130_fd_sc_hd__diode_2
Xhold89 cell0.LE_0A.config_data\[2\] vssd1 vssd1 vccd1 vccd1 net1048 sky130_fd_sc_hd__dlygate4sd3_1
Xhold67 _00515_ vssd1 vssd1 vccd1 vccd1 net1026 sky130_fd_sc_hd__dlygate4sd3_1
X_07929_ bus2_0\[12\] bus2_0\[13\] bus2_0\[14\] bus2_0\[15\] net515 net514 vssd1 vssd1
+ vccd1 vccd1 _02973_ sky130_fd_sc_hd__mux4_1
Xhold78 cell1.LE_0A.config_data\[13\] vssd1 vssd1 vccd1 vccd1 net1037 sky130_fd_sc_hd__dlygate4sd3_1
X_10940_ net379 _05893_ cell3.CB_0.config_dataA\[1\] vssd1 vssd1 vccd1 vccd1 _05894_
+ sky130_fd_sc_hd__o21a_1
XANTENNA__10847__A0 _05540_ vssd1 vssd1 vccd1 vccd1 sky130_fd_sc_hd__diode_2
XFILLER_16_305 vssd1 vssd1 vccd1 vccd1 sky130_fd_sc_hd__fill_2
XFILLER_17_839 vssd1 vssd1 vccd1 vccd1 sky130_fd_sc_hd__fill_1
XANTENNA__10311__A2 _05131_ vssd1 vssd1 vccd1 vccd1 sky130_fd_sc_hd__diode_2
XFILLER_44_658 vssd1 vssd1 vccd1 vccd1 sky130_fd_sc_hd__fill_1
X_10871_ net298 net291 cell3.LEI0.config_data\[45\] vssd1 vssd1 vccd1 vccd1 _05827_
+ sky130_fd_sc_hd__mux2_1
X_12610_ cell3.SB0.route_sel\[75\] cell3.SB0.route_sel\[74\] net876 vssd1 vssd1 vccd1
+ vccd1 _01039_ sky130_fd_sc_hd__mux2_1
XANTENNA_input100_A SBwest_in[12] vssd1 vssd1 vccd1 vccd1 sky130_fd_sc_hd__diode_2
XANTENNA__06736__A cell3.CB_0.config_dataA\[0\] vssd1 vssd1 vccd1 vccd1 sky130_fd_sc_hd__diode_2
X_13590_ clknet_leaf_94_clk _00562_ net694 vssd1 vssd1 vccd1 vccd1 cell1.LEI0.config_data\[11\]
+ sky130_fd_sc_hd__dfrtp_1
XFILLER_12_500 vssd1 vssd1 vccd1 vccd1 sky130_fd_sc_hd__fill_2
XTAP_TAPCELL_ROW_14_517 vssd1 vccd1 sky130_fd_sc_hd__tapvpwrvgnd_1
XANTENNA__10614__A3 net20 vssd1 vssd1 vccd1 vccd1 sky130_fd_sc_hd__diode_2
X_12541_ cell3.SB0.route_sel\[6\] cell3.SB0.route_sel\[5\] net919 vssd1 vssd1 vccd1
+ vccd1 _00970_ sky130_fd_sc_hd__mux2_1
X_12472_ net1151 net1124 net814 vssd1 vssd1 vccd1 vccd1 _00902_ sky130_fd_sc_hd__mux2_1
XFILLER_138_752 vssd1 vssd1 vccd1 vccd1 sky130_fd_sc_hd__fill_4
X_14211_ clknet_leaf_58_clk _01183_ net720 vssd1 vssd1 vccd1 vccd1 cell3.CB_0.config_dataA\[21\]
+ sky130_fd_sc_hd__dfstp_1
XANTENNA__09768__A1 bus3_2\[7\] vssd1 vssd1 vccd1 vccd1 sky130_fd_sc_hd__diode_2
X_11423_ _02422_ _06282_ vssd1 vssd1 vccd1 vccd1 net202 sky130_fd_sc_hd__nor2_1
XANTENNA_9 _04475_ vssd1 vssd1 vccd1 vccd1 sky130_fd_sc_hd__diode_2
XANTENNA__10545__X _05503_ vssd1 vssd1 vccd1 vccd1 sky130_fd_sc_hd__diode_2
XFILLER_6_27 vssd1 vssd1 vccd1 vccd1 sky130_fd_sc_hd__fill_1
X_11354_ net283 _04684_ _04685_ _06242_ vssd1 vssd1 vccd1 vccd1 net187 sky130_fd_sc_hd__a22o_1
X_14142_ clknet_leaf_77_clk _01114_ net726 vssd1 vssd1 vccd1 vccd1 cell3.CB_1.config_dataA\[2\]
+ sky130_fd_sc_hd__dfstp_1
XTAP_TAPCELL_ROW_74_1419 vssd1 vccd1 sky130_fd_sc_hd__tapvpwrvgnd_1
XANTENNA__08015__X _03057_ vssd1 vssd1 vccd1 vccd1 sky130_fd_sc_hd__diode_2
X_11285_ clknet_leaf_37_clk cell2.LE_1B.edge_mode vssd1 vssd1 vccd1 vccd1 cell2.LE_1B.sel_clk
+ sky130_fd_sc_hd__xnor2_2
X_10305_ _01757_ _05297_ _05298_ _05303_ vssd1 vssd1 vccd1 vccd1 _05304_ sky130_fd_sc_hd__o31a_1
XANTENNA__11327__A1 _05924_ vssd1 vssd1 vccd1 vccd1 sky130_fd_sc_hd__diode_2
X_14073_ clknet_leaf_82_clk _01045_ net670 vssd1 vssd1 vccd1 vccd1 cell3.SB0.route_sel\[81\]
+ sky130_fd_sc_hd__dfstp_1
XANTENNA_input49_X net49 vssd1 vssd1 vccd1 vccd1 sky130_fd_sc_hd__diode_2
X_13024_ cell3.LEI0.config_data\[45\] net1110 net948 vssd1 vssd1 vccd1 vccd1 _01452_
+ sky130_fd_sc_hd__mux2_1
X_10236_ _05152_ _05235_ _05236_ _05156_ cell2.CB_0.config_dataA\[17\] vssd1 vssd1
+ vccd1 vccd1 _05237_ sky130_fd_sc_hd__a221o_1
XFILLER_112_118 vssd1 vssd1 vccd1 vccd1 sky130_fd_sc_hd__fill_1
XANTENNA_output152_A net152 vssd1 vssd1 vccd1 vccd1 sky130_fd_sc_hd__diode_2
X_10167_ net421 cell2.CB_0.config_dataA\[1\] vssd1 vssd1 vccd1 vccd1 _05168_ sky130_fd_sc_hd__nor2_1
XFILLER_20_8 vccd1 vssd1 vccd1 vssd1 sky130_ef_sc_hd__decap_40_12
X_10098_ net417 net419 vssd1 vssd1 vccd1 vccd1 _05099_ sky130_fd_sc_hd__or2_1
XTAP_TAPCELL_ROW_89_1640 vssd1 vccd1 sky130_fd_sc_hd__tapvpwrvgnd_1
XFILLER_47_430 vssd1 vssd1 vccd1 vccd1 sky130_fd_sc_hd__fill_4
X_13926_ clknet_leaf_25_clk _00898_ net608 vssd1 vssd1 vccd1 vccd1 cell2.LE_0A.config_data\[5\]
+ sky130_fd_sc_hd__dfrtp_1
XANTENNA__09006__B _03820_ vssd1 vssd1 vccd1 vccd1 sky130_fd_sc_hd__diode_2
XANTENNA__09299__A3 _03861_ vssd1 vssd1 vccd1 vccd1 sky130_fd_sc_hd__diode_2
XANTENNA__10302__A2 net34 vssd1 vssd1 vccd1 vccd1 sky130_fd_sc_hd__diode_2
XFILLER_90_720 vssd1 vssd1 vccd1 vccd1 sky130_fd_sc_hd__fill_1
XFILLER_34_102 vssd1 vssd1 vccd1 vccd1 sky130_fd_sc_hd__fill_4
X_13857_ clknet_leaf_40_clk _00829_ net643 vssd1 vssd1 vccd1 vccd1 cell2.CB_1.config_dataB\[6\]
+ sky130_fd_sc_hd__dfstp_1
XTAP_TAPCELL_ROW_33_804 vssd1 vccd1 sky130_fd_sc_hd__tapvpwrvgnd_1
X_12808_ cell2.SB0.route_sel\[50\] cell2.SB0.route_sel\[49\] net812 vssd1 vssd1 vccd1
+ vccd1 _01237_ sky130_fd_sc_hd__mux2_1
X_13788_ clknet_leaf_105_clk _00760_ net664 vssd1 vssd1 vccd1 vccd1 cell1.SB0.route_sel\[65\]
+ sky130_fd_sc_hd__dfstp_1
XANTENNA__11271__B _05093_ vssd1 vssd1 vccd1 vccd1 sky130_fd_sc_hd__diode_2
XANTENNA__11263__A0 _05131_ vssd1 vssd1 vccd1 vccd1 sky130_fd_sc_hd__diode_2
X_12739_ net376 net377 net925 vssd1 vssd1 vccd1 vccd1 _01168_ sky130_fd_sc_hd__mux2_1
XFILLER_15_382 vssd1 vssd1 vccd1 vccd1 sky130_fd_sc_hd__fill_1
XFILLER_15_393 vssd1 vssd1 vccd1 vccd1 sky130_fd_sc_hd__fill_2
XFILLER_89_3 vssd1 vssd1 vccd1 vccd1 sky130_fd_sc_hd__fill_4
XANTENNA_clkbuf_0_clk_A clk vssd1 vssd1 vccd1 vccd1 sky130_fd_sc_hd__diode_2
X_14409_ clknet_leaf_61_clk _01381_ net740 vssd1 vssd1 vccd1 vccd1 cell3.LE_0B.reset_val
+ sky130_fd_sc_hd__dfrtp_1
XANTENNA__11015__A0 net53 vssd1 vssd1 vccd1 vccd1 sky130_fd_sc_hd__diode_2
XANTENNA__10369__A2 _05088_ vssd1 vssd1 vccd1 vccd1 sky130_fd_sc_hd__diode_2
XTAP_TAPCELL_ROW_116_2047 vssd1 vccd1 sky130_fd_sc_hd__tapvpwrvgnd_1
Xhold526 cell2.LE_0B.dff1_out vssd1 vssd1 vccd1 vccd1 net1485 sky130_fd_sc_hd__dlygate4sd3_1
Xhold504 cell3.LEI0.config_data\[23\] vssd1 vssd1 vccd1 vccd1 net1463 sky130_fd_sc_hd__dlygate4sd3_1
Xhold515 cell2.LEI0.config_data\[37\] vssd1 vssd1 vccd1 vccd1 net1474 sky130_fd_sc_hd__dlygate4sd3_1
Xhold559 cell3.LE_0A.config_data\[0\] vssd1 vssd1 vccd1 vccd1 net1518 sky130_fd_sc_hd__dlygate4sd3_1
X_09950_ _01822_ net305 net315 net302 cell2.LEI0.config_data\[9\] cell2.LEI0.config_data\[10\]
+ vssd1 vssd1 vccd1 vccd1 _04954_ sky130_fd_sc_hd__mux4_1
Xhold537 _00192_ vssd1 vssd1 vccd1 vccd1 net1496 sky130_fd_sc_hd__dlygate4sd3_1
Xmax_cap267 _01953_ vssd1 vssd1 vccd1 vccd1 net267 sky130_fd_sc_hd__clkbuf_2
Xhold548 cell1.LE_1B.config_data\[5\] vssd1 vssd1 vccd1 vccd1 net1507 sky130_fd_sc_hd__dlygate4sd3_1
X_08901_ net331 net326 net337 net324 cell1.LEI0.config_data\[0\] cell1.LEI0.config_data\[1\]
+ vssd1 vssd1 vccd1 vccd1 _03933_ sky130_fd_sc_hd__mux4_1
XANTENNA_clkbuf_4_9_0_clk_A clknet_0_clk vssd1 vssd1 vccd1 vccd1 sky130_fd_sc_hd__diode_2
XANTENNA__10902__Y _05856_ vssd1 vssd1 vccd1 vccd1 sky130_fd_sc_hd__diode_2
X_09881_ cell2.CB_1.config_dataA\[18\] _04878_ _04882_ _04886_ vssd1 vssd1 vccd1 vccd1
+ _04887_ sky130_fd_sc_hd__and4_1
XANTENNA__08195__A0 bus1_0\[12\] vssd1 vssd1 vccd1 vccd1 sky130_fd_sc_hd__diode_2
XTAP_TAPCELL_ROW_111_1980 vssd1 vccd1 sky130_fd_sc_hd__tapvpwrvgnd_1
XANTENNA__07924__B _02301_ vssd1 vssd1 vccd1 vccd1 sky130_fd_sc_hd__diode_2
X_08832_ net471 _03858_ _03863_ net469 vssd1 vssd1 vccd1 vccd1 _03864_ sky130_fd_sc_hd__o211a_1
XPHY_EDGE_ROW_29_Left_172 vssd1 vssd1 vccd1 vccd1 sky130_fd_sc_hd__decap_3
XFILLER_85_569 vccd1 vssd1 vccd1 vssd1 sky130_ef_sc_hd__decap_40_12
XFILLER_85_558 vssd1 vssd1 vccd1 vccd1 sky130_fd_sc_hd__fill_2
X_08763_ _03791_ _03795_ _03796_ vssd1 vssd1 vccd1 vccd1 _03797_ sky130_fd_sc_hd__a21oi_1
XFILLER_122_27 vssd1 vssd1 vccd1 vccd1 sky130_fd_sc_hd__fill_1
XANTENNA__09144__C1 net352 vssd1 vssd1 vccd1 vccd1 sky130_fd_sc_hd__diode_2
X_07714_ _02758_ _02760_ vssd1 vssd1 vccd1 vccd1 _02761_ sky130_fd_sc_hd__and2_2
XFILLER_93_591 vssd1 vssd1 vccd1 vccd1 sky130_fd_sc_hd__fill_1
X_08694_ net461 _03504_ _03727_ net460 vssd1 vssd1 vccd1 vccd1 _03728_ sky130_fd_sc_hd__o211a_1
XANTENNA__10844__A3 net25 vssd1 vssd1 vccd1 vccd1 sky130_fd_sc_hd__diode_2
X_07645_ net327 _02693_ vssd1 vssd1 vccd1 vccd1 _02694_ sky130_fd_sc_hd__nand2_1
XANTENNA__11462__A _01979_ vssd1 vssd1 vccd1 vccd1 sky130_fd_sc_hd__diode_2
XFILLER_14_809 vssd1 vssd1 vccd1 vccd1 sky130_fd_sc_hd__fill_1
XFILLER_25_157 vssd1 vssd1 vccd1 vccd1 sky130_fd_sc_hd__fill_2
XFILLER_53_477 vssd1 vssd1 vccd1 vccd1 sky130_fd_sc_hd__fill_1
X_07576_ cell0.CB_0.le_outB _02030_ _02623_ vssd1 vssd1 vccd1 vccd1 _02626_ sky130_fd_sc_hd__and3_1
XTAP_TAPCELL_ROW_0_289 vssd1 vccd1 sky130_fd_sc_hd__tapvpwrvgnd_1
XFILLER_25_179 vssd1 vssd1 vccd1 vccd1 sky130_fd_sc_hd__fill_1
X_09315_ _02000_ _04187_ net58 vssd1 vssd1 vccd1 vccd1 _04340_ sky130_fd_sc_hd__a21o_1
XANTENNA__09998__A1 bus3_2\[9\] vssd1 vssd1 vccd1 vccd1 sky130_fd_sc_hd__diode_2
X_06527_ cell0.SB0.route_sel\[26\] vssd1 vssd1 vccd1 vccd1 _01597_ sky130_fd_sc_hd__inv_2
XFILLER_15_69 vssd1 vssd1 vccd1 vccd1 sky130_fd_sc_hd__fill_1
X_09246_ cell3.SB0.route_sel\[8\] cell3.SB0.route_sel\[9\] _04264_ _04272_ net935
+ vssd1 vssd1 vccd1 vccd1 _04273_ sky130_fd_sc_hd__a311oi_2
XPHY_EDGE_ROW_38_Left_181 vssd1 vssd1 vccd1 vccd1 sky130_fd_sc_hd__decap_3
X_06458_ cell1.SB0.route_sel\[72\] vssd1 vssd1 vccd1 vccd1 _01528_ sky130_fd_sc_hd__inv_2
XANTENNA__06843__X _01912_ vssd1 vssd1 vccd1 vccd1 sky130_fd_sc_hd__diode_2
X_09177_ _04201_ _04203_ _04204_ vssd1 vssd1 vccd1 vccd1 _04205_ sky130_fd_sc_hd__a21oi_2
X_06389_ cell0.SB0.route_sel\[55\] vssd1 vssd1 vccd1 vccd1 _01459_ sky130_fd_sc_hd__inv_2
XFILLER_31_57 vssd1 vssd1 vccd1 vccd1 sky130_fd_sc_hd__fill_4
XFILLER_119_284 vssd1 vssd1 vccd1 vccd1 sky130_fd_sc_hd__fill_1
XFILLER_107_435 vssd1 vssd1 vccd1 vccd1 sky130_fd_sc_hd__fill_2
X_08128_ net544 net546 vssd1 vssd1 vccd1 vccd1 _03168_ sky130_fd_sc_hd__nand2b_1
X_08059_ _03097_ _03100_ cell0.CB_0.config_dataB\[13\] vssd1 vssd1 vccd1 vccd1 _03101_
+ sky130_fd_sc_hd__or3b_1
X_11070_ net285 net279 net297 net290 cell3.LEI0.config_data\[36\] cell3.LEI0.config_data\[37\]
+ vssd1 vssd1 vccd1 vccd1 _06024_ sky130_fd_sc_hd__mux4_1
XTAP_TAPCELL_ROW_56_1149 vssd1 vccd1 sky130_fd_sc_hd__tapvpwrvgnd_1
XFILLER_0_201 vssd1 vssd1 vccd1 vccd1 sky130_fd_sc_hd__fill_1
XFILLER_1_713 vssd1 vssd1 vccd1 vccd1 sky130_fd_sc_hd__fill_8
X_10021_ net312 cell2.CB_0.le_outB cell2.LEI0.config_data\[33\] vssd1 vssd1 vccd1
+ vccd1 _05025_ sky130_fd_sc_hd__mux2_1
XANTENNA__13945__RESET_B net635 vssd1 vssd1 vccd1 vccd1 sky130_fd_sc_hd__diode_2
XPHY_EDGE_ROW_47_Left_190 vssd1 vssd1 vccd1 vccd1 sky130_fd_sc_hd__decap_3
Xinput102 SBwest_in[14] vssd1 vssd1 vccd1 vccd1 net102 sky130_fd_sc_hd__buf_1
XFILLER_0_234 vssd1 vssd1 vccd1 vccd1 sky130_fd_sc_hd__fill_2
XFILLER_102_162 vssd1 vssd1 vccd1 vccd1 sky130_fd_sc_hd__fill_4
Xinput113 SBwest_in[24] vssd1 vssd1 vccd1 vccd1 net113 sky130_fd_sc_hd__buf_1
XFILLER_1_779 vssd1 vssd1 vccd1 vccd1 sky130_fd_sc_hd__fill_4
Xinput124 SBwest_in[5] vssd1 vssd1 vccd1 vccd1 net124 sky130_fd_sc_hd__clkbuf_1
XANTENNA__08725__A2 _03489_ vssd1 vssd1 vccd1 vccd1 sky130_fd_sc_hd__diode_2
XANTENNA__07326__S _02377_ vssd1 vssd1 vccd1 vccd1 sky130_fd_sc_hd__diode_2
XFILLER_76_558 vssd1 vssd1 vccd1 vccd1 sky130_fd_sc_hd__fill_1
XFILLER_76_547 vssd1 vssd1 vccd1 vccd1 sky130_fd_sc_hd__fill_1
XANTENNA__08489__A1 net28 vssd1 vssd1 vccd1 vccd1 sky130_fd_sc_hd__diode_2
XANTENNA__10296__A1 net37 vssd1 vssd1 vccd1 vccd1 sky130_fd_sc_hd__diode_2
X_13711_ clknet_leaf_28_clk _00683_ net617 vssd1 vssd1 vccd1 vccd1 cell2.CB_0.config_dataA\[13\]
+ sky130_fd_sc_hd__dfstp_1
XFILLER_84_591 vssd1 vssd1 vccd1 vccd1 sky130_fd_sc_hd__fill_1
XANTENNA__07850__A _02716_ vssd1 vssd1 vccd1 vccd1 sky130_fd_sc_hd__diode_2
X_11972_ cell0.SB0.route_sel\[78\] cell0.SB0.route_sel\[77\] net784 vssd1 vssd1 vccd1
+ vccd1 _00409_ sky130_fd_sc_hd__mux2_1
XANTENNA_clkbuf_leaf_2_clk_A clknet_4_0_0_clk vssd1 vssd1 vccd1 vccd1 sky130_fd_sc_hd__diode_2
XANTENNA__08489__B2 net27 vssd1 vssd1 vccd1 vccd1 sky130_fd_sc_hd__diode_2
X_10923_ cell3.SB0.route_sel\[69\] cell3.SB0.route_sel\[68\] vssd1 vssd1 vccd1 vccd1
+ _05877_ sky130_fd_sc_hd__and2b_1
XANTENNA__11372__A _02804_ vssd1 vssd1 vccd1 vccd1 sky130_fd_sc_hd__diode_2
XFILLER_44_433 vssd1 vssd1 vccd1 vccd1 sky130_fd_sc_hd__fill_1
XPHY_EDGE_ROW_19_Right_19 vssd1 vssd1 vccd1 vccd1 sky130_fd_sc_hd__decap_3
X_13642_ clknet_leaf_38_clk _00614_ net645 vssd1 vssd1 vccd1 vccd1 cell2.LE_1B.config_data\[14\]
+ sky130_fd_sc_hd__dfrtp_1
X_10854_ _05478_ _05475_ cell3.CB_1.config_dataB\[15\] vssd1 vssd1 vccd1 vccd1 _05810_
+ sky130_fd_sc_hd__mux2_1
XTAP_TAPCELL_ROW_84_1570 vssd1 vccd1 sky130_fd_sc_hd__tapvpwrvgnd_1
XANTENNA_input103_X net103 vssd1 vssd1 vccd1 vccd1 sky130_fd_sc_hd__diode_2
XFILLER_16_168 vssd1 vssd1 vccd1 vccd1 sky130_fd_sc_hd__fill_1
X_13573_ clknet_leaf_117_clk _00545_ net671 vssd1 vssd1 vccd1 vccd1 cell1.LE_0A.config_data\[16\]
+ sky130_fd_sc_hd__dfrtp_1
X_12524_ net1349 cell2.LEI0.config_data\[37\] net839 vssd1 vssd1 vccd1 vccd1 _00953_
+ sky130_fd_sc_hd__mux2_1
X_10785_ net8 net9 net10 net11 net369 net368 vssd1 vssd1 vccd1 vccd1 _05741_ sky130_fd_sc_hd__mux4_1
XANTENNA__07849__X _02893_ vssd1 vssd1 vccd1 vccd1 sky130_fd_sc_hd__diode_2
X_12455_ net1138 cell2.LE_0B.config_data\[14\] net842 vssd1 vssd1 vccd1 vccd1 _00886_
+ sky130_fd_sc_hd__mux2_1
XANTENNA__10275__X _05276_ vssd1 vssd1 vccd1 vccd1 sky130_fd_sc_hd__diode_2
X_12386_ cell1.SB0.route_sel\[124\] cell1.SB0.route_sel\[123\] net872 vssd1 vssd1
+ vccd1 vccd1 _00819_ sky130_fd_sc_hd__mux2_1
X_11406_ _01473_ cell0.SB0.route_sel\[82\] vssd1 vssd1 vccd1 vccd1 _06271_ sky130_fd_sc_hd__nand2_1
X_14125_ clknet_leaf_64_clk net1203 net748 vssd1 vssd1 vccd1 vccd1 cell3.LE_1B.config_data\[5\]
+ sky130_fd_sc_hd__dfrtp_1
XANTENNA__10220__A1 net62 vssd1 vssd1 vccd1 vccd1 sky130_fd_sc_hd__diode_2
X_11337_ net275 _05897_ _04457_ vssd1 vssd1 vccd1 vccd1 _06234_ sky130_fd_sc_hd__a21o_1
XFILLER_99_628 vssd1 vssd1 vccd1 vccd1 sky130_fd_sc_hd__fill_1
XPHY_EDGE_ROW_28_Right_28 vssd1 vssd1 vccd1 vccd1 sky130_fd_sc_hd__decap_3
XANTENNA__13897__SET_B net752 vssd1 vssd1 vccd1 vccd1 sky130_fd_sc_hd__diode_2
X_11268_ _02095_ _02097_ _05097_ vssd1 vssd1 vccd1 vccd1 _06202_ sky130_fd_sc_hd__o21ai_1
XFILLER_113_449 vssd1 vssd1 vccd1 vccd1 sky130_fd_sc_hd__fill_2
X_14056_ clknet_leaf_46_clk _01028_ net701 vssd1 vssd1 vccd1 vccd1 cell3.SB0.route_sel\[64\]
+ sky130_fd_sc_hd__dfstp_2
X_13007_ net1524 cell3.LEI0.config_data\[27\] net951 vssd1 vssd1 vccd1 vccd1 _01435_
+ sky130_fd_sc_hd__mux2_1
X_11199_ _05902_ _05898_ _05893_ _05890_ net383 net382 vssd1 vssd1 vccd1 vccd1 _06151_
+ sky130_fd_sc_hd__mux4_1
X_10219_ cell2.CB_0.config_dataA\[13\] cell2.CB_0.config_dataA\[12\] vssd1 vssd1 vccd1
+ vccd1 _05220_ sky130_fd_sc_hd__nor2_1
XFILLER_67_503 vssd1 vssd1 vccd1 vccd1 sky130_fd_sc_hd__fill_1
XANTENNA__10170__B _05144_ vssd1 vssd1 vccd1 vccd1 sky130_fd_sc_hd__diode_2
XFILLER_94_355 vssd1 vssd1 vccd1 vccd1 sky130_fd_sc_hd__fill_1
XPHY_EDGE_ROW_37_Right_37 vssd1 vssd1 vccd1 vccd1 sky130_fd_sc_hd__decap_3
X_13909_ clknet_leaf_35_clk _00881_ net637 vssd1 vssd1 vccd1 vccd1 cell2.LE_0B.config_data\[10\]
+ sky130_fd_sc_hd__dfrtp_1
X_07430_ _01862_ _02336_ vssd1 vssd1 vccd1 vccd1 _02484_ sky130_fd_sc_hd__nor2_1
XTAP_TAPCELL_ROW_46_995 vssd1 vccd1 sky130_fd_sc_hd__tapvpwrvgnd_1
X_07361_ net354 _02340_ bus2_0\[13\] vssd1 vssd1 vccd1 vccd1 _02417_ sky130_fd_sc_hd__o21a_1
XFILLER_16_680 vssd1 vssd1 vccd1 vccd1 sky130_fd_sc_hd__fill_1
XANTENNA__09687__A net24 vssd1 vssd1 vccd1 vccd1 sky130_fd_sc_hd__diode_2
X_09100_ net475 net476 vssd1 vssd1 vccd1 vccd1 _04130_ sky130_fd_sc_hd__nand2b_1
X_09031_ net484 _04059_ _04060_ vssd1 vssd1 vccd1 vccd1 _04061_ sky130_fd_sc_hd__a21oi_1
XANTENNA__08652__A1 net458 vssd1 vssd1 vccd1 vccd1 sky130_fd_sc_hd__diode_2
XFILLER_31_694 vssd1 vssd1 vccd1 vccd1 sky130_fd_sc_hd__fill_1
X_07292_ _02346_ _02349_ vssd1 vssd1 vccd1 vccd1 _02350_ sky130_fd_sc_hd__and2_2
XPHY_EDGE_ROW_46_Right_46 vssd1 vssd1 vccd1 vccd1 sky130_fd_sc_hd__decap_3
Xhold301 cell3.LE_1B.config_data\[0\] vssd1 vssd1 vccd1 vccd1 net1260 sky130_fd_sc_hd__dlygate4sd3_1
XFILLER_7_81 vccd1 vssd1 vccd1 vssd1 sky130_ef_sc_hd__decap_40_12
Xhold323 cell3.LEI0.config_data\[32\] vssd1 vssd1 vccd1 vccd1 net1282 sky130_fd_sc_hd__dlygate4sd3_1
XFILLER_117_27 vccd1 vssd1 vccd1 vssd1 sky130_ef_sc_hd__decap_40_12
Xhold312 cell1.LEI0.config_data\[41\] vssd1 vssd1 vccd1 vccd1 net1271 sky130_fd_sc_hd__dlygate4sd3_1
Xhold334 cell0.LE_1A.config_data\[6\] vssd1 vssd1 vccd1 vccd1 net1293 sky130_fd_sc_hd__dlygate4sd3_1
Xhold345 cell3.LE_1B.config_data\[15\] vssd1 vssd1 vccd1 vccd1 net1304 sky130_fd_sc_hd__dlygate4sd3_1
Xhold356 cell2.LE_1A.config_data\[14\] vssd1 vssd1 vccd1 vccd1 net1315 sky130_fd_sc_hd__dlygate4sd3_1
Xhold378 cell0.LEI0.config_data\[22\] vssd1 vssd1 vccd1 vccd1 net1337 sky130_fd_sc_hd__dlygate4sd3_1
Xhold367 cell1.LEI0.config_data\[46\] vssd1 vssd1 vccd1 vccd1 net1326 sky130_fd_sc_hd__dlygate4sd3_1
Xhold389 cell2.LE_1B.config_data\[14\] vssd1 vssd1 vccd1 vccd1 net1348 sky130_fd_sc_hd__dlygate4sd3_1
Xfanout825 net827 vssd1 vssd1 vccd1 vccd1 net825 sky130_fd_sc_hd__clkbuf_4
Xfanout814 net828 vssd1 vssd1 vccd1 vccd1 net814 sky130_fd_sc_hd__buf_2
X_09933_ cell2.CB_1.config_dataB\[2\] _04935_ _04936_ _04933_ vssd1 vssd1 vccd1 vccd1
+ _04937_ sky130_fd_sc_hd__a31o_1
Xfanout803 net805 vssd1 vssd1 vccd1 vccd1 net803 sky130_fd_sc_hd__clkbuf_4
XANTENNA__08168__A0 bus1_0\[6\] vssd1 vssd1 vccd1 vccd1 sky130_fd_sc_hd__diode_2
XTAP_TAPCELL_ROW_129_2249 vssd1 vccd1 sky130_fd_sc_hd__tapvpwrvgnd_1
XTAP_TAPCELL_ROW_129_2238 vssd1 vccd1 sky130_fd_sc_hd__tapvpwrvgnd_1
Xfanout847 net854 vssd1 vssd1 vccd1 vccd1 net847 sky130_fd_sc_hd__clkbuf_2
X_09864_ cell2.CB_1.config_dataA\[14\] _04863_ _04868_ _04869_ vssd1 vssd1 vccd1 vccd1
+ _04870_ sky130_fd_sc_hd__o211a_1
Xfanout836 net837 vssd1 vssd1 vccd1 vccd1 net836 sky130_fd_sc_hd__clkbuf_2
Xfanout858 net863 vssd1 vssd1 vccd1 vccd1 net858 sky130_fd_sc_hd__clkbuf_4
XFILLER_133_15 vccd1 vssd1 vccd1 vssd1 sky130_ef_sc_hd__decap_40_12
XTAP_TAPCELL_ROW_51_1068 vssd1 vccd1 sky130_fd_sc_hd__tapvpwrvgnd_1
X_08815_ cell1.SB0.route_sel\[74\] cell1.SB0.route_sel\[75\] cell1.SB0.route_sel\[77\]
+ _01531_ vssd1 vssd1 vccd1 vccd1 _03847_ sky130_fd_sc_hd__o22a_1
Xfanout869 net871 vssd1 vssd1 vccd1 vccd1 net869 sky130_fd_sc_hd__clkbuf_4
X_09795_ _04527_ _04794_ vssd1 vssd1 vccd1 vccd1 _04801_ sky130_fd_sc_hd__nor2_1
XPHY_EDGE_ROW_55_Right_55 vssd1 vssd1 vccd1 vccd1 sky130_fd_sc_hd__decap_3
XTAP_TAPCELL_ROW_51_1079 vssd1 vccd1 sky130_fd_sc_hd__tapvpwrvgnd_1
XANTENNA_fanout565_A net575 vssd1 vssd1 vccd1 vccd1 sky130_fd_sc_hd__diode_2
XTAP_TAPCELL_ROW_142_2449 vssd1 vccd1 sky130_fd_sc_hd__tapvpwrvgnd_1
XTAP_TAPCELL_ROW_142_2438 vssd1 vccd1 sky130_fd_sc_hd__tapvpwrvgnd_1
XANTENNA__10278__A1 cell2.LE_0A.config_data\[16\] vssd1 vssd1 vccd1 vccd1 sky130_fd_sc_hd__diode_2
XFILLER_54_731 vssd1 vssd1 vccd1 vccd1 sky130_fd_sc_hd__fill_1
XFILLER_39_783 vssd1 vssd1 vccd1 vccd1 sky130_fd_sc_hd__fill_1
X_08746_ _02444_ _03493_ _03773_ vssd1 vssd1 vccd1 vccd1 _03780_ sky130_fd_sc_hd__o21ai_1
XANTENNA_fanout732_A net733 vssd1 vssd1 vccd1 vccd1 sky130_fd_sc_hd__diode_2
XFILLER_81_550 vssd1 vssd1 vccd1 vccd1 sky130_fd_sc_hd__fill_2
XANTENNA_fanout353_X net353 vssd1 vssd1 vccd1 vccd1 sky130_fd_sc_hd__diode_2
XFILLER_26_433 vssd1 vssd1 vccd1 vccd1 sky130_fd_sc_hd__fill_1
X_08677_ net461 _03465_ vssd1 vssd1 vccd1 vccd1 _03711_ sky130_fd_sc_hd__or2_1
X_07628_ cell0.SB0.route_sel\[12\] cell0.SB0.route_sel\[13\] _01816_ cell0.SB0.route_sel\[8\]
+ _02676_ vssd1 vssd1 vccd1 vccd1 _02677_ sky130_fd_sc_hd__o221a_1
XFILLER_14_606 vssd1 vssd1 vccd1 vccd1 sky130_fd_sc_hd__fill_8
XFILLER_26_477 vssd1 vssd1 vccd1 vccd1 sky130_fd_sc_hd__fill_2
XANTENNA__12975__A0 cell3.LE_0A.reset_val vssd1 vssd1 vccd1 vccd1 sky130_fd_sc_hd__diode_2
XFILLER_9_109 vssd1 vssd1 vccd1 vccd1 sky130_fd_sc_hd__fill_2
X_07559_ cell0.CB_1.config_dataB\[22\] cell0.CB_1.config_dataB\[23\] vssd1 vssd1 vccd1
+ vccd1 _02609_ sky130_fd_sc_hd__or2_1
XTAP_TAPCELL_ROW_24_667 vssd1 vccd1 sky130_fd_sc_hd__tapvpwrvgnd_1
XANTENNA__09840__B1 _04555_ vssd1 vssd1 vccd1 vccd1 sky130_fd_sc_hd__diode_2
X_10570_ _04662_ _05527_ vssd1 vssd1 vccd1 vccd1 _05528_ sky130_fd_sc_hd__nand2_2
XPHY_EDGE_ROW_64_Right_64 vssd1 vssd1 vccd1 vccd1 sky130_fd_sc_hd__decap_3
XANTENNA__08643__B2 net27 vssd1 vssd1 vccd1 vccd1 sky130_fd_sc_hd__diode_2
XANTENNA__08643__A1 net28 vssd1 vssd1 vccd1 vccd1 sky130_fd_sc_hd__diode_2
XANTENNA__12227__S net824 vssd1 vssd1 vccd1 vccd1 sky130_fd_sc_hd__diode_2
X_09229_ cell2.SB0.route_sel\[8\] cell2.SB0.route_sel\[9\] _04255_ vssd1 vssd1 vccd1
+ vccd1 _04256_ sky130_fd_sc_hd__a21oi_1
XANTENNA__10095__X _05096_ vssd1 vssd1 vccd1 vccd1 sky130_fd_sc_hd__diode_2
X_12240_ cell2.CB_0.config_dataA\[3\] cell2.CB_0.config_dataA\[2\] net818 vssd1 vssd1
+ vccd1 vccd1 _00673_ sky130_fd_sc_hd__mux2_1
XFILLER_5_337 vssd1 vssd1 vccd1 vccd1 sky130_fd_sc_hd__fill_4
X_12171_ net1274 cell2.LE_1B.config_data\[3\] net852 vssd1 vssd1 vccd1 vccd1 _00604_
+ sky130_fd_sc_hd__mux2_1
XANTENNA__10202__A1 _05111_ vssd1 vssd1 vccd1 vccd1 sky130_fd_sc_hd__diode_2
XANTENNA__08946__A2 _03885_ vssd1 vssd1 vccd1 vccd1 sky130_fd_sc_hd__diode_2
XFILLER_108_799 vssd1 vssd1 vccd1 vccd1 sky130_fd_sc_hd__fill_1
X_11122_ net286 net279 net297 net290 cell3.LEI0.config_data\[3\] cell3.LEI0.config_data\[4\]
+ vssd1 vssd1 vccd1 vccd1 _06074_ sky130_fd_sc_hd__mux4_1
X_11053_ _05879_ _05998_ vssd1 vssd1 vccd1 vccd1 _06007_ sky130_fd_sc_hd__nor2_1
XFILLER_3_39 vccd1 vssd1 vccd1 vssd1 sky130_ef_sc_hd__decap_40_12
X_10004_ cell2.CB_1.config_dataB\[12\] _05006_ _05007_ _05004_ cell2.CB_1.config_dataB\[13\]
+ vssd1 vssd1 vccd1 vccd1 _05008_ sky130_fd_sc_hd__o311a_1
XFILLER_103_471 vssd1 vssd1 vccd1 vccd1 sky130_fd_sc_hd__fill_2
XPHY_EDGE_ROW_73_Right_73 vssd1 vssd1 vccd1 vccd1 sky130_fd_sc_hd__decap_3
XANTENNA__09659__B1 _04673_ vssd1 vssd1 vccd1 vccd1 sky130_fd_sc_hd__diode_2
XTAP_TAPCELL_ROW_4_370 vssd1 vccd1 sky130_fd_sc_hd__tapvpwrvgnd_1
X_11955_ cell0.SB0.route_sel\[61\] cell0.SB0.route_sel\[60\] net761 vssd1 vssd1 vccd1
+ vccd1 _00392_ sky130_fd_sc_hd__mux2_1
X_10906_ _01742_ cell3.SB0.route_sel\[111\] cell3.SB0.route_sel\[108\] _01743_ _05859_
+ vssd1 vssd1 vccd1 vccd1 _05860_ sky130_fd_sc_hd__a221o_1
XFILLER_60_734 vssd1 vssd1 vccd1 vccd1 sky130_fd_sc_hd__fill_1
X_11886_ cell1.CB_0.config_dataA\[17\] net463 net883 vssd1 vssd1 vccd1 vccd1 _00323_
+ sky130_fd_sc_hd__mux2_1
X_13625_ clknet_leaf_86_clk _00597_ net685 vssd1 vssd1 vccd1 vccd1 cell1.LEI0.config_data\[46\]
+ sky130_fd_sc_hd__dfrtp_1
XTAP_TAPCELL_ROW_43_954 vssd1 vccd1 sky130_fd_sc_hd__tapvpwrvgnd_1
X_10837_ cell3.CB_1.config_dataB\[14\] _05761_ _05766_ _05787_ _05792_ vssd1 vssd1
+ vccd1 vccd1 _05793_ sky130_fd_sc_hd__a311oi_4
XPHY_EDGE_ROW_82_Right_82 vssd1 vssd1 vccd1 vccd1 sky130_fd_sc_hd__decap_3
X_10768_ net369 net368 vssd1 vssd1 vccd1 vccd1 _05724_ sky130_fd_sc_hd__nor2_1
X_13556_ clknet_1_0__leaf_cell1.LE_0B.sel_clk _00528_ net753 vssd1 vssd1 vccd1 vccd1
+ cell1.LE_0B.dff0_out sky130_fd_sc_hd__dfrtp_1
XFILLER_40_480 vssd1 vssd1 vccd1 vccd1 sky130_fd_sc_hd__fill_1
XFILLER_12_171 vssd1 vssd1 vccd1 vccd1 sky130_fd_sc_hd__fill_1
X_12507_ cell2.LEI0.config_data\[21\] net1078 net850 vssd1 vssd1 vccd1 vccd1 _00936_
+ sky130_fd_sc_hd__mux2_1
XFILLER_118_508 vssd1 vssd1 vccd1 vccd1 sky130_fd_sc_hd__fill_1
XFILLER_12_193 vssd1 vssd1 vccd1 vccd1 sky130_fd_sc_hd__fill_2
X_13487_ clknet_leaf_101_clk _00459_ net677 vssd1 vssd1 vccd1 vccd1 cell1.CB_1.config_dataB\[0\]
+ sky130_fd_sc_hd__dfstp_1
X_12438_ net755 _04920_ vssd1 vssd1 vccd1 vccd1 _06382_ sky130_fd_sc_hd__nand2_1
XTAP_TAPCELL_ROW_113_2006 vssd1 vccd1 sky130_fd_sc_hd__tapvpwrvgnd_1
XTAP_TAPCELL_ROW_97_1761 vssd1 vccd1 sky130_fd_sc_hd__tapvpwrvgnd_1
X_10699_ net390 _05655_ _05656_ vssd1 vssd1 vccd1 vccd1 _05657_ sky130_fd_sc_hd__a21bo_1
XANTENNA__08398__A0 bus1_0\[0\] vssd1 vssd1 vccd1 vccd1 sky130_fd_sc_hd__diode_2
XANTENNA__10744__A2 _05548_ vssd1 vssd1 vccd1 vccd1 sky130_fd_sc_hd__diode_2
X_12369_ cell1.SB0.route_sel\[107\] cell1.SB0.route_sel\[106\] net874 vssd1 vssd1
+ vccd1 vccd1 _00802_ sky130_fd_sc_hd__mux2_1
X_14108_ clknet_leaf_78_clk _01080_ net711 vssd1 vssd1 vccd1 vccd1 cell3.SB0.route_sel\[116\]
+ sky130_fd_sc_hd__dfstp_1
X_14039_ clknet_leaf_49_clk _01011_ net706 vssd1 vssd1 vccd1 vccd1 cell3.SB0.route_sel\[47\]
+ sky130_fd_sc_hd__dfstp_1
XFILLER_101_419 vssd1 vssd1 vccd1 vccd1 sky130_fd_sc_hd__fill_4
XFILLER_101_408 vssd1 vssd1 vccd1 vccd1 sky130_fd_sc_hd__fill_1
XPHY_EDGE_ROW_91_Right_91 vssd1 vssd1 vccd1 vccd1 sky130_fd_sc_hd__decap_3
X_06930_ _01996_ vssd1 vssd1 vccd1 vccd1 _01997_ sky130_fd_sc_hd__inv_2
XANTENNA__08165__A3 bus1_0\[3\] vssd1 vssd1 vccd1 vccd1 sky130_fd_sc_hd__diode_2
X_06861_ _01611_ cell2.SB0.route_sel\[49\] _01612_ cell2.SB0.route_sel\[50\] _01929_
+ vssd1 vssd1 vccd1 vccd1 _01930_ sky130_fd_sc_hd__o221a_1
XANTENNA__08570__A0 net31 vssd1 vssd1 vccd1 vccd1 sky130_fd_sc_hd__diode_2
X_08600_ cell1.CB_1.config_dataA\[17\] _03627_ _03635_ vssd1 vssd1 vccd1 vccd1 _03636_
+ sky130_fd_sc_hd__o21a_1
X_09580_ _04315_ _04545_ vssd1 vssd1 vccd1 vccd1 _04598_ sky130_fd_sc_hd__nor2_1
X_06792_ cell0.CB_0.config_dataA\[24\] cell0.CB_0.config_dataA\[20\] cell0.CB_0.config_dataA\[21\]
+ vssd1 vssd1 vccd1 vccd1 _01862_ sky130_fd_sc_hd__or3b_2
XANTENNA__07761__Y _02807_ vssd1 vssd1 vccd1 vccd1 sky130_fd_sc_hd__diode_2
XTAP_TAPCELL_ROW_124_2168 vssd1 vccd1 sky130_fd_sc_hd__tapvpwrvgnd_1
X_08531_ net493 net494 _03498_ _03566_ cell1.CB_1.config_dataA\[7\] vssd1 vssd1 vccd1
+ vccd1 _03567_ sky130_fd_sc_hd__o311a_1
XANTENNA__07490__A net349 vssd1 vssd1 vccd1 vccd1 sky130_fd_sc_hd__diode_2
X_08462_ _03496_ _03497_ _02373_ vssd1 vssd1 vccd1 vccd1 _03498_ sky130_fd_sc_hd__a21boi_4
X_07413_ net815 _02467_ vssd1 vssd1 vccd1 vccd1 _02468_ sky130_fd_sc_hd__or2_1
XANTENNA__06884__B1 _01951_ vssd1 vssd1 vccd1 vccd1 sky130_fd_sc_hd__diode_2
X_08393_ _01493_ _03429_ _03430_ vssd1 vssd1 vccd1 vccd1 _03431_ sky130_fd_sc_hd__and3_1
X_07344_ _02396_ _02399_ _02400_ vssd1 vssd1 vccd1 vccd1 _02401_ sky130_fd_sc_hd__a21oi_1
XTAP_TAPCELL_ROW_21_626 vssd1 vccd1 sky130_fd_sc_hd__tapvpwrvgnd_1
XFILLER_12_26 vssd1 vssd1 vccd1 vccd1 sky130_fd_sc_hd__fill_2
X_07275_ cell0.SB0.route_sel\[101\] cell0.SB0.route_sel\[100\] net68 vssd1 vssd1 vccd1
+ vccd1 _02333_ sky130_fd_sc_hd__a21boi_1
XANTENNA__10983__A2 net56 vssd1 vssd1 vccd1 vccd1 sky130_fd_sc_hd__diode_2
X_09014_ net482 _03841_ _04043_ net481 vssd1 vssd1 vccd1 vccd1 _04044_ sky130_fd_sc_hd__o211a_1
XANTENNA__11886__S net883 vssd1 vssd1 vccd1 vccd1 sky130_fd_sc_hd__diode_2
Xhold153 _00613_ vssd1 vssd1 vccd1 vccd1 net1112 sky130_fd_sc_hd__dlygate4sd3_1
Xhold142 cell3.LE_1A.config_data\[12\] vssd1 vssd1 vccd1 vccd1 net1101 sky130_fd_sc_hd__dlygate4sd3_1
Xhold120 cell3.LE_1A.config_data\[11\] vssd1 vssd1 vccd1 vccd1 net1079 sky130_fd_sc_hd__dlygate4sd3_1
Xhold131 _00005_ vssd1 vssd1 vccd1 vccd1 net1090 sky130_fd_sc_hd__dlygate4sd3_1
XFILLER_2_307 vssd1 vssd1 vccd1 vccd1 sky130_fd_sc_hd__fill_1
Xhold175 cell3.LE_0A.config_data\[4\] vssd1 vssd1 vccd1 vccd1 net1134 sky130_fd_sc_hd__dlygate4sd3_1
Xhold186 cell2.LEI0.config_data\[8\] vssd1 vssd1 vccd1 vccd1 net1145 sky130_fd_sc_hd__dlygate4sd3_1
XTAP_TAPCELL_ROW_53_1108 vssd1 vccd1 sky130_fd_sc_hd__tapvpwrvgnd_1
Xhold164 _00134_ vssd1 vssd1 vccd1 vccd1 net1123 sky130_fd_sc_hd__dlygate4sd3_1
XANTENNA__07665__A net347 vssd1 vssd1 vccd1 vccd1 sky130_fd_sc_hd__diode_2
XFILLER_132_577 vssd1 vssd1 vccd1 vccd1 sky130_fd_sc_hd__fill_1
Xfanout622 net623 vssd1 vssd1 vccd1 vccd1 net622 sky130_fd_sc_hd__clkbuf_2
Xfanout633 net635 vssd1 vssd1 vccd1 vccd1 net633 sky130_fd_sc_hd__clkbuf_4
X_09916_ _01754_ cell2.LE_1A.dff_out vssd1 vssd1 vccd1 vccd1 _04921_ sky130_fd_sc_hd__or2_1
Xfanout611 net612 vssd1 vssd1 vccd1 vccd1 net611 sky130_fd_sc_hd__clkbuf_4
Xhold197 cell1.LE_0B.config_data\[2\] vssd1 vssd1 vccd1 vccd1 net1156 sky130_fd_sc_hd__dlygate4sd3_1
Xfanout600 net601 vssd1 vssd1 vccd1 vccd1 net600 sky130_fd_sc_hd__dlymetal6s2s_1
Xfanout644 net649 vssd1 vssd1 vccd1 vccd1 net644 sky130_fd_sc_hd__clkbuf_2
Xfanout666 net667 vssd1 vssd1 vccd1 vccd1 net666 sky130_fd_sc_hd__clkbuf_4
XANTENNA__08156__A3 cell0.CB_1.le_outB vssd1 vssd1 vccd1 vccd1 sky130_fd_sc_hd__diode_2
Xfanout655 net657 vssd1 vssd1 vccd1 vccd1 net655 sky130_fd_sc_hd__clkbuf_2
XANTENNA_fanout947_A net952 vssd1 vssd1 vccd1 vccd1 sky130_fd_sc_hd__diode_2
X_09847_ bus3_2\[6\] bus3_2\[7\] net442 vssd1 vssd1 vccd1 vccd1 _04853_ sky130_fd_sc_hd__mux2_1
Xfanout699 net700 vssd1 vssd1 vccd1 vccd1 net699 sky130_fd_sc_hd__buf_2
Xfanout688 net689 vssd1 vssd1 vccd1 vccd1 net688 sky130_fd_sc_hd__clkbuf_4
Xfanout677 net684 vssd1 vssd1 vccd1 vccd1 net677 sky130_fd_sc_hd__clkbuf_2
X_09778_ cell2.CB_1.config_dataA\[7\] _04781_ _04782_ _04783_ vssd1 vssd1 vccd1 vccd1
+ _04784_ sky130_fd_sc_hd__a31o_1
XFILLER_46_528 vssd1 vssd1 vccd1 vccd1 sky130_fd_sc_hd__fill_1
XTAP_TAPCELL_ROW_29_737 vssd1 vccd1 sky130_fd_sc_hd__tapvpwrvgnd_1
XANTENNA__14396__RESET_B net723 vssd1 vssd1 vccd1 vccd1 sky130_fd_sc_hd__diode_2
XTAP_TAPCELL_ROW_29_748 vssd1 vccd1 sky130_fd_sc_hd__tapvpwrvgnd_1
X_08729_ cell1.CB_1.config_dataB\[14\] _03750_ _03762_ vssd1 vssd1 vccd1 vccd1 _03763_
+ sky130_fd_sc_hd__or3b_1
X_11740_ net1018 cell0.LE_0A.config_data\[12\] net808 vssd1 vssd1 vccd1 vccd1 _00178_
+ sky130_fd_sc_hd__mux2_1
XFILLER_14_447 vssd1 vssd1 vccd1 vccd1 sky130_fd_sc_hd__fill_2
XFILLER_53_77 vssd1 vssd1 vccd1 vccd1 sky130_fd_sc_hd__fill_1
XFILLER_53_55 vssd1 vssd1 vccd1 vccd1 sky130_fd_sc_hd__fill_1
XTAP_TAPCELL_ROW_40_902 vssd1 vccd1 sky130_fd_sc_hd__tapvpwrvgnd_1
XANTENNA_fanout902_X net902 vssd1 vssd1 vccd1 vccd1 sky130_fd_sc_hd__diode_2
X_11671_ cell0.CB_1.config_dataB\[17\] net499 net786 vssd1 vssd1 vccd1 vccd1 _00112_
+ sky130_fd_sc_hd__mux2_1
XFILLER_139_121 vssd1 vssd1 vccd1 vccd1 sky130_fd_sc_hd__fill_1
X_14390_ clknet_1_0__leaf_cell3.LE_1A.sel_clk _01362_ net753 vssd1 vssd1 vccd1 vccd1
+ cell3.LE_1A.dff0_out sky130_fd_sc_hd__dfrtp_1
X_10622_ _05577_ _05578_ _05579_ _05575_ vssd1 vssd1 vccd1 vccd1 _05580_ sky130_fd_sc_hd__o31a_1
XTAP_TAPCELL_ROW_40_913 vssd1 vccd1 sky130_fd_sc_hd__tapvpwrvgnd_1
X_13410_ clknet_leaf_134_clk _00382_ net555 vssd1 vssd1 vccd1 vccd1 cell0.SB0.route_sel\[51\]
+ sky130_fd_sc_hd__dfstp_1
X_10553_ cell3.SB0.route_sel\[0\] _01673_ cell3.SB0.route_sel\[4\] cell3.SB0.route_sel\[5\]
+ vssd1 vssd1 vccd1 vccd1 _05511_ sky130_fd_sc_hd__o22a_1
X_13341_ clknet_leaf_83_clk _00313_ net671 vssd1 vssd1 vccd1 vccd1 cell1.CB_0.config_dataA\[7\]
+ sky130_fd_sc_hd__dfstp_2
XANTENNA__10974__A2 net298 vssd1 vssd1 vccd1 vccd1 sky130_fd_sc_hd__diode_2
X_13272_ clknet_leaf_93_clk _00244_ net693 vssd1 vssd1 vccd1 vccd1 cell1.LE_1B.config_data\[8\]
+ sky130_fd_sc_hd__dfrtp_1
XFILLER_6_657 vccd1 vssd1 vccd1 vssd1 sky130_ef_sc_hd__decap_40_12
XANTENNA_input76_A SBsouth_in[1] vssd1 vssd1 vccd1 vccd1 sky130_fd_sc_hd__diode_2
XFILLER_10_697 vssd1 vssd1 vccd1 vccd1 sky130_fd_sc_hd__fill_2
X_10484_ _05457_ net334 _02641_ vssd1 vssd1 vccd1 vccd1 net134 sky130_fd_sc_hd__mux2_1
X_12223_ net426 net428 net824 vssd1 vssd1 vccd1 vccd1 _00656_ sky130_fd_sc_hd__mux2_1
XANTENNA__06750__Y _01820_ vssd1 vssd1 vccd1 vccd1 sky130_fd_sc_hd__diode_2
XTAP_TAPCELL_ROW_79_1491 vssd1 vccd1 sky130_fd_sc_hd__tapvpwrvgnd_1
XANTENNA__09041__A1 bus3_1\[13\] vssd1 vssd1 vccd1 vccd1 sky130_fd_sc_hd__diode_2
XANTENNA__07846__Y _02890_ vssd1 vssd1 vccd1 vccd1 sky130_fd_sc_hd__diode_2
XANTENNA__08919__A2 _03858_ vssd1 vssd1 vccd1 vccd1 sky130_fd_sc_hd__diode_2
XFILLER_5_178 vccd1 vssd1 vccd1 vssd1 sky130_ef_sc_hd__decap_40_12
X_12154_ cell1.LEI0.config_data\[36\] net1218 net903 vssd1 vssd1 vccd1 vccd1 _00587_
+ sky130_fd_sc_hd__mux2_1
XTAP_TAPCELL_ROW_9_440 vssd1 vccd1 sky130_fd_sc_hd__tapvpwrvgnd_1
X_11105_ _01796_ net388 _05883_ _01795_ vssd1 vssd1 vccd1 vccd1 _06057_ sky130_fd_sc_hd__o31a_1
XFILLER_96_428 vssd1 vssd1 vccd1 vccd1 sky130_fd_sc_hd__fill_1
XTAP_TAPCELL_ROW_92_1691 vssd1 vccd1 sky130_fd_sc_hd__tapvpwrvgnd_1
XFILLER_78_74 vssd1 vssd1 vccd1 vccd1 sky130_fd_sc_hd__fill_1
Xclkbuf_1_1__f_cell0.LE_1B.sel_clk clknet_0_cell0.LE_1B.sel_clk vssd1 vssd1 vccd1
+ vccd1 clknet_1_1__leaf_cell0.LE_1B.sel_clk sky130_fd_sc_hd__clkbuf_16
XANTENNA_input31_X net31 vssd1 vssd1 vccd1 vccd1 sky130_fd_sc_hd__diode_2
XFILLER_78_96 vssd1 vssd1 vccd1 vccd1 sky130_fd_sc_hd__fill_1
X_12085_ net1519 cell1.LE_0B.config_data\[12\] net906 vssd1 vssd1 vccd1 vccd1 _00520_
+ sky130_fd_sc_hd__mux2_1
XFILLER_1_373 vccd1 vssd1 vccd1 vssd1 sky130_ef_sc_hd__decap_40_12
X_11036_ cell3.CB_0.config_dataA\[14\] _05975_ _05989_ vssd1 vssd1 vccd1 vccd1 _05990_
+ sky130_fd_sc_hd__nor3_1
XANTENNA_output232_A net232 vssd1 vssd1 vccd1 vccd1 sky130_fd_sc_hd__diode_2
XFILLER_76_141 vssd1 vssd1 vccd1 vccd1 sky130_fd_sc_hd__fill_2
XANTENNA__11384__X net258 vssd1 vssd1 vccd1 vccd1 sky130_fd_sc_hd__diode_2
XANTENNA__09895__A3 _04399_ vssd1 vssd1 vccd1 vccd1 sky130_fd_sc_hd__diode_2
XFILLER_76_174 vssd1 vssd1 vccd1 vccd1 sky130_fd_sc_hd__fill_1
XANTENNA__06919__A net267 vssd1 vssd1 vccd1 vccd1 sky130_fd_sc_hd__diode_2
XFILLER_92_656 vssd1 vssd1 vccd1 vccd1 sky130_fd_sc_hd__fill_1
X_12987_ cell3.LEI0.config_data\[8\] net1431 net945 vssd1 vssd1 vccd1 vccd1 _01415_
+ sky130_fd_sc_hd__mux2_1
XANTENNA__08304__A0 net350 vssd1 vssd1 vccd1 vccd1 sky130_fd_sc_hd__diode_2
XFILLER_45_583 vssd1 vssd1 vccd1 vccd1 sky130_fd_sc_hd__fill_1
XFILLER_17_274 vssd1 vssd1 vccd1 vccd1 sky130_fd_sc_hd__fill_1
XFILLER_17_296 vssd1 vssd1 vccd1 vccd1 sky130_fd_sc_hd__fill_2
X_11938_ cell0.SB0.route_sel\[44\] cell0.SB0.route_sel\[43\] net757 vssd1 vssd1 vccd1
+ vccd1 _00375_ sky130_fd_sc_hd__mux2_1
XANTENNA__10662__A1 net16 vssd1 vssd1 vccd1 vccd1 sky130_fd_sc_hd__diode_2
X_11869_ cell1.CB_0.config_dataA\[0\] net1384 net896 vssd1 vssd1 vccd1 vccd1 _00306_
+ sky130_fd_sc_hd__mux2_1
XANTENNA__06866__B1 _01931_ vssd1 vssd1 vccd1 vccd1 sky130_fd_sc_hd__diode_2
X_13608_ clknet_leaf_87_clk _00580_ net689 vssd1 vssd1 vccd1 vccd1 cell1.LEI0.config_data\[29\]
+ sky130_fd_sc_hd__dfrtp_1
X_13539_ clknet_leaf_73_clk _00511_ net729 vssd1 vssd1 vccd1 vccd1 cell1.LE_0B.config_data\[4\]
+ sky130_fd_sc_hd__dfrtp_1
X_07060_ _02123_ vssd1 vssd1 vccd1 vccd1 _02124_ sky130_fd_sc_hd__inv_2
XANTENNA__06941__X _02008_ vssd1 vssd1 vccd1 vccd1 sky130_fd_sc_hd__diode_2
XFILLER_142_820 vssd1 vssd1 vccd1 vccd1 sky130_fd_sc_hd__fill_4
Xoutput225 net225 vssd1 vssd1 vccd1 vccd1 SBsouth_out[5] sky130_fd_sc_hd__buf_2
Xoutput203 net203 vssd1 vssd1 vccd1 vccd1 SBsouth_out[14] sky130_fd_sc_hd__buf_2
Xoutput214 net214 vssd1 vssd1 vccd1 vccd1 SBsouth_out[24] sky130_fd_sc_hd__buf_2
Xoutput247 net247 vssd1 vssd1 vccd1 vccd1 SBwest_out[25] sky130_fd_sc_hd__buf_2
Xoutput236 net236 vssd1 vssd1 vccd1 vccd1 SBwest_out[15] sky130_fd_sc_hd__buf_2
Xoutput258 net258 vssd1 vssd1 vccd1 vccd1 SBwest_out[6] sky130_fd_sc_hd__buf_2
XANTENNA__09583__A2 _04600_ vssd1 vssd1 vccd1 vccd1 sky130_fd_sc_hd__diode_2
XANTENNA__08080__S _03057_ vssd1 vssd1 vccd1 vccd1 sky130_fd_sc_hd__diode_2
XFILLER_99_299 vssd1 vssd1 vccd1 vccd1 sky130_fd_sc_hd__fill_1
X_09701_ cell3.SB0.route_sel\[118\] cell3.SB0.route_sel\[119\] vssd1 vssd1 vccd1 vccd1
+ _04715_ sky130_fd_sc_hd__nor2_1
X_07962_ _03004_ _03005_ cell0.CB_0.config_dataA\[17\] vssd1 vssd1 vccd1 vccd1 _03006_
+ sky130_fd_sc_hd__mux2_1
X_07893_ net522 _02235_ _02936_ net520 vssd1 vssd1 vccd1 vccd1 _02937_ sky130_fd_sc_hd__o211a_1
X_06913_ _01522_ cell1.SB0.route_sel\[59\] _01523_ cell1.SB0.route_sel\[60\] vssd1
+ vssd1 vccd1 vccd1 _01981_ sky130_fd_sc_hd__o22a_1
X_09632_ net21 _04647_ vssd1 vssd1 vccd1 vccd1 _04648_ sky130_fd_sc_hd__or2_1
XANTENNA__11294__X net141 vssd1 vssd1 vccd1 vccd1 sky130_fd_sc_hd__diode_2
X_06844_ _01874_ _01912_ vssd1 vssd1 vccd1 vccd1 _01913_ sky130_fd_sc_hd__and2_2
XANTENNA__07897__A2 bus2_0\[10\] vssd1 vssd1 vccd1 vccd1 sky130_fd_sc_hd__diode_2
XTAP_TAPCELL_ROW_108_1930 vssd1 vccd1 sky130_fd_sc_hd__tapvpwrvgnd_1
XFILLER_82_133 vssd1 vssd1 vccd1 vccd1 sky130_fd_sc_hd__fill_1
X_09563_ cell2.SB0.route_sel\[84\] cell2.SB0.route_sel\[85\] vssd1 vssd1 vccd1 vccd1
+ _04581_ sky130_fd_sc_hd__nor2_1
XFILLER_130_27 vssd1 vssd1 vccd1 vccd1 sky130_fd_sc_hd__fill_1
X_06775_ cell1.SB0.route_sel\[50\] cell1.SB0.route_sel\[51\] vssd1 vssd1 vccd1 vccd1
+ _01845_ sky130_fd_sc_hd__nand2_1
X_08514_ net493 net495 vssd1 vssd1 vccd1 vccd1 _03550_ sky130_fd_sc_hd__and2b_2
X_09494_ _04366_ _04414_ vssd1 vssd1 vccd1 vccd1 _04515_ sky130_fd_sc_hd__nor2_1
XANTENNA_clkbuf_leaf_42_clk_A clknet_4_6_0_clk vssd1 vssd1 vccd1 vccd1 sky130_fd_sc_hd__diode_2
XANTENNA__10653__A1 net18 vssd1 vssd1 vccd1 vccd1 sky130_fd_sc_hd__diode_2
X_08445_ net4 net5 net6 net7 net498 net496 vssd1 vssd1 vccd1 vccd1 _03481_ sky130_fd_sc_hd__mux4_1
X_08376_ cell0.CB_1.config_dataB\[14\] _03396_ _03411_ _03412_ vssd1 vssd1 vccd1 vccd1
+ _03414_ sky130_fd_sc_hd__o31a_1
XTAP_TAPCELL_ROW_137_2359 vssd1 vccd1 sky130_fd_sc_hd__tapvpwrvgnd_1
Xwire319 _02402_ vssd1 vssd1 vccd1 vccd1 net319 sky130_fd_sc_hd__clkbuf_2
X_07327_ cell2.SB0.route_sel\[99\] cell2.SB0.route_sel\[98\] _02383_ vssd1 vssd1 vccd1
+ vccd1 _02384_ sky130_fd_sc_hd__a21oi_1
XFILLER_139_69 vccd1 vssd1 vccd1 vssd1 sky130_ef_sc_hd__decap_40_12
XANTENNA_fanout316_X net316 vssd1 vssd1 vccd1 vccd1 sky130_fd_sc_hd__diode_2
XANTENNA_clkbuf_leaf_57_clk_A clknet_4_13_0_clk vssd1 vssd1 vccd1 vccd1 sky130_fd_sc_hd__diode_2
X_07258_ net308 _02314_ _02316_ vssd1 vssd1 vccd1 vccd1 _02317_ sky130_fd_sc_hd__o21ba_1
X_07189_ net34 cell2.CB_0.le_outB _02248_ vssd1 vssd1 vccd1 vccd1 _02250_ sky130_fd_sc_hd__mux2_1
XANTENNA_fanout897_A net898 vssd1 vssd1 vccd1 vccd1 sky130_fd_sc_hd__diode_2
XANTENNA_clkbuf_leaf_100_clk_A clknet_4_10_0_clk vssd1 vssd1 vccd1 vccd1 sky130_fd_sc_hd__diode_2
XFILLER_2_137 vssd1 vssd1 vccd1 vccd1 sky130_fd_sc_hd__fill_2
XANTENNA__10092__Y _05093_ vssd1 vssd1 vccd1 vccd1 sky130_fd_sc_hd__diode_2
Xfanout430 cell2.CB_0.config_dataB\[6\] vssd1 vssd1 vccd1 vccd1 net430 sky130_fd_sc_hd__clkbuf_2
XANTENNA__11525__A_N _06350_ vssd1 vssd1 vccd1 vccd1 sky130_fd_sc_hd__diode_2
Xfanout441 net442 vssd1 vssd1 vccd1 vccd1 net441 sky130_fd_sc_hd__clkbuf_2
XFILLER_93_409 vssd1 vssd1 vccd1 vccd1 sky130_fd_sc_hd__fill_1
Xfanout474 cell1.CB_0.config_dataA\[0\] vssd1 vssd1 vccd1 vccd1 net474 sky130_fd_sc_hd__clkbuf_2
Xfanout463 cell1.CB_0.config_dataA\[16\] vssd1 vssd1 vccd1 vccd1 net463 sky130_fd_sc_hd__clkbuf_2
XANTENNA_clkbuf_leaf_115_clk_A clknet_4_9_0_clk vssd1 vssd1 vccd1 vccd1 sky130_fd_sc_hd__diode_2
Xfanout452 net453 vssd1 vssd1 vccd1 vccd1 net452 sky130_fd_sc_hd__clkbuf_2
XANTENNA_input130_A config_en vssd1 vssd1 vccd1 vccd1 sky130_fd_sc_hd__diode_2
X_13890_ clknet_leaf_40_clk _00862_ net643 vssd1 vssd1 vccd1 vccd1 cell2.LE_1A.config_data\[13\]
+ sky130_fd_sc_hd__dfrtp_1
XFILLER_86_461 vssd1 vssd1 vccd1 vccd1 sky130_fd_sc_hd__fill_1
X_12910_ cell3.CB_1.config_dataB\[24\] net362 net936 vssd1 vssd1 vccd1 vccd1 _01339_
+ sky130_fd_sc_hd__mux2_1
Xfanout485 net486 vssd1 vssd1 vccd1 vccd1 net485 sky130_fd_sc_hd__clkbuf_2
XFILLER_48_88 vssd1 vssd1 vccd1 vccd1 sky130_fd_sc_hd__fill_1
Xfanout496 cell1.CB_1.config_dataA\[1\] vssd1 vssd1 vccd1 vccd1 net496 sky130_fd_sc_hd__clkbuf_2
X_12841_ cell2.SB0.route_sel\[83\] cell2.SB0.route_sel\[82\] net797 vssd1 vssd1 vccd1
+ vccd1 _01270_ sky130_fd_sc_hd__mux2_1
XFILLER_0_29 vccd1 vssd1 vccd1 vssd1 sky130_ef_sc_hd__decap_40_12
XANTENNA__07561__C net353 vssd1 vssd1 vccd1 vccd1 sky130_fd_sc_hd__diode_2
XFILLER_15_712 vssd1 vssd1 vccd1 vccd1 sky130_fd_sc_hd__fill_1
X_12772_ cell2.SB0.route_sel\[14\] cell2.SB0.route_sel\[13\] net829 vssd1 vssd1 vccd1
+ vccd1 _01201_ sky130_fd_sc_hd__mux2_1
XANTENNA__09402__X _04425_ vssd1 vssd1 vccd1 vccd1 sky130_fd_sc_hd__diode_2
X_11723_ cell0.LE_0B.reset_mode cell0.LE_0B.reset_val net804 vssd1 vssd1 vccd1 vccd1
+ _00162_ sky130_fd_sc_hd__mux2_1
XFILLER_9_27 vccd1 vssd1 vccd1 vssd1 sky130_ef_sc_hd__decap_40_12
X_14442_ clknet_leaf_68_clk _01414_ net734 vssd1 vssd1 vccd1 vccd1 cell3.LEI0.config_data\[7\]
+ sky130_fd_sc_hd__dfrtp_1
X_11654_ net510 cell0.CB_1.config_dataA\[24\] net790 vssd1 vssd1 vccd1 vccd1 _00095_
+ sky130_fd_sc_hd__mux2_1
X_10605_ net398 _04714_ _05518_ vssd1 vssd1 vccd1 vccd1 _05563_ sky130_fd_sc_hd__or3_1
X_14373_ clknet_leaf_65_clk net1378 net744 vssd1 vssd1 vccd1 vccd1 cell3.LE_1A.config_data\[4\]
+ sky130_fd_sc_hd__dfrtp_1
X_11585_ net541 net542 net788 vssd1 vssd1 vccd1 vccd1 _00026_ sky130_fd_sc_hd__mux2_1
XANTENNA_output182_A net182 vssd1 vssd1 vccd1 vccd1 sky130_fd_sc_hd__diode_2
X_10536_ net15 net16 net395 vssd1 vssd1 vccd1 vccd1 _05494_ sky130_fd_sc_hd__mux2_1
X_13324_ clknet_leaf_87_clk _00296_ net690 vssd1 vssd1 vccd1 vccd1 cell1.CB_0.config_dataB\[15\]
+ sky130_fd_sc_hd__dfstp_1
XANTENNA_input79_X net79 vssd1 vssd1 vccd1 vccd1 sky130_fd_sc_hd__diode_2
XTAP_TAPCELL_ROW_12_489 vssd1 vccd1 sky130_fd_sc_hd__tapvpwrvgnd_1
XANTENNA__07857__X _02901_ vssd1 vssd1 vccd1 vccd1 sky130_fd_sc_hd__diode_2
XPHY_EDGE_ROW_108_Right_108 vssd1 vssd1 vccd1 vccd1 sky130_fd_sc_hd__decap_3
X_10467_ cell3.SB0.route_sel\[104\] cell3.SB0.route_sel\[105\] cell3.SB0.route_sel\[108\]
+ _01743_ _05451_ vssd1 vssd1 vccd1 vccd1 _05452_ sky130_fd_sc_hd__o221a_1
XTAP_TAPCELL_ROW_94_1720 vssd1 vccd1 sky130_fd_sc_hd__tapvpwrvgnd_1
X_13255_ clknet_leaf_9_clk _00227_ net570 vssd1 vssd1 vccd1 vccd1 cell0.LEI0.config_data\[40\]
+ sky130_fd_sc_hd__dfrtp_1
X_12206_ cell2.CB_1.config_dataA\[19\] cell2.CB_1.config_dataA\[18\] net835 vssd1
+ vssd1 vccd1 vccd1 _00639_ sky130_fd_sc_hd__mux2_1
X_10398_ net424 _05128_ _05396_ vssd1 vssd1 vccd1 vccd1 _05397_ sky130_fd_sc_hd__a21o_1
X_13186_ clknet_leaf_13_clk _00158_ net590 vssd1 vssd1 vccd1 vccd1 cell0.LE_0B.config_data\[15\]
+ sky130_fd_sc_hd__dfrtp_1
X_12137_ net1523 cell1.LEI0.config_data\[18\] net903 vssd1 vssd1 vccd1 vccd1 _00570_
+ sky130_fd_sc_hd__mux2_1
XFILLER_2_693 vssd1 vssd1 vccd1 vccd1 sky130_fd_sc_hd__fill_4
X_12068_ cell1.LE_1A.reset_mode net1535 net903 vssd1 vssd1 vccd1 vccd1 _00504_ sky130_fd_sc_hd__mux2_1
XFILLER_1_181 vccd1 vssd1 vccd1 vssd1 sky130_ef_sc_hd__decap_40_12
X_11019_ _05879_ _05964_ vssd1 vssd1 vccd1 vccd1 _05973_ sky130_fd_sc_hd__nor2_1
XFILLER_77_483 vssd1 vssd1 vccd1 vccd1 sky130_fd_sc_hd__fill_1
XTAP_TAPCELL_ROW_121_2127 vssd1 vccd1 sky130_fd_sc_hd__tapvpwrvgnd_1
XTAP_TAPCELL_ROW_121_2116 vssd1 vccd1 sky130_fd_sc_hd__tapvpwrvgnd_1
XFILLER_80_648 vssd1 vssd1 vccd1 vccd1 sky130_fd_sc_hd__fill_2
X_06560_ cell2.SB0.route_sel\[83\] vssd1 vssd1 vccd1 vccd1 _01630_ sky130_fd_sc_hd__inv_2
X_06491_ cell0.CB_0.config_dataB\[17\] vssd1 vssd1 vccd1 vccd1 _01561_ sky130_fd_sc_hd__inv_2
XTAP_TAPCELL_ROW_103_1860 vssd1 vccd1 sky130_fd_sc_hd__tapvpwrvgnd_1
XFILLER_20_214 vssd1 vssd1 vccd1 vccd1 sky130_fd_sc_hd__fill_2
X_08230_ net537 _02494_ net535 vssd1 vssd1 vccd1 vccd1 _03270_ sky130_fd_sc_hd__o21ai_1
XFILLER_20_236 vssd1 vssd1 vccd1 vccd1 sky130_fd_sc_hd__fill_1
XANTENNA__08056__A2 bus2_0\[14\] vssd1 vssd1 vccd1 vccd1 sky130_fd_sc_hd__diode_2
X_08161_ cell0.CB_1.config_dataA\[6\] net543 vssd1 vssd1 vccd1 vccd1 _03201_ sky130_fd_sc_hd__nor2_1
XANTENNA__07199__B _01933_ vssd1 vssd1 vccd1 vccd1 sky130_fd_sc_hd__diode_2
XTAP_TAPCELL_ROW_31_776 vssd1 vccd1 sky130_fd_sc_hd__tapvpwrvgnd_1
XTAP_TAPCELL_ROW_119_2089 vssd1 vccd1 sky130_fd_sc_hd__tapvpwrvgnd_1
X_07112_ net114 cell2.SB0.route_sel\[77\] cell2.SB0.route_sel\[76\] vssd1 vssd1 vccd1
+ vccd1 _02175_ sky130_fd_sc_hd__and3_1
X_08092_ bus2_0\[4\] _03125_ _03126_ bus2_0\[5\] cell0.CB_0.config_dataB\[18\] vssd1
+ vssd1 vccd1 vccd1 _03134_ sky130_fd_sc_hd__a221o_1
Xclkload51 clknet_leaf_28_clk vssd1 vssd1 vccd1 vccd1 clkload51/X sky130_fd_sc_hd__clkbuf_8
Xclkload62 clknet_leaf_33_clk vssd1 vssd1 vccd1 vccd1 clkload62/Y sky130_fd_sc_hd__inv_16
X_07043_ _01620_ cell2.SB0.route_sel\[66\] cell2.SB0.route_sel\[70\] cell2.SB0.route_sel\[71\]
+ _02107_ vssd1 vssd1 vccd1 vccd1 _02108_ sky130_fd_sc_hd__o221a_1
Xclkload40 clknet_leaf_120_clk vssd1 vssd1 vccd1 vccd1 clkload40/Y sky130_fd_sc_hd__inv_6
XTAP_TAPCELL_ROW_132_2289 vssd1 vccd1 sky130_fd_sc_hd__tapvpwrvgnd_1
Xclkload95 clknet_leaf_88_clk vssd1 vssd1 vccd1 vccd1 clkload95/Y sky130_fd_sc_hd__clkinv_4
Xclkload84 clknet_leaf_116_clk vssd1 vssd1 vccd1 vccd1 clkload84/Y sky130_fd_sc_hd__clkinvlp_4
Xclkload73 clknet_leaf_108_clk vssd1 vssd1 vccd1 vccd1 clkload73/Y sky130_fd_sc_hd__inv_6
XANTENNA__10353__B _05144_ vssd1 vssd1 vccd1 vccd1 sky130_fd_sc_hd__diode_2
XFILLER_0_619 vssd1 vssd1 vccd1 vccd1 sky130_fd_sc_hd__fill_1
XFILLER_125_27 vccd1 vssd1 vccd1 vssd1 sky130_ef_sc_hd__decap_40_12
X_08994_ net482 _03858_ _04023_ net481 vssd1 vssd1 vccd1 vccd1 _04024_ sky130_fd_sc_hd__o211a_1
XPHY_EDGE_ROW_10_Left_153 vssd1 vssd1 vccd1 vccd1 sky130_fd_sc_hd__decap_3
XFILLER_102_569 vssd1 vssd1 vccd1 vccd1 sky130_fd_sc_hd__fill_1
X_07945_ net512 _02897_ vssd1 vssd1 vccd1 vccd1 _02989_ sky130_fd_sc_hd__nand2_1
XANTENNA__08516__A0 net1 vssd1 vssd1 vccd1 vccd1 sky130_fd_sc_hd__diode_2
XANTENNA__11115__A2 net42 vssd1 vssd1 vccd1 vccd1 sky130_fd_sc_hd__diode_2
XANTENNA__09713__C1 _04718_ vssd1 vssd1 vccd1 vccd1 sky130_fd_sc_hd__diode_2
XANTENNA__08758__B _03529_ vssd1 vssd1 vccd1 vccd1 sky130_fd_sc_hd__diode_2
XFILLER_141_15 vccd1 vssd1 vccd1 vssd1 sky130_ef_sc_hd__decap_40_12
XFILLER_110_591 vssd1 vssd1 vccd1 vccd1 sky130_fd_sc_hd__fill_4
X_09615_ cell3.SB0.route_sel\[88\] _01732_ vssd1 vssd1 vccd1 vccd1 _04632_ sky130_fd_sc_hd__nand2_1
X_07876_ net520 net521 vssd1 vssd1 vccd1 vccd1 _02920_ sky130_fd_sc_hd__and2b_1
XFILLER_28_325 vssd1 vssd1 vccd1 vccd1 sky130_fd_sc_hd__fill_1
XANTENNA_fanout645_A net649 vssd1 vssd1 vccd1 vccd1 sky130_fd_sc_hd__diode_2
XTAP_TAPCELL_ROW_39_887 vssd1 vccd1 sky130_fd_sc_hd__tapvpwrvgnd_1
XANTENNA__08531__A3 _03498_ vssd1 vssd1 vccd1 vccd1 sky130_fd_sc_hd__diode_2
XFILLER_18_69 vssd1 vssd1 vccd1 vccd1 sky130_fd_sc_hd__fill_1
X_06827_ cell1.SB0.route_sel\[48\] cell1.SB0.route_sel\[49\] _01883_ _01896_ net858
+ vssd1 vssd1 vccd1 vccd1 _01897_ sky130_fd_sc_hd__a311o_2
X_09546_ _04230_ _04537_ vssd1 vssd1 vccd1 vccd1 _04565_ sky130_fd_sc_hd__or2_1
X_06758_ net347 vssd1 vssd1 vccd1 vccd1 _01828_ sky130_fd_sc_hd__inv_2
XTAP_TAPCELL_ROW_48_1029 vssd1 vccd1 sky130_fd_sc_hd__tapvpwrvgnd_1
XTAP_TAPCELL_ROW_39_898 vssd1 vccd1 sky130_fd_sc_hd__tapvpwrvgnd_1
XANTENNA__07417__A_N _02469_ vssd1 vssd1 vccd1 vccd1 sky130_fd_sc_hd__diode_2
X_09477_ _02008_ _04497_ vssd1 vssd1 vccd1 vccd1 _04498_ sky130_fd_sc_hd__and2_2
XANTENNA__11471__Y net216 vssd1 vssd1 vccd1 vccd1 sky130_fd_sc_hd__diode_2
X_06689_ cell2.LEI0.config_data\[41\] vssd1 vssd1 vccd1 vccd1 _01759_ sky130_fd_sc_hd__inv_2
XTAP_TAPCELL_ROW_61_1229 vssd1 vccd1 sky130_fd_sc_hd__tapvpwrvgnd_1
XTAP_TAPCELL_ROW_61_1218 vssd1 vccd1 sky130_fd_sc_hd__tapvpwrvgnd_1
X_08428_ cell1.SB0.route_sel\[85\] cell1.SB0.route_sel\[84\] _01535_ cell1.SB0.route_sel\[87\]
+ _03463_ vssd1 vssd1 vccd1 vccd1 _03464_ sky130_fd_sc_hd__o221a_1
XANTENNA__06845__A3 _01912_ vssd1 vssd1 vccd1 vccd1 sky130_fd_sc_hd__diode_2
XFILLER_11_236 vssd1 vssd1 vccd1 vccd1 sky130_fd_sc_hd__fill_8
XFILLER_109_113 vssd1 vssd1 vccd1 vccd1 sky130_fd_sc_hd__fill_1
Xclkload1 clknet_4_1_0_clk vssd1 vssd1 vccd1 vccd1 clkload1/Y sky130_fd_sc_hd__inv_6
X_08359_ net503 _01956_ vssd1 vssd1 vccd1 vccd1 _03397_ sky130_fd_sc_hd__nand2_1
XANTENNA__11051__A1 _05871_ vssd1 vssd1 vccd1 vccd1 sky130_fd_sc_hd__diode_2
X_11370_ cell0.SB0.route_sel\[33\] cell0.SB0.route_sel\[32\] vssd1 vssd1 vccd1 vccd1
+ _06247_ sky130_fd_sc_hd__nor2_1
X_10321_ cell2.CB_0.config_dataB\[3\] cell2.CB_0.config_dataB\[2\] vssd1 vssd1 vccd1
+ vccd1 _05320_ sky130_fd_sc_hd__nor2_1
XFILLER_119_3 vccd1 vssd1 vccd1 vssd1 sky130_ef_sc_hd__decap_40_12
XTAP_TAPCELL_ROW_76_1450 vssd1 vccd1 sky130_fd_sc_hd__tapvpwrvgnd_1
X_13040_ clknet_leaf_120_clk net1144 net593 vssd1 vssd1 vccd1 vccd1 cell0.LE_1B.config_data\[12\]
+ sky130_fd_sc_hd__dfrtp_1
X_10252_ _05111_ _05235_ _05251_ _05252_ vssd1 vssd1 vccd1 vccd1 _05253_ sky130_fd_sc_hd__a211o_1
XFILLER_1_3 vccd1 vssd1 vccd1 vssd1 sky130_ef_sc_hd__decap_40_12
X_10183_ net319 _05113_ _05168_ _01766_ vssd1 vssd1 vccd1 vccd1 _05184_ sky130_fd_sc_hd__a31o_1
XFILLER_105_374 vssd1 vssd1 vccd1 vccd1 sky130_fd_sc_hd__fill_1
XANTENNA_input39_A CBnorth_in[15] vssd1 vssd1 vccd1 vccd1 sky130_fd_sc_hd__diode_2
XANTENNA__07853__A net268 vssd1 vssd1 vccd1 vccd1 sky130_fd_sc_hd__diode_2
XANTENNA_input133_X net133 vssd1 vssd1 vccd1 vccd1 sky130_fd_sc_hd__diode_2
Xfanout282 net284 vssd1 vssd1 vccd1 vccd1 net282 sky130_fd_sc_hd__buf_2
X_13942_ clknet_1_0__leaf_cell2.LE_0A.sel_clk _00914_ net752 vssd1 vssd1 vccd1 vccd1
+ cell2.LE_0A.dff0_out sky130_fd_sc_hd__dfrtp_1
XFILLER_93_206 vccd1 vssd1 vccd1 vssd1 sky130_ef_sc_hd__decap_40_12
Xfanout293 net296 vssd1 vssd1 vccd1 vccd1 net293 sky130_fd_sc_hd__clkbuf_2
X_13873_ clknet_leaf_15_clk _00845_ net626 vssd1 vssd1 vccd1 vccd1 cell2.CB_1.config_dataB\[22\]
+ sky130_fd_sc_hd__dfstp_1
XFILLER_74_475 vssd1 vssd1 vccd1 vccd1 sky130_fd_sc_hd__fill_1
XANTENNA__07730__A1 bus3_1\[3\] vssd1 vssd1 vccd1 vccd1 sky130_fd_sc_hd__diode_2
X_12824_ cell2.SB0.route_sel\[66\] cell2.SB0.route_sel\[65\] net815 vssd1 vssd1 vccd1
+ vccd1 _01253_ sky130_fd_sc_hd__mux2_1
XFILLER_27_380 vssd1 vssd1 vccd1 vccd1 sky130_fd_sc_hd__fill_1
X_12755_ cell3.CB_0.config_dataA\[22\] cell3.CB_0.config_dataA\[21\] net930 vssd1
+ vssd1 vccd1 vccd1 _01184_ sky130_fd_sc_hd__mux2_1
XANTENNA__11814__A0 net1514 vssd1 vssd1 vccd1 vccd1 sky130_fd_sc_hd__diode_2
XTAP_TAPCELL_ROW_17_559 vssd1 vccd1 sky130_fd_sc_hd__tapvpwrvgnd_1
X_11706_ net1169 cell0.LE_0B.config_data\[1\] net804 vssd1 vssd1 vccd1 vccd1 _00145_
+ sky130_fd_sc_hd__mux2_1
X_12686_ cell3.CB_1.config_dataA\[3\] cell3.CB_1.config_dataA\[2\] net937 vssd1 vssd1
+ vccd1 vccd1 _01115_ sky130_fd_sc_hd__mux2_1
X_14425_ clknet_leaf_55_clk net1131 net718 vssd1 vssd1 vccd1 vccd1 cell3.LE_0A.config_data\[12\]
+ sky130_fd_sc_hd__dfrtp_1
X_11637_ cell0.CB_0.config_dataA\[8\] cell0.CB_0.config_dataA\[7\] net771 vssd1 vssd1
+ vccd1 vccd1 _00078_ sky130_fd_sc_hd__mux2_1
X_14356_ clknet_leaf_71_clk _01328_ net730 vssd1 vssd1 vccd1 vccd1 cell3.CB_1.config_dataB\[13\]
+ sky130_fd_sc_hd__dfstp_1
X_11568_ net1265 net1256 net802 vssd1 vssd1 vccd1 vccd1 _00009_ sky130_fd_sc_hd__mux2_1
XFILLER_7_752 vssd1 vssd1 vccd1 vccd1 sky130_fd_sc_hd__fill_2
XFILLER_7_741 vssd1 vssd1 vccd1 vccd1 sky130_fd_sc_hd__fill_4
XANTENNA__08589__A3 net26 vssd1 vssd1 vccd1 vccd1 sky130_fd_sc_hd__diode_2
XANTENNA__08623__S _03546_ vssd1 vssd1 vccd1 vccd1 sky130_fd_sc_hd__diode_2
XANTENNA__07587__X _02637_ vssd1 vssd1 vccd1 vccd1 sky130_fd_sc_hd__diode_2
X_10519_ cell3.SB0.route_sel\[48\] _01709_ cell3.SB0.route_sel\[52\] cell3.SB0.route_sel\[53\]
+ _05476_ vssd1 vssd1 vccd1 vccd1 _05477_ sky130_fd_sc_hd__o221a_1
XFILLER_6_240 vssd1 vssd1 vccd1 vccd1 sky130_fd_sc_hd__fill_2
X_13307_ clknet_leaf_102_clk _00279_ net676 vssd1 vssd1 vccd1 vccd1 cell1.CB_1.config_dataA\[23\]
+ sky130_fd_sc_hd__dfstp_1
X_11499_ cell2.SB0.route_sel\[32\] cell2.SB0.route_sel\[33\] vssd1 vssd1 vccd1 vccd1
+ _06333_ sky130_fd_sc_hd__nor2_1
X_14287_ clknet_leaf_20_clk _01259_ net611 vssd1 vssd1 vccd1 vccd1 cell2.SB0.route_sel\[72\]
+ sky130_fd_sc_hd__dfstp_1
X_13238_ clknet_leaf_122_clk _00210_ net586 vssd1 vssd1 vccd1 vccd1 cell0.LEI0.config_data\[23\]
+ sky130_fd_sc_hd__dfrtp_1
XANTENNA__09962__B _04498_ vssd1 vssd1 vccd1 vccd1 sky130_fd_sc_hd__diode_2
X_13169_ clknet_1_1__leaf_cell0.LE_1B.sel_clk _00141_ net751 vssd1 vssd1 vccd1 vccd1
+ cell0.LE_1B.dff1_out sky130_fd_sc_hd__dfstp_1
X_07730_ bus3_1\[3\] _02775_ _02776_ vssd1 vssd1 vccd1 vccd1 _02777_ sky130_fd_sc_hd__a21o_1
XFILLER_84_239 vssd1 vssd1 vccd1 vccd1 sky130_fd_sc_hd__fill_1
X_07661_ _02704_ _02705_ _02708_ vssd1 vssd1 vccd1 vccd1 _02709_ sky130_fd_sc_hd__a21bo_1
XFILLER_26_829 vssd1 vssd1 vccd1 vccd1 sky130_fd_sc_hd__fill_1
XFILLER_80_434 vssd1 vssd1 vccd1 vccd1 sky130_fd_sc_hd__fill_1
X_09400_ cell3.SB0.route_sel\[44\] cell3.SB0.route_sel\[45\] _02863_ _04422_ _02860_
+ vssd1 vssd1 vccd1 vccd1 _04423_ sky130_fd_sc_hd__a221o_1
X_06612_ cell1.CB_0.config_dataA\[14\] vssd1 vssd1 vccd1 vccd1 _01682_ sky130_fd_sc_hd__inv_2
X_07592_ net320 net1 _02639_ vssd1 vssd1 vccd1 vccd1 _02642_ sky130_fd_sc_hd__mux2_1
XFILLER_37_199 vssd1 vssd1 vccd1 vccd1 sky130_fd_sc_hd__fill_1
X_06543_ cell2.SB0.route_sel\[55\] vssd1 vssd1 vccd1 vccd1 _01613_ sky130_fd_sc_hd__inv_2
X_09331_ cell3.CB_1.config_dataA\[24\] cell3.CB_1.config_dataA\[21\] cell3.CB_1.config_dataA\[20\]
+ vssd1 vssd1 vccd1 vccd1 _04356_ sky130_fd_sc_hd__nand3b_1
XFILLER_80_456 vssd1 vssd1 vccd1 vccd1 sky130_fd_sc_hd__fill_1
XFILLER_18_391 vssd1 vssd1 vccd1 vccd1 sky130_fd_sc_hd__fill_2
XTAP_TAPCELL_ROW_36_846 vssd1 vccd1 sky130_fd_sc_hd__tapvpwrvgnd_1
XANTENNA__11224__S _06076_ vssd1 vssd1 vccd1 vccd1 sky130_fd_sc_hd__diode_2
XANTENNA_clkbuf_4_5_0_clk_A clknet_0_clk vssd1 vssd1 vccd1 vccd1 sky130_fd_sc_hd__diode_2
XTAP_TAPCELL_ROW_101_1819 vssd1 vccd1 sky130_fd_sc_hd__tapvpwrvgnd_1
X_09262_ cell2.SB0.route_sel\[23\] cell2.SB0.route_sel\[22\] _01589_ _04286_ vssd1
+ vssd1 vccd1 vccd1 _04288_ sky130_fd_sc_hd__a211o_1
XFILLER_21_534 vssd1 vssd1 vccd1 vccd1 sky130_fd_sc_hd__fill_1
X_06474_ cell1.SB0.route_sel\[107\] vssd1 vssd1 vccd1 vccd1 _01544_ sky130_fd_sc_hd__inv_2
X_09193_ net278 net40 _04217_ vssd1 vssd1 vccd1 vccd1 _04221_ sky130_fd_sc_hd__mux2_1
Xclkbuf_0_cell1.LE_1B.sel_clk cell1.LE_1B.sel_clk vssd1 vssd1 vccd1 vccd1 clknet_0_cell1.LE_1B.sel_clk
+ sky130_fd_sc_hd__clkbuf_16
X_08213_ net539 _02761_ vssd1 vssd1 vccd1 vccd1 _03253_ sky130_fd_sc_hd__nand2_1
XTAP_TAPCELL_ROW_134_2318 vssd1 vccd1 sky130_fd_sc_hd__tapvpwrvgnd_1
X_08144_ bus1_0\[6\] bus1_0\[7\] net547 vssd1 vssd1 vccd1 vccd1 _03184_ sky130_fd_sc_hd__mux2_1
Xclkload140 clknet_1_1__leaf_cell2.LE_1B.sel_clk vssd1 vssd1 vccd1 vccd1 clkload140/X
+ sky130_fd_sc_hd__clkbuf_4
X_08075_ cell0.CB_0.config_dataB\[14\] _03092_ vssd1 vssd1 vccd1 vccd1 _03117_ sky130_fd_sc_hd__nand2_1
X_07026_ net301 _02085_ _02086_ _02089_ vssd1 vssd1 vccd1 vccd1 _02091_ sky130_fd_sc_hd__o211a_1
XTAP_TAPCELL_ROW_58_1180 vssd1 vccd1 sky130_fd_sc_hd__tapvpwrvgnd_1
XFILLER_0_427 vssd1 vssd1 vccd1 vccd1 sky130_fd_sc_hd__fill_2
Xhold13 cell1.LE_0A.dff0_out vssd1 vssd1 vccd1 vccd1 net972 sky130_fd_sc_hd__dlygate4sd3_1
XFILLER_0_449 vssd1 vssd1 vccd1 vccd1 sky130_fd_sc_hd__fill_2
XANTENNA__08752__A3 net26 vssd1 vssd1 vccd1 vccd1 sky130_fd_sc_hd__diode_2
Xhold24 cell1.LE_0B.dff0_out vssd1 vssd1 vccd1 vccd1 net983 sky130_fd_sc_hd__dlygate4sd3_1
XFILLER_75_206 vssd1 vssd1 vccd1 vccd1 sky130_fd_sc_hd__fill_8
XTAP_TAPCELL_ROW_71_1380 vssd1 vccd1 sky130_fd_sc_hd__tapvpwrvgnd_1
Xhold35 _00170_ vssd1 vssd1 vccd1 vccd1 net994 sky130_fd_sc_hd__dlygate4sd3_1
X_08977_ _04007_ _04008_ _03902_ vssd1 vssd1 vccd1 vccd1 _04009_ sky130_fd_sc_hd__mux2_1
XANTENNA__07960__A1 bus2_0\[9\] vssd1 vssd1 vccd1 vccd1 sky130_fd_sc_hd__diode_2
Xhold46 cell1.LE_1A.config_data\[12\] vssd1 vssd1 vccd1 vccd1 net1005 sky130_fd_sc_hd__dlygate4sd3_1
XANTENNA_fanout762_A net768 vssd1 vssd1 vccd1 vccd1 sky130_fd_sc_hd__diode_2
XFILLER_29_57 vssd1 vssd1 vccd1 vccd1 sky130_fd_sc_hd__fill_1
XANTENNA__12297__A0 cell1.SB0.route_sel\[35\] vssd1 vssd1 vccd1 vccd1 sky130_fd_sc_hd__diode_2
Xhold57 _01365_ vssd1 vssd1 vccd1 vccd1 net1016 sky130_fd_sc_hd__dlygate4sd3_1
XFILLER_75_228 vssd1 vssd1 vccd1 vccd1 sky130_fd_sc_hd__fill_1
X_07928_ bus2_0\[8\] bus2_0\[9\] bus2_0\[10\] bus2_0\[11\] net515 net514 vssd1 vssd1
+ vccd1 vccd1 _02972_ sky130_fd_sc_hd__mux4_1
Xhold79 cell1.LE_0A.config_data\[2\] vssd1 vssd1 vccd1 vccd1 net1038 sky130_fd_sc_hd__dlygate4sd3_1
XFILLER_28_111 vssd1 vssd1 vccd1 vccd1 sky130_fd_sc_hd__fill_1
Xhold68 cell1.LE_1B.config_data\[3\] vssd1 vssd1 vccd1 vccd1 net1027 sky130_fd_sc_hd__dlygate4sd3_1
XANTENNA_fanout550_X net550 vssd1 vssd1 vccd1 vccd1 sky130_fd_sc_hd__diode_2
XFILLER_56_475 vssd1 vssd1 vccd1 vccd1 sky130_fd_sc_hd__fill_1
X_07859_ cell0.SB0.route_sel\[14\] cell0.SB0.route_sel\[15\] vssd1 vssd1 vccd1 vccd1
+ _02903_ sky130_fd_sc_hd__nand2b_1
XFILLER_17_818 vssd1 vssd1 vccd1 vccd1 sky130_fd_sc_hd__fill_1
X_10870_ cell3.LEI0.config_data\[46\] _05825_ vssd1 vssd1 vccd1 vccd1 _05826_ sky130_fd_sc_hd__nor2_1
X_09529_ cell3.SB0.route_sel\[64\] cell3.SB0.route_sel\[65\] _04548_ vssd1 vssd1 vccd1
+ vccd1 _04549_ sky130_fd_sc_hd__a21oi_1
XFILLER_71_467 vssd1 vssd1 vccd1 vccd1 sky130_fd_sc_hd__fill_8
XFILLER_45_67 vssd1 vssd1 vccd1 vccd1 sky130_fd_sc_hd__fill_1
XTAP_TAPCELL_ROW_14_518 vssd1 vccd1 sky130_fd_sc_hd__tapvpwrvgnd_1
X_12540_ cell3.SB0.route_sel\[5\] cell3.SB0.route_sel\[4\] net919 vssd1 vssd1 vccd1
+ vccd1 _00969_ sky130_fd_sc_hd__mux2_1
XFILLER_40_843 vssd1 vssd1 vccd1 vccd1 sky130_fd_sc_hd__fill_1
X_12471_ net1124 cell2.LE_0A.config_data\[7\] net814 vssd1 vssd1 vccd1 vccd1 _00901_
+ sky130_fd_sc_hd__mux2_1
XFILLER_12_556 vssd1 vssd1 vccd1 vccd1 sky130_fd_sc_hd__fill_1
XFILLER_12_589 vssd1 vssd1 vccd1 vccd1 sky130_fd_sc_hd__fill_1
XANTENNA__11024__A1 _05901_ vssd1 vssd1 vccd1 vccd1 sky130_fd_sc_hd__diode_2
X_14210_ clknet_leaf_52_clk _01182_ net720 vssd1 vssd1 vccd1 vccd1 cell3.CB_0.config_dataA\[20\]
+ sky130_fd_sc_hd__dfstp_1
X_11422_ cell0.SB0.route_sel\[110\] cell0.SB0.route_sel\[111\] _01481_ cell0.SB0.route_sel\[106\]
+ _06281_ vssd1 vssd1 vccd1 vccd1 _06282_ sky130_fd_sc_hd__o221a_1
XANTENNA__06752__A net313 vssd1 vssd1 vccd1 vccd1 sky130_fd_sc_hd__diode_2
X_14141_ clknet_leaf_77_clk _01113_ net726 vssd1 vssd1 vccd1 vccd1 cell3.CB_1.config_dataA\[1\]
+ sky130_fd_sc_hd__dfstp_1
XANTENNA__07779__A1 net339 vssd1 vssd1 vccd1 vccd1 sky130_fd_sc_hd__diode_2
XANTENNA__07200__X _02260_ vssd1 vssd1 vccd1 vccd1 sky130_fd_sc_hd__diode_2
X_11353_ _04265_ _04654_ _05861_ vssd1 vssd1 vccd1 vccd1 _06242_ sky130_fd_sc_hd__o21ai_1
X_10304_ cell2.CB_0.config_dataB\[7\] _05300_ _05302_ vssd1 vssd1 vccd1 vccd1 _05303_
+ sky130_fd_sc_hd__or3_1
X_11284_ net310 _02599_ _02600_ _06210_ vssd1 vssd1 vccd1 vccd1 net172 sky130_fd_sc_hd__a22o_2
X_14072_ clknet_leaf_82_clk _01044_ net669 vssd1 vssd1 vccd1 vccd1 cell3.SB0.route_sel\[80\]
+ sky130_fd_sc_hd__dfstp_1
XFILLER_4_755 vssd1 vssd1 vccd1 vccd1 sky130_fd_sc_hd__fill_1
XFILLER_3_221 vssd1 vssd1 vccd1 vccd1 sky130_fd_sc_hd__fill_2
X_13023_ net1110 net1189 net948 vssd1 vssd1 vccd1 vccd1 _01451_ sky130_fd_sc_hd__mux2_1
X_10235_ net412 cell2.CB_0.config_dataA\[16\] vssd1 vssd1 vccd1 vccd1 _05236_ sky130_fd_sc_hd__nor2_1
XANTENNA__10561__X _05519_ vssd1 vssd1 vccd1 vccd1 sky130_fd_sc_hd__diode_2
XFILLER_10_81 vssd1 vssd1 vccd1 vccd1 sky130_fd_sc_hd__fill_2
XANTENNA__07583__A _02630_ vssd1 vssd1 vccd1 vccd1 sky130_fd_sc_hd__diode_2
XFILLER_120_141 vssd1 vssd1 vccd1 vccd1 sky130_fd_sc_hd__fill_1
X_10166_ net420 net421 vssd1 vssd1 vccd1 vccd1 _05167_ sky130_fd_sc_hd__and2b_1
XFILLER_86_63 vssd1 vssd1 vccd1 vccd1 sky130_fd_sc_hd__fill_1
XFILLER_86_41 vssd1 vssd1 vccd1 vccd1 sky130_fd_sc_hd__fill_1
XFILLER_67_729 vssd1 vssd1 vccd1 vccd1 sky130_fd_sc_hd__fill_1
X_10097_ net417 net418 vssd1 vssd1 vccd1 vccd1 _05098_ sky130_fd_sc_hd__nor2_1
XTAP_TAPCELL_ROW_89_1641 vssd1 vccd1 sky130_fd_sc_hd__tapvpwrvgnd_1
X_13925_ clknet_leaf_25_clk net1056 net608 vssd1 vssd1 vccd1 vccd1 cell2.LE_0A.config_data\[4\]
+ sky130_fd_sc_hd__dfrtp_1
XFILLER_142_80 vssd1 vssd1 vccd1 vccd1 sky130_fd_sc_hd__fill_2
XANTENNA__10302__A3 net35 vssd1 vssd1 vccd1 vccd1 sky130_fd_sc_hd__diode_2
X_13856_ clknet_leaf_40_clk _00828_ net643 vssd1 vssd1 vccd1 vccd1 cell2.CB_1.config_dataB\[5\]
+ sky130_fd_sc_hd__dfstp_1
XANTENNA_clkload4_A clknet_4_4_0_clk vssd1 vssd1 vccd1 vccd1 sky130_fd_sc_hd__diode_2
X_12807_ cell2.SB0.route_sel\[49\] cell2.SB0.route_sel\[48\] net812 vssd1 vssd1 vccd1
+ vccd1 _01236_ sky130_fd_sc_hd__mux2_1
XFILLER_62_434 vssd1 vssd1 vccd1 vccd1 sky130_fd_sc_hd__fill_1
XANTENNA__08618__S _03546_ vssd1 vssd1 vccd1 vccd1 sky130_fd_sc_hd__diode_2
XANTENNA__11552__B _02716_ vssd1 vssd1 vccd1 vccd1 sky130_fd_sc_hd__diode_2
X_10999_ net376 _05951_ _05952_ vssd1 vssd1 vccd1 vccd1 _05953_ sky130_fd_sc_hd__a21oi_1
X_13787_ clknet_leaf_105_clk _00759_ net660 vssd1 vssd1 vccd1 vccd1 cell1.SB0.route_sel\[64\]
+ sky130_fd_sc_hd__dfstp_1
XTAP_TAPCELL_ROW_33_805 vssd1 vccd1 sky130_fd_sc_hd__tapvpwrvgnd_1
X_12738_ net377 cell3.CB_0.config_dataA\[4\] net925 vssd1 vssd1 vccd1 vccd1 _01167_
+ sky130_fd_sc_hd__mux2_1
XANTENNA__09022__B _03881_ vssd1 vssd1 vccd1 vccd1 sky130_fd_sc_hd__diode_2
X_12669_ net1258 net1202 net954 vssd1 vssd1 vccd1 vccd1 _01098_ sky130_fd_sc_hd__mux2_1
X_14408_ clknet_leaf_61_clk _01380_ net739 vssd1 vssd1 vccd1 vccd1 cell3.LE_0B.edge_mode
+ sky130_fd_sc_hd__dfstp_1
XANTENNA__11015__A1 net54 vssd1 vssd1 vccd1 vccd1 sky130_fd_sc_hd__diode_2
XANTENNA__09759__A2 _04696_ vssd1 vssd1 vccd1 vccd1 sky130_fd_sc_hd__diode_2
XTAP_TAPCELL_ROW_116_2048 vssd1 vccd1 sky130_fd_sc_hd__tapvpwrvgnd_1
XANTENNA__10774__A0 net17 vssd1 vssd1 vccd1 vccd1 sky130_fd_sc_hd__diode_2
X_14339_ clknet_leaf_17_clk _01311_ net627 vssd1 vssd1 vccd1 vccd1 cell2.SB0.route_sel\[124\]
+ sky130_fd_sc_hd__dfstp_1
XANTENNA__13191__SET_B net751 vssd1 vssd1 vccd1 vccd1 sky130_fd_sc_hd__diode_2
Xhold527 cell0.LE_1B.dff1_out vssd1 vssd1 vccd1 vccd1 net1486 sky130_fd_sc_hd__dlygate4sd3_1
Xhold505 cell0.LEI0.config_data\[32\] vssd1 vssd1 vccd1 vccd1 net1464 sky130_fd_sc_hd__dlygate4sd3_1
Xhold516 cell0.LEI0.config_data\[45\] vssd1 vssd1 vccd1 vccd1 net1475 sky130_fd_sc_hd__dlygate4sd3_1
Xmax_cap268 _02758_ vssd1 vssd1 vccd1 vccd1 net268 sky130_fd_sc_hd__clkbuf_2
Xhold549 _00242_ vssd1 vssd1 vccd1 vccd1 net1508 sky130_fd_sc_hd__dlygate4sd3_1
Xhold538 cell0.LEI0.config_data\[10\] vssd1 vssd1 vccd1 vccd1 net1497 sky130_fd_sc_hd__dlygate4sd3_1
X_09880_ _04671_ _04875_ _04884_ _04885_ vssd1 vssd1 vccd1 vccd1 _04886_ sky130_fd_sc_hd__a211o_1
X_08900_ _03921_ _03927_ _03931_ _03917_ vssd1 vssd1 vccd1 vccd1 _03932_ sky130_fd_sc_hd__a31o_1
XANTENNA__09392__A0 net45 vssd1 vssd1 vccd1 vccd1 sky130_fd_sc_hd__diode_2
X_08831_ net471 _03862_ vssd1 vssd1 vccd1 vccd1 _03863_ sky130_fd_sc_hd__nand2_1
XANTENNA__08195__A1 bus1_0\[13\] vssd1 vssd1 vccd1 vccd1 sky130_fd_sc_hd__diode_2
XTAP_TAPCELL_ROW_111_1970 vssd1 vccd1 sky130_fd_sc_hd__tapvpwrvgnd_1
XANTENNA__09931__A2 _04498_ vssd1 vssd1 vccd1 vccd1 sky130_fd_sc_hd__diode_2
XFILLER_85_526 vssd1 vssd1 vccd1 vccd1 sky130_fd_sc_hd__fill_4
X_08762_ _01659_ _03777_ _03782_ _01661_ vssd1 vssd1 vccd1 vccd1 _03796_ sky130_fd_sc_hd__o31ai_1
XFILLER_38_453 vssd1 vssd1 vccd1 vccd1 sky130_fd_sc_hd__fill_1
X_07713_ _01598_ cell0.SB0.route_sel\[30\] cell0.SB0.route_sel\[25\] _01818_ _02759_
+ vssd1 vssd1 vccd1 vccd1 _02760_ sky130_fd_sc_hd__a221o_1
XANTENNA__08498__A2 _03533_ vssd1 vssd1 vccd1 vccd1 sky130_fd_sc_hd__diode_2
X_08693_ net461 _03509_ vssd1 vssd1 vccd1 vccd1 _03727_ sky130_fd_sc_hd__nand2_1
XFILLER_81_710 vccd1 vssd1 vccd1 vssd1 sky130_ef_sc_hd__decap_40_12
X_07644_ _02153_ _02650_ vssd1 vssd1 vccd1 vccd1 _02693_ sky130_fd_sc_hd__nor2_1
XFILLER_38_475 vssd1 vssd1 vccd1 vccd1 sky130_fd_sc_hd__fill_1
X_07575_ _02031_ _02624_ bus2_0\[0\] vssd1 vssd1 vccd1 vccd1 _02625_ sky130_fd_sc_hd__o21a_1
XFILLER_15_15 vccd1 vssd1 vccd1 vssd1 sky130_ef_sc_hd__decap_40_12
X_09314_ _02000_ _04187_ vssd1 vssd1 vccd1 vccd1 _04339_ sky130_fd_sc_hd__nand2_1
XANTENNA__09998__A2 bus3_2\[10\] vssd1 vssd1 vccd1 vccd1 sky130_fd_sc_hd__diode_2
X_06526_ cell2.SB0.route_sel\[29\] vssd1 vssd1 vccd1 vccd1 _01596_ sky130_fd_sc_hd__inv_2
XANTENNA__09867__B _04608_ vssd1 vssd1 vccd1 vccd1 sky130_fd_sc_hd__diode_2
X_09245_ cell3.SB0.route_sel\[8\] cell3.SB0.route_sel\[9\] _04271_ vssd1 vssd1 vccd1
+ vccd1 _04272_ sky130_fd_sc_hd__a21oi_1
X_06457_ cell1.SB0.route_sel\[70\] vssd1 vssd1 vccd1 vccd1 _01527_ sky130_fd_sc_hd__inv_2
X_09176_ cell3.SB0.route_sel\[3\] cell3.SB0.route_sel\[2\] vssd1 vssd1 vccd1 vccd1
+ _04204_ sky130_fd_sc_hd__nand2_1
XANTENNA__08263__S _03263_ vssd1 vssd1 vccd1 vccd1 sky130_fd_sc_hd__diode_2
XANTENNA__08958__A0 bus3_1\[12\] vssd1 vssd1 vccd1 vccd1 sky130_fd_sc_hd__diode_2
X_06388_ cell0.SB0.route_sel\[54\] vssd1 vssd1 vccd1 vccd1 _01458_ sky130_fd_sc_hd__inv_2
XFILLER_107_447 vssd1 vssd1 vccd1 vccd1 sky130_fd_sc_hd__fill_1
X_08127_ net544 net547 vssd1 vssd1 vccd1 vccd1 _03167_ sky130_fd_sc_hd__and2b_1
XFILLER_135_767 vccd1 vssd1 vccd1 vssd1 sky130_ef_sc_hd__decap_40_12
X_08058_ _03098_ _03099_ _01559_ vssd1 vssd1 vccd1 vccd1 _03100_ sky130_fd_sc_hd__mux2_1
X_07009_ _02037_ _02073_ vssd1 vssd1 vccd1 vccd1 _02074_ sky130_fd_sc_hd__nor2_4
XANTENNA__11477__X net218 vssd1 vssd1 vccd1 vccd1 sky130_fd_sc_hd__diode_2
X_10020_ _05000_ _05008_ _05023_ cell2.CB_1.config_dataB\[14\] vssd1 vssd1 vccd1 vccd1
+ _05024_ sky130_fd_sc_hd__a211o_1
XANTENNA_hold388_A cell1.LE_1B.config_data\[0\] vssd1 vssd1 vccd1 vccd1 sky130_fd_sc_hd__diode_2
XFILLER_76_526 vssd1 vssd1 vccd1 vccd1 sky130_fd_sc_hd__fill_4
Xinput114 SBwest_in[25] vssd1 vssd1 vccd1 vccd1 net114 sky130_fd_sc_hd__buf_1
Xinput103 SBwest_in[15] vssd1 vssd1 vccd1 vccd1 net103 sky130_fd_sc_hd__clkbuf_1
XFILLER_0_268 vssd1 vssd1 vccd1 vccd1 sky130_fd_sc_hd__fill_4
Xinput125 SBwest_in[6] vssd1 vssd1 vccd1 vccd1 net125 sky130_fd_sc_hd__buf_1
XFILLER_130_494 vssd1 vssd1 vccd1 vccd1 sky130_fd_sc_hd__fill_4
XANTENNA_hold555_A cell1.LE_1B.config_data\[15\] vssd1 vssd1 vccd1 vccd1 sky130_fd_sc_hd__diode_2
XANTENNA_fanout932_X net932 vssd1 vssd1 vccd1 vccd1 sky130_fd_sc_hd__diode_2
X_11971_ cell0.SB0.route_sel\[77\] cell0.SB0.route_sel\[76\] net784 vssd1 vssd1 vccd1
+ vccd1 _00408_ sky130_fd_sc_hd__mux2_1
XANTENNA__10296__A2 net38 vssd1 vssd1 vccd1 vccd1 sky130_fd_sc_hd__diode_2
X_10922_ _01806_ _05871_ cell3.CB_0.config_dataA\[1\] vssd1 vssd1 vccd1 vccd1 _05876_
+ sky130_fd_sc_hd__o21ai_1
X_13710_ clknet_leaf_26_clk _00682_ net617 vssd1 vssd1 vccd1 vccd1 cell2.CB_0.config_dataA\[12\]
+ sky130_fd_sc_hd__dfstp_2
XANTENNA__07850__B _02893_ vssd1 vssd1 vccd1 vccd1 sky130_fd_sc_hd__diode_2
X_13641_ clknet_leaf_38_clk net1112 net648 vssd1 vssd1 vccd1 vccd1 cell2.LE_1B.config_data\[13\]
+ sky130_fd_sc_hd__dfrtp_1
XFILLER_112_94 vssd1 vssd1 vccd1 vccd1 sky130_fd_sc_hd__fill_1
X_10853_ cell3.CB_1.config_dataB\[17\] _05802_ _05808_ vssd1 vssd1 vccd1 vccd1 _05809_
+ sky130_fd_sc_hd__a21bo_1
XTAP_TAPCELL_ROW_84_1571 vssd1 vccd1 sky130_fd_sc_hd__tapvpwrvgnd_1
X_10784_ _05489_ _05725_ _05727_ _05483_ cell3.CB_1.config_dataB\[7\] vssd1 vssd1
+ vccd1 vccd1 _05740_ sky130_fd_sc_hd__o221a_1
X_13572_ clknet_leaf_83_clk net1004 net671 vssd1 vssd1 vccd1 vccd1 cell1.LE_0A.config_data\[15\]
+ sky130_fd_sc_hd__dfrtp_1
X_12523_ net1474 net1554 net839 vssd1 vssd1 vccd1 vccd1 _00952_ sky130_fd_sc_hd__mux2_1
XANTENNA__11799__S net905 vssd1 vssd1 vccd1 vccd1 sky130_fd_sc_hd__diode_2
XANTENNA__12484__A net755 vssd1 vssd1 vccd1 vccd1 sky130_fd_sc_hd__diode_2
XFILLER_9_847 vssd1 vssd1 vccd1 vccd1 sky130_fd_sc_hd__fill_1
X_12454_ net1245 cell2.LE_0B.config_data\[13\] net842 vssd1 vssd1 vccd1 vccd1 _00885_
+ sky130_fd_sc_hd__mux2_1
X_12385_ cell1.SB0.route_sel\[123\] cell1.SB0.route_sel\[122\] net872 vssd1 vssd1
+ vccd1 vccd1 _00818_ sky130_fd_sc_hd__mux2_1
X_11405_ _06270_ net341 vssd1 vssd1 vccd1 vccd1 net199 sky130_fd_sc_hd__and2b_1
XANTENNA_input61_X net61 vssd1 vssd1 vccd1 vccd1 sky130_fd_sc_hd__diode_2
X_14124_ clknet_leaf_64_clk net1314 net748 vssd1 vssd1 vccd1 vccd1 cell3.LE_1B.config_data\[4\]
+ sky130_fd_sc_hd__dfrtp_1
X_11336_ _06233_ net281 _04415_ vssd1 vssd1 vccd1 vccd1 net178 sky130_fd_sc_hd__mux2_1
XFILLER_99_607 vssd1 vssd1 vccd1 vccd1 sky130_fd_sc_hd__fill_8
XFILLER_4_530 vssd1 vssd1 vccd1 vccd1 sky130_fd_sc_hd__fill_2
X_14055_ clknet_leaf_45_clk _01027_ net629 vssd1 vssd1 vccd1 vccd1 cell3.SB0.route_sel\[63\]
+ sky130_fd_sc_hd__dfstp_1
XFILLER_4_585 vssd1 vssd1 vccd1 vccd1 sky130_fd_sc_hd__fill_2
XANTENNA_output262_A net262 vssd1 vssd1 vccd1 vccd1 sky130_fd_sc_hd__diode_2
X_13006_ cell3.LEI0.config_data\[27\] net1443 net951 vssd1 vssd1 vccd1 vccd1 _01434_
+ sky130_fd_sc_hd__mux2_1
X_11267_ _06201_ net309 _02004_ vssd1 vssd1 vccd1 vccd1 net195 sky130_fd_sc_hd__mux2_2
XFILLER_97_73 vssd1 vssd1 vccd1 vccd1 sky130_fd_sc_hd__fill_1
X_11198_ cell3.CB_0.config_dataB\[18\] cell3.CB_0.config_dataB\[17\] _06144_ _06149_
+ vssd1 vssd1 vccd1 vccd1 _06150_ sky130_fd_sc_hd__o22a_1
X_10218_ _05216_ _05218_ vssd1 vssd1 vccd1 vccd1 _05219_ sky130_fd_sc_hd__nand2_1
XFILLER_97_95 vssd1 vssd1 vccd1 vccd1 sky130_fd_sc_hd__fill_1
XFILLER_94_312 vssd1 vssd1 vccd1 vccd1 sky130_fd_sc_hd__fill_1
X_10149_ cell2.SB0.route_sel\[11\] cell2.SB0.route_sel\[10\] vssd1 vssd1 vccd1 vccd1
+ _05150_ sky130_fd_sc_hd__or2_1
XFILLER_67_559 vssd1 vssd1 vccd1 vccd1 sky130_fd_sc_hd__fill_1
XANTENNA__10878__S _05758_ vssd1 vssd1 vccd1 vccd1 sky130_fd_sc_hd__diode_2
XFILLER_75_581 vssd1 vssd1 vccd1 vccd1 sky130_fd_sc_hd__fill_1
X_13908_ clknet_leaf_35_clk net1280 net637 vssd1 vssd1 vccd1 vccd1 cell2.LE_0B.config_data\[9\]
+ sky130_fd_sc_hd__dfrtp_1
XANTENNA__10287__A2 _05148_ vssd1 vssd1 vccd1 vccd1 sky130_fd_sc_hd__diode_2
XFILLER_90_540 vssd1 vssd1 vccd1 vccd1 sky130_fd_sc_hd__fill_2
X_13839_ clknet_leaf_113_clk _00811_ net674 vssd1 vssd1 vccd1 vccd1 cell1.SB0.route_sel\[116\]
+ sky130_fd_sc_hd__dfstp_1
XANTENNA__06944__X bus2_0\[7\] vssd1 vssd1 vccd1 vccd1 sky130_fd_sc_hd__diode_2
X_07360_ net343 _02121_ _02336_ vssd1 vssd1 vccd1 vccd1 _02416_ sky130_fd_sc_hd__or3_1
XTAP_TAPCELL_ROW_46_996 vssd1 vccd1 sky130_fd_sc_hd__tapvpwrvgnd_1
XANTENNA__10995__A0 net40 vssd1 vssd1 vccd1 vccd1 sky130_fd_sc_hd__diode_2
X_09030_ bus3_1\[5\] _04054_ _04055_ bus3_1\[4\] cell1.CB_0.config_dataB\[3\] vssd1
+ vssd1 vccd1 vccd1 _04060_ sky130_fd_sc_hd__a221o_1
XANTENNA__08652__A2 _03465_ vssd1 vssd1 vccd1 vccd1 sky130_fd_sc_hd__diode_2
XFILLER_30_150 vssd1 vssd1 vccd1 vccd1 sky130_fd_sc_hd__fill_2
XFILLER_31_673 vssd1 vssd1 vccd1 vccd1 sky130_fd_sc_hd__fill_1
X_07291_ _02348_ vssd1 vssd1 vccd1 vccd1 _02349_ sky130_fd_sc_hd__inv_2
Xhold302 _01093_ vssd1 vssd1 vccd1 vccd1 net1261 sky130_fd_sc_hd__dlygate4sd3_1
Xhold324 _01439_ vssd1 vssd1 vccd1 vccd1 net1283 sky130_fd_sc_hd__dlygate4sd3_1
Xhold335 cell2.LE_1B.config_data\[2\] vssd1 vssd1 vccd1 vccd1 net1294 sky130_fd_sc_hd__dlygate4sd3_1
Xhold313 _00593_ vssd1 vssd1 vccd1 vccd1 net1272 sky130_fd_sc_hd__dlygate4sd3_1
XFILLER_7_93 vccd1 vssd1 vccd1 vssd1 sky130_ef_sc_hd__decap_40_12
Xhold357 cell2.LEI0.config_data\[26\] vssd1 vssd1 vccd1 vccd1 net1316 sky130_fd_sc_hd__dlygate4sd3_1
Xhold346 _01107_ vssd1 vssd1 vccd1 vccd1 net1305 sky130_fd_sc_hd__dlygate4sd3_1
XFILLER_117_39 vccd1 vssd1 vccd1 vssd1 sky130_ef_sc_hd__decap_40_12
XFILLER_104_406 vssd1 vssd1 vccd1 vccd1 sky130_fd_sc_hd__fill_1
X_09932_ _04924_ _04445_ _04399_ _04923_ vssd1 vssd1 vccd1 vccd1 _04936_ sky130_fd_sc_hd__o2bb2a_1
Xhold368 cell1.LE_1A.config_data\[0\] vssd1 vssd1 vccd1 vccd1 net1327 sky130_fd_sc_hd__dlygate4sd3_1
Xfanout815 net817 vssd1 vssd1 vccd1 vccd1 net815 sky130_fd_sc_hd__clkbuf_4
Xfanout804 net805 vssd1 vssd1 vccd1 vccd1 net804 sky130_fd_sc_hd__clkbuf_4
Xhold379 cell1.LEI0.config_data\[23\] vssd1 vssd1 vccd1 vccd1 net1338 sky130_fd_sc_hd__dlygate4sd3_1
XTAP_TAPCELL_ROW_129_2239 vssd1 vccd1 sky130_fd_sc_hd__tapvpwrvgnd_1
Xfanout826 net827 vssd1 vssd1 vccd1 vccd1 net826 sky130_fd_sc_hd__clkbuf_4
Xfanout848 net854 vssd1 vssd1 vccd1 vccd1 net848 sky130_fd_sc_hd__clkbuf_4
Xfanout837 net855 vssd1 vssd1 vccd1 vccd1 net837 sky130_fd_sc_hd__buf_2
X_09863_ cell2.CB_1.config_dataA\[13\] cell2.CB_1.config_dataA\[12\] cell2.CB_1.config_dataA\[14\]
+ _04835_ vssd1 vssd1 vccd1 vccd1 _04869_ sky130_fd_sc_hd__or4bb_1
XFILLER_86_813 vssd1 vssd1 vccd1 vccd1 sky130_fd_sc_hd__fill_1
XFILLER_140_781 vccd1 vssd1 vccd1 vssd1 sky130_ef_sc_hd__decap_40_12
XFILLER_133_27 vccd1 vssd1 vccd1 vssd1 sky130_ef_sc_hd__decap_40_12
X_09794_ net448 _04608_ vssd1 vssd1 vccd1 vccd1 _04800_ sky130_fd_sc_hd__nand2_1
XFILLER_100_623 vssd1 vssd1 vccd1 vccd1 sky130_fd_sc_hd__fill_1
X_08814_ net471 _03841_ _03845_ net469 vssd1 vssd1 vccd1 vccd1 _03846_ sky130_fd_sc_hd__o211a_1
XTAP_TAPCELL_ROW_51_1069 vssd1 vccd1 sky130_fd_sc_hd__tapvpwrvgnd_1
Xfanout859 net862 vssd1 vssd1 vccd1 vccd1 net859 sky130_fd_sc_hd__clkbuf_4
X_08745_ net452 _03486_ _03778_ net451 vssd1 vssd1 vccd1 vccd1 _03779_ sky130_fd_sc_hd__o211ai_1
XTAP_TAPCELL_ROW_142_2439 vssd1 vccd1 sky130_fd_sc_hd__tapvpwrvgnd_1
XFILLER_85_389 vssd1 vssd1 vccd1 vccd1 sky130_fd_sc_hd__fill_2
XANTENNA__10278__A2 _05276_ vssd1 vssd1 vccd1 vccd1 sky130_fd_sc_hd__diode_2
XFILLER_54_743 vssd1 vssd1 vccd1 vccd1 sky130_fd_sc_hd__fill_1
X_08676_ net461 _03468_ vssd1 vssd1 vccd1 vccd1 _03710_ sky130_fd_sc_hd__nand2_1
XANTENNA__08340__A1 net346 vssd1 vssd1 vccd1 vccd1 sky130_fd_sc_hd__diode_2
XANTENNA_fanout725_A net727 vssd1 vssd1 vccd1 vccd1 sky130_fd_sc_hd__diode_2
X_07627_ cell0.SB0.route_sel\[15\] cell0.SB0.route_sel\[14\] vssd1 vssd1 vccd1 vccd1
+ _02676_ sky130_fd_sc_hd__nand2b_1
XFILLER_14_618 vssd1 vssd1 vccd1 vccd1 sky130_fd_sc_hd__fill_1
XFILLER_26_69 vssd1 vssd1 vccd1 vccd1 sky130_fd_sc_hd__fill_1
XANTENNA_fanout346_X net346 vssd1 vssd1 vccd1 vccd1 sky130_fd_sc_hd__diode_2
X_07558_ _02011_ _02607_ vssd1 vssd1 vccd1 vccd1 _02608_ sky130_fd_sc_hd__or2_1
X_06509_ cell2.SB0.route_sel\[8\] vssd1 vssd1 vccd1 vccd1 _01579_ sky130_fd_sc_hd__inv_2
XTAP_TAPCELL_ROW_24_668 vssd1 vccd1 sky130_fd_sc_hd__tapvpwrvgnd_1
X_07489_ cell0.CB_1.le_outB _01932_ _02325_ _02323_ _01931_ vssd1 vssd1 vccd1 vccd1
+ _02541_ sky130_fd_sc_hd__a32o_1
X_09228_ _04254_ net310 _04253_ vssd1 vssd1 vccd1 vccd1 _04255_ sky130_fd_sc_hd__mux2_1
X_09159_ cell2.CB_0.config_dataB\[22\] cell2.CB_0.config_dataB\[23\] vssd1 vssd1 vccd1
+ vccd1 _04187_ sky130_fd_sc_hd__nor2_1
X_12170_ cell2.LE_1B.config_data\[3\] net1294 net850 vssd1 vssd1 vccd1 vccd1 _00603_
+ sky130_fd_sc_hd__mux2_1
XPHY_EDGE_ROW_2_Left_145 vssd1 vssd1 vccd1 vccd1 sky130_fd_sc_hd__decap_3
X_11121_ cell3.CB_0.config_dataB\[2\] _06061_ _06062_ _06068_ _06072_ vssd1 vssd1
+ vccd1 vccd1 _06073_ sky130_fd_sc_hd__a311o_1
XFILLER_101_3 vccd1 vssd1 vccd1 vssd1 sky130_ef_sc_hd__decap_40_12
XANTENNA__13337__SET_B net674 vssd1 vssd1 vccd1 vccd1 sky130_fd_sc_hd__diode_2
X_11052_ net372 _06005_ vssd1 vssd1 vccd1 vccd1 _06006_ sky130_fd_sc_hd__and2_1
XFILLER_89_684 vssd1 vssd1 vccd1 vccd1 sky130_fd_sc_hd__fill_1
XFILLER_89_673 vssd1 vssd1 vccd1 vccd1 sky130_fd_sc_hd__fill_1
XANTENNA__10910__A0 net53 vssd1 vssd1 vccd1 vccd1 sky130_fd_sc_hd__diode_2
X_10003_ _04527_ _04998_ _04555_ _04996_ vssd1 vssd1 vccd1 vccd1 _05007_ sky130_fd_sc_hd__a2bb2o_1
XANTENNA_input21_A CBeast_in[28] vssd1 vssd1 vccd1 vccd1 sky130_fd_sc_hd__diode_2
XFILLER_49_559 vssd1 vssd1 vccd1 vccd1 sky130_fd_sc_hd__fill_1
XANTENNA__07861__A _02675_ vssd1 vssd1 vccd1 vccd1 sky130_fd_sc_hd__diode_2
XANTENNA_clkbuf_4_13_0_clk_A clknet_0_clk vssd1 vssd1 vccd1 vccd1 sky130_fd_sc_hd__diode_2
XTAP_TAPCELL_ROW_86_1600 vssd1 vccd1 sky130_fd_sc_hd__tapvpwrvgnd_1
XANTENNA__08676__B _03468_ vssd1 vssd1 vccd1 vccd1 sky130_fd_sc_hd__diode_2
XTAP_TAPCELL_ROW_4_371 vssd1 vccd1 sky130_fd_sc_hd__tapvpwrvgnd_1
XFILLER_36_209 vssd1 vssd1 vccd1 vccd1 sky130_fd_sc_hd__fill_1
XFILLER_91_337 vssd1 vssd1 vccd1 vccd1 sky130_fd_sc_hd__fill_4
XFILLER_44_231 vssd1 vssd1 vccd1 vccd1 sky130_fd_sc_hd__fill_1
X_11954_ cell0.SB0.route_sel\[60\] cell0.SB0.route_sel\[59\] net761 vssd1 vssd1 vccd1
+ vccd1 _00391_ sky130_fd_sc_hd__mux2_1
X_10905_ cell3.SB0.route_sel\[107\] cell3.SB0.route_sel\[106\] vssd1 vssd1 vccd1 vccd1
+ _05859_ sky130_fd_sc_hd__nor2_1
X_11885_ net463 net464 net881 vssd1 vssd1 vccd1 vccd1 _00322_ sky130_fd_sc_hd__mux2_1
X_10836_ cell3.LEI0.config_data\[34\] _05788_ _05791_ vssd1 vssd1 vccd1 vccd1 _05792_
+ sky130_fd_sc_hd__o21a_1
XANTENNA__08882__A2 _03817_ vssd1 vssd1 vccd1 vccd1 sky130_fd_sc_hd__diode_2
X_13624_ clknet_leaf_95_clk _00596_ net687 vssd1 vssd1 vccd1 vccd1 cell1.LEI0.config_data\[45\]
+ sky130_fd_sc_hd__dfrtp_1
XTAP_TAPCELL_ROW_43_955 vssd1 vccd1 sky130_fd_sc_hd__tapvpwrvgnd_1
X_10767_ _05519_ _05523_ net369 vssd1 vssd1 vccd1 vccd1 _05723_ sky130_fd_sc_hd__mux2_1
X_13555_ clknet_1_1__leaf_cell1.LE_1A.sel_clk _00527_ net753 vssd1 vssd1 vccd1 vccd1
+ cell1.LE_1A.dff1_out sky130_fd_sc_hd__dfstp_1
XFILLER_8_121 vccd1 vssd1 vccd1 vssd1 sky130_ef_sc_hd__decap_40_12
XFILLER_13_673 vssd1 vssd1 vccd1 vccd1 sky130_fd_sc_hd__fill_4
X_12506_ net1078 net1310 net850 vssd1 vssd1 vccd1 vccd1 _00935_ sky130_fd_sc_hd__mux2_1
X_10698_ _05489_ _05643_ _05645_ _05483_ cell3.CB_1.config_dataA\[17\] vssd1 vssd1
+ vccd1 vccd1 _05656_ sky130_fd_sc_hd__o221a_1
X_13486_ clknet_leaf_10_clk _00458_ net592 vssd1 vssd1 vccd1 vccd1 cell0.SB0.config_data_out
+ sky130_fd_sc_hd__dfstp_2
X_12437_ net1487 net549 _06381_ vssd1 vssd1 vccd1 vccd1 _00869_ sky130_fd_sc_hd__a21bo_1
XANTENNA__13688__SET_B net619 vssd1 vssd1 vccd1 vccd1 sky130_fd_sc_hd__diode_2
XTAP_TAPCELL_ROW_113_2007 vssd1 vccd1 sky130_fd_sc_hd__tapvpwrvgnd_1
XTAP_TAPCELL_ROW_97_1762 vssd1 vccd1 sky130_fd_sc_hd__tapvpwrvgnd_1
XANTENNA__09595__B1 _04611_ vssd1 vssd1 vccd1 vccd1 sky130_fd_sc_hd__diode_2
XANTENNA__08398__A1 bus1_0\[1\] vssd1 vssd1 vccd1 vccd1 sky130_fd_sc_hd__diode_2
X_14107_ clknet_leaf_76_clk _01079_ net726 vssd1 vssd1 vccd1 vccd1 cell3.SB0.route_sel\[115\]
+ sky130_fd_sc_hd__dfstp_1
X_12368_ cell1.SB0.route_sel\[106\] cell1.SB0.route_sel\[105\] net874 vssd1 vssd1
+ vccd1 vccd1 _00801_ sky130_fd_sc_hd__mux2_1
X_11319_ _04662_ _05527_ _04647_ vssd1 vssd1 vccd1 vccd1 _06225_ sky130_fd_sc_hd__a21o_1
X_12299_ cell1.SB0.route_sel\[37\] cell1.SB0.route_sel\[36\] net860 vssd1 vssd1 vccd1
+ vccd1 _00732_ sky130_fd_sc_hd__mux2_1
XFILLER_113_258 vssd1 vssd1 vccd1 vccd1 sky130_fd_sc_hd__fill_1
XANTENNA__10181__B _05103_ vssd1 vssd1 vccd1 vccd1 sky130_fd_sc_hd__diode_2
X_14038_ clknet_leaf_49_clk _01010_ net706 vssd1 vssd1 vccd1 vccd1 cell3.SB0.route_sel\[46\]
+ sky130_fd_sc_hd__dfstp_1
X_06860_ cell2.SB0.route_sel\[54\] cell2.SB0.route_sel\[55\] vssd1 vssd1 vccd1 vccd1
+ _01929_ sky130_fd_sc_hd__or2_1
XANTENNA__06939__X _02006_ vssd1 vssd1 vccd1 vccd1 sky130_fd_sc_hd__diode_2
XANTENNA__08570__A1 net32 vssd1 vssd1 vccd1 vccd1 sky130_fd_sc_hd__diode_2
X_06791_ _01860_ _01856_ _01857_ vssd1 vssd1 vccd1 vccd1 _01861_ sky130_fd_sc_hd__mux2_1
XTAP_TAPCELL_ROW_124_2169 vssd1 vccd1 sky130_fd_sc_hd__tapvpwrvgnd_1
XFILLER_94_197 vccd1 vssd1 vccd1 vssd1 sky130_ef_sc_hd__decap_40_12
X_08530_ _02444_ _03493_ _03550_ vssd1 vssd1 vccd1 vccd1 _03566_ sky130_fd_sc_hd__o21ai_1
XANTENNA__07490__B _01931_ vssd1 vssd1 vccd1 vccd1 sky130_fd_sc_hd__diode_2
X_08461_ _01539_ cell1.SB0.route_sel\[96\] cell1.SB0.route_sel\[103\] _01543_ vssd1
+ vssd1 vccd1 vccd1 _03497_ sky130_fd_sc_hd__o22a_1
XANTENNA__11209__B2 _05861_ vssd1 vssd1 vccd1 vccd1 sky130_fd_sc_hd__diode_2
XANTENNA__11209__A1 _05856_ vssd1 vssd1 vccd1 vccd1 sky130_fd_sc_hd__diode_2
XTAP_TAPCELL_ROW_106_1891 vssd1 vccd1 sky130_fd_sc_hd__tapvpwrvgnd_1
X_07412_ cell2.SB0.route_sel\[104\] cell2.SB0.route_sel\[105\] _02466_ vssd1 vssd1
+ vccd1 vccd1 _02467_ sky130_fd_sc_hd__a21oi_1
XANTENNA__12957__A1 cell2.SB0.config_data_out vssd1 vssd1 vccd1 vccd1 sky130_fd_sc_hd__diode_2
X_08392_ _03422_ _02136_ _02040_ _03421_ vssd1 vssd1 vccd1 vccd1 _03430_ sky130_fd_sc_hd__o2bb2a_1
XANTENNA__11232__S _06076_ vssd1 vssd1 vccd1 vccd1 sky130_fd_sc_hd__diode_2
X_07343_ cell2.SB0.route_sel\[96\] cell2.SB0.route_sel\[97\] net311 _02398_ vssd1
+ vssd1 vccd1 vccd1 _02400_ sky130_fd_sc_hd__a22o_1
XFILLER_10_109 vssd1 vssd1 vccd1 vccd1 sky130_fd_sc_hd__fill_8
XTAP_TAPCELL_ROW_21_616 vssd1 vccd1 sky130_fd_sc_hd__tapvpwrvgnd_1
XTAP_TAPCELL_ROW_21_627 vssd1 vccd1 sky130_fd_sc_hd__tapvpwrvgnd_1
XTAP_TAPCELL_ROW_139_2390 vssd1 vccd1 sky130_fd_sc_hd__tapvpwrvgnd_1
XFILLER_137_829 vssd1 vssd1 vccd1 vccd1 sky130_fd_sc_hd__fill_2
XANTENNA__07833__A0 bus2_0\[8\] vssd1 vssd1 vccd1 vccd1 sky130_fd_sc_hd__diode_2
XANTENNA__09210__B _03870_ vssd1 vssd1 vccd1 vccd1 sky130_fd_sc_hd__diode_2
X_07274_ cell0.SB0.route_sel\[102\] cell0.SB0.route_sel\[103\] vssd1 vssd1 vccd1 vccd1
+ _02332_ sky130_fd_sc_hd__nand2_1
XFILLER_129_380 vssd1 vssd1 vccd1 vccd1 sky130_fd_sc_hd__fill_1
XANTENNA__10983__A3 net57 vssd1 vssd1 vccd1 vccd1 sky130_fd_sc_hd__diode_2
XFILLER_128_27 vssd1 vssd1 vccd1 vccd1 sky130_fd_sc_hd__fill_1
X_09013_ net483 _03844_ vssd1 vssd1 vccd1 vccd1 _04043_ sky130_fd_sc_hd__nand2_1
XANTENNA_fanout306_A net308 vssd1 vssd1 vccd1 vccd1 sky130_fd_sc_hd__diode_2
Xhold110 _00136_ vssd1 vssd1 vccd1 vccd1 net1069 sky130_fd_sc_hd__dlygate4sd3_1
XFILLER_3_809 vccd1 vssd1 vccd1 vssd1 sky130_ef_sc_hd__decap_40_12
Xhold132 cell2.LE_0A.config_data\[14\] vssd1 vssd1 vccd1 vccd1 net1091 sky130_fd_sc_hd__dlygate4sd3_1
Xhold121 _01353_ vssd1 vssd1 vccd1 vccd1 net1080 sky130_fd_sc_hd__dlygate4sd3_1
Xhold143 cell1.LE_0A.config_data\[14\] vssd1 vssd1 vccd1 vccd1 net1102 sky130_fd_sc_hd__dlygate4sd3_1
XANTENNA_clkbuf_leaf_1_clk_A clknet_4_0_0_clk vssd1 vssd1 vccd1 vccd1 sky130_fd_sc_hd__diode_2
Xhold176 _01389_ vssd1 vssd1 vccd1 vccd1 net1135 sky130_fd_sc_hd__dlygate4sd3_1
Xhold165 cell2.LE_0A.config_data\[8\] vssd1 vssd1 vccd1 vccd1 net1124 sky130_fd_sc_hd__dlygate4sd3_1
Xhold154 cell0.LEI0.config_data\[1\] vssd1 vssd1 vccd1 vccd1 net1113 sky130_fd_sc_hd__dlygate4sd3_1
XTAP_TAPCELL_ROW_53_1109 vssd1 vccd1 sky130_fd_sc_hd__tapvpwrvgnd_1
Xfanout623 net650 vssd1 vssd1 vccd1 vccd1 net623 sky130_fd_sc_hd__buf_2
Xhold187 _00923_ vssd1 vssd1 vccd1 vccd1 net1146 sky130_fd_sc_hd__dlygate4sd3_1
X_09915_ cell2.LE_1A.dff0_out cell2.LE_1A.dff1_out cell2.LE_1A.reset_val vssd1 vssd1
+ vccd1 vccd1 cell2.LE_1A.dff_out sky130_fd_sc_hd__mux2_1
Xfanout612 net623 vssd1 vssd1 vccd1 vccd1 net612 sky130_fd_sc_hd__clkbuf_2
Xhold198 cell0.LE_0A.config_data\[16\] vssd1 vssd1 vccd1 vccd1 net1157 sky130_fd_sc_hd__dlygate4sd3_1
Xfanout601 net602 vssd1 vssd1 vccd1 vccd1 net601 sky130_fd_sc_hd__clkbuf_2
Xfanout645 net649 vssd1 vssd1 vccd1 vccd1 net645 sky130_fd_sc_hd__clkbuf_4
Xfanout634 net635 vssd1 vssd1 vccd1 vccd1 net634 sky130_fd_sc_hd__clkbuf_2
X_09846_ _04851_ vssd1 vssd1 vccd1 vccd1 _04852_ sky130_fd_sc_hd__inv_2
XANTENNA__09889__A1 bus3_2\[5\] vssd1 vssd1 vccd1 vccd1 sky130_fd_sc_hd__diode_2
XANTENNA__09889__B2 bus3_2\[4\] vssd1 vssd1 vccd1 vccd1 sky130_fd_sc_hd__diode_2
XANTENNA_fanout675_A net750 vssd1 vssd1 vccd1 vccd1 sky130_fd_sc_hd__diode_2
Xfanout667 net672 vssd1 vssd1 vccd1 vccd1 net667 sky130_fd_sc_hd__clkbuf_2
Xfanout656 net657 vssd1 vssd1 vccd1 vccd1 net656 sky130_fd_sc_hd__clkbuf_4
XFILLER_100_431 vssd1 vssd1 vccd1 vccd1 sky130_fd_sc_hd__fill_1
XFILLER_86_643 vssd1 vssd1 vccd1 vccd1 sky130_fd_sc_hd__fill_1
Xfanout689 net690 vssd1 vssd1 vccd1 vccd1 net689 sky130_fd_sc_hd__clkbuf_4
Xfanout678 net684 vssd1 vssd1 vccd1 vccd1 net678 sky130_fd_sc_hd__clkbuf_4
XANTENNA_fanout842_A net845 vssd1 vssd1 vccd1 vccd1 sky130_fd_sc_hd__diode_2
X_09777_ _04771_ _04772_ _04779_ vssd1 vssd1 vccd1 vccd1 _04783_ sky130_fd_sc_hd__o21ai_1
XFILLER_100_475 vssd1 vssd1 vccd1 vccd1 sky130_fd_sc_hd__fill_1
X_06989_ _02049_ _02053_ _02054_ vssd1 vssd1 vccd1 vccd1 _02055_ sky130_fd_sc_hd__a21oi_1
XANTENNA__11474__Y net217 vssd1 vssd1 vccd1 vccd1 sky130_fd_sc_hd__diode_2
XFILLER_37_57 vssd1 vssd1 vccd1 vccd1 sky130_fd_sc_hd__fill_8
XFILLER_73_337 vssd1 vssd1 vccd1 vccd1 sky130_fd_sc_hd__fill_1
XTAP_TAPCELL_ROW_68_1330 vssd1 vccd1 sky130_fd_sc_hd__tapvpwrvgnd_1
XTAP_TAPCELL_ROW_1_330 vssd1 vccd1 sky130_fd_sc_hd__tapvpwrvgnd_1
X_08728_ _03754_ _03757_ _03761_ cell1.CB_1.config_dataB\[13\] vssd1 vssd1 vccd1 vccd1
+ _03762_ sky130_fd_sc_hd__or4b_1
XTAP_TAPCELL_ROW_29_738 vssd1 vccd1 sky130_fd_sc_hd__tapvpwrvgnd_1
XTAP_TAPCELL_ROW_29_749 vssd1 vccd1 sky130_fd_sc_hd__tapvpwrvgnd_1
X_08659_ _02444_ _03493_ _03670_ vssd1 vssd1 vccd1 vccd1 _03693_ sky130_fd_sc_hd__o21ai_1
XTAP_TAPCELL_ROW_81_1530 vssd1 vccd1 sky130_fd_sc_hd__tapvpwrvgnd_1
XFILLER_41_234 vssd1 vssd1 vccd1 vccd1 sky130_fd_sc_hd__fill_1
XTAP_TAPCELL_ROW_40_903 vssd1 vccd1 sky130_fd_sc_hd__tapvpwrvgnd_1
X_11670_ net499 net500 net786 vssd1 vssd1 vccd1 vccd1 _00111_ sky130_fd_sc_hd__mux2_1
XFILLER_139_111 vssd1 vssd1 vccd1 vccd1 sky130_fd_sc_hd__fill_1
X_10621_ _05553_ _05569_ _01784_ vssd1 vssd1 vccd1 vccd1 _05579_ sky130_fd_sc_hd__o21ai_1
XANTENNA__10547__A _05504_ vssd1 vssd1 vccd1 vccd1 sky130_fd_sc_hd__diode_2
XTAP_TAPCELL_ROW_40_914 vssd1 vccd1 sky130_fd_sc_hd__tapvpwrvgnd_1
X_10552_ net276 _05509_ vssd1 vssd1 vccd1 vccd1 _05510_ sky130_fd_sc_hd__nand2_4
X_13340_ clknet_leaf_83_clk _00312_ net671 vssd1 vssd1 vccd1 vccd1 cell1.CB_0.config_dataA\[6\]
+ sky130_fd_sc_hd__dfstp_1
XANTENNA__10974__A3 net291 vssd1 vssd1 vccd1 vccd1 sky130_fd_sc_hd__diode_2
X_13271_ clknet_leaf_93_clk _00243_ net693 vssd1 vssd1 vccd1 vccd1 cell1.LE_1B.config_data\[7\]
+ sky130_fd_sc_hd__dfrtp_1
XFILLER_5_113 vccd1 vssd1 vccd1 vssd1 sky130_ef_sc_hd__decap_40_12
X_12222_ net429 cell2.CB_0.config_dataB\[9\] net825 vssd1 vssd1 vccd1 vccd1 _00655_
+ sky130_fd_sc_hd__mux2_1
XFILLER_6_669 vccd1 vssd1 vccd1 vssd1 sky130_ef_sc_hd__decap_40_12
X_10483_ net320 _03518_ _02639_ vssd1 vssd1 vccd1 vccd1 _05457_ sky130_fd_sc_hd__mux2_1
XANTENNA__10187__A1 _02106_ vssd1 vssd1 vccd1 vccd1 sky130_fd_sc_hd__diode_2
XANTENNA__10187__B2 _05093_ vssd1 vssd1 vccd1 vccd1 sky130_fd_sc_hd__diode_2
XTAP_TAPCELL_ROW_79_1492 vssd1 vccd1 sky130_fd_sc_hd__tapvpwrvgnd_1
XANTENNA__09041__A2 bus3_1\[14\] vssd1 vssd1 vccd1 vccd1 sky130_fd_sc_hd__diode_2
XANTENNA_input69_A SBsouth_in[13] vssd1 vssd1 vccd1 vccd1 sky130_fd_sc_hd__diode_2
XANTENNA__06760__A cell0.CB_1.le_outB vssd1 vssd1 vccd1 vccd1 sky130_fd_sc_hd__diode_2
X_12153_ net1218 net1237 net900 vssd1 vssd1 vccd1 vccd1 _00586_ sky130_fd_sc_hd__mux2_1
XTAP_TAPCELL_ROW_9_441 vssd1 vccd1 sky130_fd_sc_hd__tapvpwrvgnd_1
XFILLER_2_831 vssd1 vssd1 vccd1 vccd1 sky130_fd_sc_hd__fill_1
X_11104_ net274 _05878_ _06047_ vssd1 vssd1 vccd1 vccd1 _06056_ sky130_fd_sc_hd__a21o_1
XTAP_TAPCELL_ROW_92_1681 vssd1 vccd1 sky130_fd_sc_hd__tapvpwrvgnd_1
X_12084_ cell1.LE_0B.config_data\[12\] net1097 net905 vssd1 vssd1 vccd1 vccd1 _00519_
+ sky130_fd_sc_hd__mux2_1
X_11035_ _05987_ _05988_ _05979_ _05985_ vssd1 vssd1 vccd1 vccd1 _05989_ sky130_fd_sc_hd__o211a_1
XTAP_TAPCELL_ROW_92_1692 vssd1 vccd1 sky130_fd_sc_hd__tapvpwrvgnd_1
XFILLER_1_385 vssd1 vssd1 vccd1 vccd1 sky130_fd_sc_hd__fill_4
XANTENNA__09790__B _04696_ vssd1 vssd1 vccd1 vccd1 sky130_fd_sc_hd__diode_2
XANTENNA_input24_X net24 vssd1 vssd1 vccd1 vccd1 sky130_fd_sc_hd__diode_2
XFILLER_134_81 vssd1 vssd1 vccd1 vccd1 sky130_fd_sc_hd__fill_1
XFILLER_94_41 vccd1 vssd1 vccd1 vssd1 sky130_ef_sc_hd__decap_40_12
XFILLER_77_687 vssd1 vssd1 vccd1 vccd1 sky130_fd_sc_hd__fill_4
X_12986_ net1431 net1454 net945 vssd1 vssd1 vccd1 vccd1 _01414_ sky130_fd_sc_hd__mux2_1
XFILLER_94_85 vccd1 vssd1 vccd1 vssd1 sky130_ef_sc_hd__decap_40_12
XANTENNA__12636__A0 cell3.SB0.route_sel\[101\] vssd1 vssd1 vccd1 vccd1 sky130_fd_sc_hd__diode_2
XANTENNA__06919__B _01985_ vssd1 vssd1 vccd1 vccd1 sky130_fd_sc_hd__diode_2
XANTENNA__08304__A1 net338 vssd1 vssd1 vccd1 vccd1 sky130_fd_sc_hd__diode_2
X_11937_ cell0.SB0.route_sel\[43\] cell0.SB0.route_sel\[42\] net757 vssd1 vssd1 vccd1
+ vccd1 _00374_ sky130_fd_sc_hd__mux2_1
X_11868_ cell1.CB_0.config_dataB\[24\] cell1.CB_0.config_dataB\[23\] net881 vssd1
+ vssd1 vccd1 vccd1 _00305_ sky130_fd_sc_hd__mux2_1
XANTENNA__08626__S _03546_ vssd1 vssd1 vccd1 vccd1 sky130_fd_sc_hd__diode_2
XANTENNA__06866__A1 cell0.CB_1.le_outB vssd1 vssd1 vccd1 vccd1 sky130_fd_sc_hd__diode_2
X_10819_ _05510_ _05761_ _05773_ net366 cell3.CB_1.config_dataB\[12\] vssd1 vssd1
+ vccd1 vccd1 _05775_ sky130_fd_sc_hd__a221o_1
X_13607_ clknet_leaf_86_clk net1365 net686 vssd1 vssd1 vccd1 vccd1 cell1.LEI0.config_data\[28\]
+ sky130_fd_sc_hd__dfrtp_1
X_11799_ net1347 cell1.LE_0A.reset_mode net905 vssd1 vssd1 vccd1 vccd1 _00236_ sky130_fd_sc_hd__mux2_1
XANTENNA__08068__A0 bus2_0\[6\] vssd1 vssd1 vccd1 vccd1 sky130_fd_sc_hd__diode_2
XFILLER_32_289 vssd1 vssd1 vccd1 vccd1 sky130_fd_sc_hd__fill_1
X_13538_ clknet_leaf_90_clk _00510_ net697 vssd1 vssd1 vccd1 vccd1 cell1.LE_0B.config_data\[3\]
+ sky130_fd_sc_hd__dfrtp_1
XPHY_EDGE_ROW_65_Left_208 vssd1 vssd1 vccd1 vccd1 sky130_fd_sc_hd__decap_3
XANTENNA__11987__S net787 vssd1 vssd1 vccd1 vccd1 sky130_fd_sc_hd__diode_2
X_13469_ clknet_leaf_0_clk _00441_ net554 vssd1 vssd1 vccd1 vccd1 cell0.SB0.route_sel\[110\]
+ sky130_fd_sc_hd__dfstp_1
XFILLER_142_810 vssd1 vssd1 vccd1 vccd1 sky130_fd_sc_hd__fill_2
XANTENNA__06670__A cell3.SB0.route_sel\[100\] vssd1 vssd1 vccd1 vccd1 sky130_fd_sc_hd__diode_2
Xoutput226 net226 vssd1 vssd1 vccd1 vccd1 SBsouth_out[6] sky130_fd_sc_hd__buf_2
Xoutput204 net204 vssd1 vssd1 vccd1 vccd1 SBsouth_out[15] sky130_fd_sc_hd__buf_2
Xoutput215 net215 vssd1 vssd1 vccd1 vccd1 SBsouth_out[25] sky130_fd_sc_hd__buf_2
XANTENNA__07766__A net77 vssd1 vssd1 vccd1 vccd1 sky130_fd_sc_hd__diode_2
Xoutput248 net248 vssd1 vssd1 vccd1 vccd1 SBwest_out[26] sky130_fd_sc_hd__buf_2
Xoutput237 net237 vssd1 vssd1 vccd1 vccd1 SBwest_out[16] sky130_fd_sc_hd__buf_2
Xoutput259 net259 vssd1 vssd1 vccd1 vccd1 SBwest_out[7] sky130_fd_sc_hd__buf_2
X_07961_ bus2_0\[12\] bus2_0\[13\] bus2_0\[14\] bus2_0\[15\] net513 net511 vssd1 vssd1
+ vccd1 vccd1 _03005_ sky130_fd_sc_hd__mux4_1
X_09700_ cell3.SB0.route_sel\[112\] cell3.SB0.route_sel\[113\] _04706_ _04713_ vssd1
+ vssd1 vccd1 vccd1 _04714_ sky130_fd_sc_hd__a31o_1
XFILLER_4_83 vssd1 vssd1 vccd1 vccd1 sky130_fd_sc_hd__fill_1
X_06912_ cell1.SB0.route_sel\[56\] cell1.SB0.route_sel\[57\] vssd1 vssd1 vccd1 vccd1
+ _01980_ sky130_fd_sc_hd__or2_1
XFILLER_114_29 vccd1 vssd1 vccd1 vssd1 sky130_ef_sc_hd__decap_40_12
XPHY_EDGE_ROW_74_Left_217 vssd1 vssd1 vccd1 vccd1 sky130_fd_sc_hd__decap_3
XFILLER_68_643 vssd1 vssd1 vccd1 vccd1 sky130_fd_sc_hd__fill_1
X_07892_ net522 _02301_ vssd1 vssd1 vccd1 vccd1 _02936_ sky130_fd_sc_hd__nand2_1
X_09631_ _04210_ _04646_ vssd1 vssd1 vccd1 vccd1 _04647_ sky130_fd_sc_hd__nor2_1
X_06843_ _01457_ cell0.SB0.route_sel\[52\] _01458_ cell0.SB0.route_sel\[55\] _01911_
+ vssd1 vssd1 vccd1 vccd1 _01912_ sky130_fd_sc_hd__a221o_1
XFILLER_28_529 vssd1 vssd1 vccd1 vccd1 sky130_fd_sc_hd__fill_2
XANTENNA__11227__S _06076_ vssd1 vssd1 vccd1 vccd1 sky130_fd_sc_hd__diode_2
XTAP_TAPCELL_ROW_108_1931 vssd1 vccd1 sky130_fd_sc_hd__tapvpwrvgnd_1
X_09562_ cell3.SB0.route_sel\[85\] cell3.SB0.route_sel\[84\] _02227_ _04579_ _02224_
+ vssd1 vssd1 vccd1 vccd1 _04580_ sky130_fd_sc_hd__a221o_1
XANTENNA__07897__A3 bus2_0\[11\] vssd1 vssd1 vccd1 vccd1 sky130_fd_sc_hd__diode_2
X_06774_ net320 _01837_ _01838_ _01841_ _01842_ vssd1 vssd1 vccd1 vccd1 _01844_ sky130_fd_sc_hd__o32a_1
X_08513_ cell1.CB_1.config_dataA\[6\] net494 vssd1 vssd1 vccd1 vccd1 _03549_ sky130_fd_sc_hd__nor2_1
X_09493_ net380 _04363_ net381 vssd1 vssd1 vccd1 vccd1 _04514_ sky130_fd_sc_hd__nand3b_1
XANTENNA__10653__A2 net19 vssd1 vssd1 vccd1 vccd1 sky130_fd_sc_hd__diode_2
X_08444_ _03470_ _03479_ vssd1 vssd1 vccd1 vccd1 _03480_ sky130_fd_sc_hd__nor2_1
XTAP_TAPCELL_ROW_63_1260 vssd1 vccd1 sky130_fd_sc_hd__tapvpwrvgnd_1
X_08375_ net342 net346 net349 net340 cell0.LEI0.config_data\[33\] cell0.LEI0.config_data\[34\]
+ vssd1 vssd1 vccd1 vccd1 _03413_ sky130_fd_sc_hd__mux4_1
XFILLER_23_15 vccd1 vssd1 vccd1 vssd1 sky130_ef_sc_hd__decap_40_12
XFILLER_139_15 vccd1 vssd1 vccd1 vssd1 sky130_ef_sc_hd__decap_40_12
X_07326_ net317 _02382_ _02377_ vssd1 vssd1 vccd1 vccd1 _02383_ sky130_fd_sc_hd__mux2_1
XPHY_EDGE_ROW_83_Left_226 vssd1 vssd1 vccd1 vccd1 sky130_fd_sc_hd__decap_3
X_07257_ _02003_ _02100_ vssd1 vssd1 vccd1 vccd1 _02316_ sky130_fd_sc_hd__nor2_1
X_07188_ _01922_ _02100_ vssd1 vssd1 vccd1 vccd1 _02249_ sky130_fd_sc_hd__nor2_1
XANTENNA__10169__A1 _05136_ vssd1 vssd1 vccd1 vccd1 sky130_fd_sc_hd__diode_2
XANTENNA__09023__A2 _03885_ vssd1 vssd1 vccd1 vccd1 sky130_fd_sc_hd__diode_2
XANTENNA__08124__X cell0.CB_0.le_outB vssd1 vssd1 vccd1 vccd1 sky130_fd_sc_hd__diode_2
XFILLER_3_617 vccd1 vssd1 vccd1 vssd1 sky130_ef_sc_hd__decap_40_12
XFILLER_133_843 vssd1 vssd1 vccd1 vccd1 sky130_fd_sc_hd__fill_1
XFILLER_132_331 vssd1 vssd1 vccd1 vccd1 sky130_fd_sc_hd__fill_4
XFILLER_105_567 vssd1 vssd1 vccd1 vccd1 sky130_fd_sc_hd__fill_1
XTAP_TAPCELL_ROW_6_400 vssd1 vccd1 sky130_fd_sc_hd__tapvpwrvgnd_1
Xfanout431 net432 vssd1 vssd1 vccd1 vccd1 net431 sky130_fd_sc_hd__buf_2
XFILLER_105_589 vssd1 vssd1 vccd1 vccd1 sky130_fd_sc_hd__fill_1
Xfanout420 cell2.CB_0.config_dataA\[1\] vssd1 vssd1 vccd1 vccd1 net420 sky130_fd_sc_hd__buf_2
XPHY_EDGE_ROW_92_Left_235 vssd1 vssd1 vccd1 vccd1 sky130_fd_sc_hd__decap_3
Xfanout442 cell2.CB_1.config_dataA\[10\] vssd1 vssd1 vccd1 vccd1 net442 sky130_fd_sc_hd__clkbuf_2
Xfanout464 cell1.CB_0.config_dataA\[15\] vssd1 vssd1 vccd1 vccd1 net464 sky130_fd_sc_hd__buf_2
Xfanout475 cell1.CB_0.config_dataB\[16\] vssd1 vssd1 vccd1 vccd1 net475 sky130_fd_sc_hd__clkbuf_2
Xfanout453 cell1.CB_1.config_dataB\[15\] vssd1 vssd1 vccd1 vccd1 net453 sky130_fd_sc_hd__buf_2
XANTENNA_fanout845_X net845 vssd1 vssd1 vccd1 vccd1 sky130_fd_sc_hd__diode_2
X_09829_ net440 net442 vssd1 vssd1 vccd1 vccd1 _04835_ sky130_fd_sc_hd__and2b_1
XFILLER_86_473 vssd1 vssd1 vccd1 vccd1 sky130_fd_sc_hd__fill_2
Xfanout486 cell1.CB_0.config_dataB\[0\] vssd1 vssd1 vccd1 vccd1 net486 sky130_fd_sc_hd__clkbuf_2
Xfanout497 cell1.CB_1.config_dataA\[0\] vssd1 vssd1 vccd1 vccd1 net497 sky130_fd_sc_hd__clkbuf_2
X_12840_ cell2.SB0.route_sel\[82\] cell2.SB0.route_sel\[81\] net797 vssd1 vssd1 vccd1
+ vccd1 _01269_ sky130_fd_sc_hd__mux2_1
XANTENNA__09115__B _03820_ vssd1 vssd1 vccd1 vccd1 sky130_fd_sc_hd__diode_2
XANTENNA_input123_A SBwest_in[4] vssd1 vssd1 vccd1 vccd1 sky130_fd_sc_hd__diode_2
XFILLER_73_156 vssd1 vssd1 vccd1 vccd1 sky130_fd_sc_hd__fill_4
X_12771_ cell2.SB0.route_sel\[13\] cell2.SB0.route_sel\[12\] net795 vssd1 vssd1 vccd1
+ vccd1 _01200_ sky130_fd_sc_hd__mux2_1
XFILLER_14_212 vssd1 vssd1 vccd1 vccd1 sky130_fd_sc_hd__fill_1
X_11722_ net1527 cell0.LE_0B.edge_mode net803 vssd1 vssd1 vccd1 vccd1 _00161_ sky130_fd_sc_hd__mux2_1
XFILLER_54_392 vssd1 vssd1 vccd1 vccd1 sky130_fd_sc_hd__fill_1
XFILLER_120_83 vssd1 vssd1 vccd1 vccd1 sky130_fd_sc_hd__fill_1
XFILLER_120_61 vssd1 vssd1 vccd1 vccd1 sky130_fd_sc_hd__fill_1
X_14441_ clknet_leaf_59_clk _01413_ net734 vssd1 vssd1 vccd1 vccd1 cell3.LEI0.config_data\[6\]
+ sky130_fd_sc_hd__dfrtp_1
X_11653_ cell0.CB_0.config_dataA\[24\] cell0.CB_0.config_dataA\[23\] net777 vssd1
+ vssd1 vccd1 vccd1 _00094_ sky130_fd_sc_hd__mux2_1
XFILLER_42_587 vssd1 vssd1 vccd1 vccd1 sky130_fd_sc_hd__fill_1
XFILLER_9_39 vccd1 vssd1 vccd1 vssd1 sky130_ef_sc_hd__decap_40_12
X_14372_ clknet_leaf_65_clk net1407 net744 vssd1 vssd1 vccd1 vccd1 cell3.LE_1A.config_data\[3\]
+ sky130_fd_sc_hd__dfrtp_1
X_10604_ cell3.CB_1.config_dataA\[9\] _05516_ _05557_ _05560_ vssd1 vssd1 vccd1 vccd1
+ _05562_ sky130_fd_sc_hd__o31ai_4
XANTENNA__09798__A0 bus3_2\[8\] vssd1 vssd1 vccd1 vccd1 sky130_fd_sc_hd__diode_2
XFILLER_80_98 vssd1 vssd1 vccd1 vccd1 sky130_fd_sc_hd__fill_1
X_13323_ clknet_leaf_87_clk _00295_ net690 vssd1 vssd1 vccd1 vccd1 cell1.CB_0.config_dataB\[14\]
+ sky130_fd_sc_hd__dfstp_1
X_11584_ net542 cell0.CB_1.config_dataA\[4\] net788 vssd1 vssd1 vccd1 vccd1 _00025_
+ sky130_fd_sc_hd__mux2_1
XFILLER_127_125 vssd1 vssd1 vccd1 vccd1 sky130_fd_sc_hd__fill_1
X_10535_ cell3.CB_1.config_dataA\[8\] cell3.CB_1.config_dataA\[7\] vssd1 vssd1 vccd1
+ vccd1 _05493_ sky130_fd_sc_hd__or2_1
XFILLER_10_473 vssd1 vssd1 vccd1 vccd1 sky130_fd_sc_hd__fill_2
XFILLER_142_117 vssd1 vssd1 vccd1 vccd1 sky130_fd_sc_hd__fill_1
XFILLER_127_169 vssd1 vssd1 vccd1 vccd1 sky130_fd_sc_hd__fill_1
X_10466_ _01741_ cell3.SB0.route_sel\[106\] vssd1 vssd1 vccd1 vccd1 _05451_ sky130_fd_sc_hd__nand2_1
XTAP_TAPCELL_ROW_94_1721 vssd1 vccd1 sky130_fd_sc_hd__tapvpwrvgnd_1
XANTENNA__09014__A2 _03841_ vssd1 vssd1 vccd1 vccd1 sky130_fd_sc_hd__diode_2
X_13254_ clknet_leaf_9_clk _00226_ net570 vssd1 vssd1 vccd1 vccd1 cell0.LEI0.config_data\[39\]
+ sky130_fd_sc_hd__dfrtp_1
XANTENNA_output175_A net175 vssd1 vssd1 vccd1 vccd1 sky130_fd_sc_hd__diode_2
X_12205_ cell2.CB_1.config_dataA\[18\] cell2.CB_1.config_dataA\[17\] net835 vssd1
+ vssd1 vccd1 vccd1 _00638_ sky130_fd_sc_hd__mux2_1
X_13185_ clknet_leaf_13_clk net1269 net590 vssd1 vssd1 vccd1 vccd1 cell0.LE_0B.config_data\[14\]
+ sky130_fd_sc_hd__dfrtp_1
X_10397_ net424 _05131_ net423 vssd1 vssd1 vccd1 vccd1 _05396_ sky130_fd_sc_hd__o21ai_1
XFILLER_97_727 vssd1 vssd1 vccd1 vccd1 sky130_fd_sc_hd__fill_1
X_12136_ cell1.LEI0.config_data\[18\] net1064 net896 vssd1 vssd1 vccd1 vccd1 _00569_
+ sky130_fd_sc_hd__mux2_1
XFILLER_96_226 vssd1 vssd1 vccd1 vccd1 sky130_fd_sc_hd__fill_1
XFILLER_111_559 vssd1 vssd1 vccd1 vccd1 sky130_fd_sc_hd__fill_1
XFILLER_96_259 vssd1 vssd1 vccd1 vccd1 sky130_fd_sc_hd__fill_4
X_12067_ net1535 cell1.LE_1A.edge_mode net903 vssd1 vssd1 vccd1 vccd1 _00503_ sky130_fd_sc_hd__mux2_1
XFILLER_1_193 vccd1 vssd1 vccd1 vssd1 sky130_ef_sc_hd__decap_40_12
X_11018_ cell3.CB_0.config_dataA\[11\] _05971_ vssd1 vssd1 vccd1 vccd1 _05972_ sky130_fd_sc_hd__and2_1
XANTENNA__08525__B2 _03537_ vssd1 vssd1 vccd1 vccd1 sky130_fd_sc_hd__diode_2
XANTENNA__08525__A1 _03540_ vssd1 vssd1 vccd1 vccd1 sky130_fd_sc_hd__diode_2
XANTENNA__11555__B net268 vssd1 vssd1 vccd1 vccd1 sky130_fd_sc_hd__diode_2
XFILLER_64_112 vssd1 vssd1 vccd1 vccd1 sky130_fd_sc_hd__fill_1
XTAP_TAPCELL_ROW_121_2117 vssd1 vccd1 sky130_fd_sc_hd__tapvpwrvgnd_1
X_12969_ net1130 cell3.LE_0A.config_data\[11\] net928 vssd1 vssd1 vccd1 vccd1 _01397_
+ sky130_fd_sc_hd__mux2_1
XTAP_TAPCELL_ROW_121_2128 vssd1 vccd1 sky130_fd_sc_hd__tapvpwrvgnd_1
XANTENNA__06839__A1 net303 vssd1 vssd1 vccd1 vccd1 sky130_fd_sc_hd__diode_2
XFILLER_60_340 vssd1 vssd1 vccd1 vccd1 sky130_fd_sc_hd__fill_1
X_06490_ cell0.CB_0.config_dataB\[18\] vssd1 vssd1 vccd1 vccd1 _01560_ sky130_fd_sc_hd__inv_2
XTAP_TAPCELL_ROW_103_1850 vssd1 vccd1 sky130_fd_sc_hd__tapvpwrvgnd_1
Xclkbuf_1_0__f_cell2.LE_1A.sel_clk clknet_0_cell2.LE_1A.sel_clk vssd1 vssd1 vccd1
+ vccd1 clknet_1_0__leaf_cell2.LE_1A.sel_clk sky130_fd_sc_hd__clkbuf_16
XANTENNA__09789__A0 bus3_2\[12\] vssd1 vssd1 vccd1 vccd1 sky130_fd_sc_hd__diode_2
X_08160_ net543 _01877_ _03199_ cell0.CB_1.config_dataA\[6\] vssd1 vssd1 vccd1 vccd1
+ _03200_ sky130_fd_sc_hd__o211a_1
X_07111_ cell2.SB0.route_sel\[77\] cell2.SB0.route_sel\[76\] _02129_ _02173_ _02124_
+ vssd1 vssd1 vccd1 vccd1 _02174_ sky130_fd_sc_hd__a221o_1
XANTENNA__08056__A3 bus2_0\[15\] vssd1 vssd1 vccd1 vccd1 sky130_fd_sc_hd__diode_2
XANTENNA__07199__C net357 vssd1 vssd1 vccd1 vccd1 sky130_fd_sc_hd__diode_2
XTAP_TAPCELL_ROW_31_766 vssd1 vccd1 sky130_fd_sc_hd__tapvpwrvgnd_1
XTAP_TAPCELL_ROW_31_777 vssd1 vccd1 sky130_fd_sc_hd__tapvpwrvgnd_1
XANTENNA__10474__X bus3_2\[15\] vssd1 vssd1 vccd1 vccd1 sky130_fd_sc_hd__diode_2
X_08091_ bus2_0\[6\] bus2_0\[7\] net525 vssd1 vssd1 vccd1 vccd1 _03133_ sky130_fd_sc_hd__mux2_1
Xclkload52 clknet_leaf_29_clk vssd1 vssd1 vccd1 vccd1 clkload52/Y sky130_fd_sc_hd__clkinv_4
X_07042_ cell2.SB0.route_sel\[65\] cell2.SB0.route_sel\[64\] vssd1 vssd1 vccd1 vccd1
+ _02107_ sky130_fd_sc_hd__nand2b_1
Xclkload41 clknet_leaf_121_clk vssd1 vssd1 vccd1 vccd1 clkload41/Y sky130_fd_sc_hd__inv_12
Xclkload30 clknet_leaf_124_clk vssd1 vssd1 vccd1 vccd1 clkload30/Y sky130_fd_sc_hd__inv_8
Xclkload63 clknet_leaf_34_clk vssd1 vssd1 vccd1 vccd1 clkload63/Y sky130_fd_sc_hd__inv_6
Xclkload96 clknet_leaf_90_clk vssd1 vssd1 vccd1 vccd1 clkload96/Y sky130_fd_sc_hd__bufinv_16
Xclkload85 clknet_leaf_96_clk vssd1 vssd1 vccd1 vccd1 clkload85/Y sky130_fd_sc_hd__inv_6
Xclkload74 clknet_leaf_109_clk vssd1 vssd1 vccd1 vccd1 clkload74/Y sky130_fd_sc_hd__clkinv_4
XANTENNA__08764__A1 net327 vssd1 vssd1 vccd1 vccd1 sky130_fd_sc_hd__diode_2
XFILLER_125_39 vccd1 vssd1 vccd1 vssd1 sky130_ef_sc_hd__decap_40_12
X_08993_ net482 _03862_ vssd1 vssd1 vccd1 vccd1 _04023_ sky130_fd_sc_hd__nand2_1
XANTENNA_clkbuf_4_1_0_clk_A clknet_0_clk vssd1 vssd1 vccd1 vccd1 sky130_fd_sc_hd__diode_2
X_07944_ cell0.CB_0.config_dataA\[18\] cell0.CB_0.config_dataA\[17\] _02986_ _02987_
+ vssd1 vssd1 vccd1 vccd1 _02988_ sky130_fd_sc_hd__o22a_1
XANTENNA__11115__A3 net43 vssd1 vssd1 vccd1 vccd1 sky130_fd_sc_hd__diode_2
XANTENNA__09713__B1 _02595_ vssd1 vssd1 vccd1 vccd1 sky130_fd_sc_hd__diode_2
XANTENNA__09216__A net105 vssd1 vssd1 vccd1 vccd1 sky130_fd_sc_hd__diode_2
X_07875_ net522 _01913_ _02918_ cell0.CB_0.config_dataA\[1\] vssd1 vssd1 vccd1 vccd1
+ _02919_ sky130_fd_sc_hd__o211a_1
XANTENNA__08516__A1 net12 vssd1 vssd1 vccd1 vccd1 sky130_fd_sc_hd__diode_2
XFILLER_18_26 vssd1 vssd1 vccd1 vccd1 sky130_fd_sc_hd__fill_2
XFILLER_141_27 vccd1 vssd1 vccd1 vssd1 sky130_ef_sc_hd__decap_40_12
XANTENNA__10323__B2 net60 vssd1 vssd1 vccd1 vccd1 sky130_fd_sc_hd__diode_2
XANTENNA__10323__A1 net59 vssd1 vssd1 vccd1 vccd1 sky130_fd_sc_hd__diode_2
XFILLER_95_270 vssd1 vssd1 vccd1 vccd1 sky130_fd_sc_hd__fill_2
X_09614_ _04617_ _04623_ _04630_ vssd1 vssd1 vccd1 vccd1 _04631_ sky130_fd_sc_hd__a21oi_1
X_06826_ cell1.SB0.route_sel\[48\] cell1.SB0.route_sel\[49\] _01895_ vssd1 vssd1 vccd1
+ vccd1 _01896_ sky130_fd_sc_hd__a21oi_1
XANTENNA__09503__X bus3_1\[7\] vssd1 vssd1 vccd1 vccd1 sky130_fd_sc_hd__diode_2
XANTENNA__06846__Y _01915_ vssd1 vssd1 vccd1 vccd1 sky130_fd_sc_hd__diode_2
X_09545_ cell3.SB0.route_sel\[72\] cell3.SB0.route_sel\[73\] vssd1 vssd1 vccd1 vccd1
+ _04564_ sky130_fd_sc_hd__nand2_1
X_06757_ net344 vssd1 vssd1 vccd1 vccd1 _01827_ sky130_fd_sc_hd__inv_2
XTAP_TAPCELL_ROW_39_899 vssd1 vccd1 sky130_fd_sc_hd__tapvpwrvgnd_1
XTAP_TAPCELL_ROW_39_888 vssd1 vccd1 sky130_fd_sc_hd__tapvpwrvgnd_1
Xclkbuf_leaf_129_clk clknet_4_2_0_clk vssd1 vssd1 vccd1 vccd1 clknet_leaf_129_clk
+ sky130_fd_sc_hd__clkbuf_8
XANTENNA_fanout638_A net640 vssd1 vssd1 vccd1 vccd1 sky130_fd_sc_hd__diode_2
X_06688_ cell2.CB_0.config_dataB\[9\] vssd1 vssd1 vccd1 vccd1 _01758_ sky130_fd_sc_hd__inv_2
XANTENNA__09222__Y _04249_ vssd1 vssd1 vccd1 vccd1 sky130_fd_sc_hd__diode_2
X_09476_ _04496_ vssd1 vssd1 vccd1 vccd1 _04497_ sky130_fd_sc_hd__inv_2
XFILLER_70_159 vssd1 vssd1 vccd1 vccd1 sky130_fd_sc_hd__fill_1
XANTENNA__08266__S _03231_ vssd1 vssd1 vccd1 vccd1 sky130_fd_sc_hd__diode_2
XTAP_TAPCELL_ROW_19_590 vssd1 vccd1 sky130_fd_sc_hd__tapvpwrvgnd_1
XFILLER_24_554 vssd1 vssd1 vccd1 vccd1 sky130_fd_sc_hd__fill_1
XANTENNA__09492__A2 _04512_ vssd1 vssd1 vccd1 vccd1 sky130_fd_sc_hd__diode_2
XTAP_TAPCELL_ROW_61_1219 vssd1 vccd1 sky130_fd_sc_hd__tapvpwrvgnd_1
X_08427_ cell1.SB0.route_sel\[80\] cell1.SB0.route_sel\[81\] vssd1 vssd1 vccd1 vccd1
+ _03463_ sky130_fd_sc_hd__nand2b_1
XANTENNA_fanout805_A net806 vssd1 vssd1 vccd1 vccd1 sky130_fd_sc_hd__diode_2
XFILLER_51_395 vssd1 vssd1 vccd1 vccd1 sky130_fd_sc_hd__fill_1
XFILLER_11_215 vssd1 vssd1 vccd1 vccd1 sky130_fd_sc_hd__fill_1
XANTENNA__13939__RESET_B net635 vssd1 vssd1 vccd1 vccd1 sky130_fd_sc_hd__diode_2
XANTENNA__06862__X bus2_0\[6\] vssd1 vssd1 vccd1 vccd1 sky130_fd_sc_hd__diode_2
XFILLER_7_219 vssd1 vssd1 vccd1 vccd1 sky130_fd_sc_hd__fill_4
XFILLER_7_208 vssd1 vssd1 vccd1 vccd1 sky130_fd_sc_hd__fill_2
X_08358_ _03385_ _03387_ _03395_ vssd1 vssd1 vccd1 vccd1 _03396_ sky130_fd_sc_hd__a21oi_1
Xclkload2 clknet_4_2_0_clk vssd1 vssd1 vccd1 vccd1 clkload2/Y sky130_fd_sc_hd__inv_8
X_07309_ cell1.CB_0.config_dataB\[23\] cell1.CB_0.config_dataB\[22\] vssd1 vssd1 vccd1
+ vccd1 _02367_ sky130_fd_sc_hd__nand2_1
XANTENNA__08452__B1 cell1.SB0.config_data_out vssd1 vssd1 vccd1 vccd1 sky130_fd_sc_hd__diode_2
X_08289_ _01491_ _03314_ _03318_ _03326_ vssd1 vssd1 vccd1 vccd1 _03327_ sky130_fd_sc_hd__a31o_1
XFILLER_20_793 vssd1 vssd1 vccd1 vccd1 sky130_fd_sc_hd__fill_1
X_10320_ _05318_ _05317_ _05315_ _05314_ vssd1 vssd1 vccd1 vccd1 _05319_ sky130_fd_sc_hd__a2bb2o_1
XFILLER_124_106 vssd1 vssd1 vccd1 vccd1 sky130_fd_sc_hd__fill_1
XFILLER_109_169 vssd1 vssd1 vccd1 vccd1 sky130_fd_sc_hd__fill_1
XFILLER_50_68 vssd1 vssd1 vccd1 vccd1 sky130_fd_sc_hd__fill_1
X_10251_ net319 _05113_ _05236_ _01773_ vssd1 vssd1 vccd1 vccd1 _05252_ sky130_fd_sc_hd__a31o_1
XTAP_TAPCELL_ROW_76_1451 vssd1 vccd1 sky130_fd_sc_hd__tapvpwrvgnd_1
XFILLER_79_705 vssd1 vssd1 vccd1 vccd1 sky130_fd_sc_hd__fill_2
XFILLER_3_447 vssd1 vssd1 vccd1 vccd1 sky130_fd_sc_hd__fill_1
XANTENNA__08755__A1 net27 vssd1 vssd1 vccd1 vccd1 sky130_fd_sc_hd__diode_2
XFILLER_132_172 vssd1 vssd1 vccd1 vccd1 sky130_fd_sc_hd__fill_1
X_10182_ net421 _05107_ _05182_ net420 vssd1 vssd1 vccd1 vccd1 _05183_ sky130_fd_sc_hd__o211a_1
XANTENNA__08755__B2 net28 vssd1 vssd1 vccd1 vccd1 sky130_fd_sc_hd__diode_2
XANTENNA__07853__B _02896_ vssd1 vssd1 vccd1 vccd1 sky130_fd_sc_hd__diode_2
X_13941_ clknet_1_1__leaf_cell2.LE_0B.sel_clk _00913_ net752 vssd1 vssd1 vccd1 vccd1
+ cell2.LE_0B.dff1_out sky130_fd_sc_hd__dfstp_1
Xfanout283 net284 vssd1 vssd1 vccd1 vccd1 net283 sky130_fd_sc_hd__dlymetal6s2s_1
Xfanout272 _04740_ vssd1 vssd1 vccd1 vccd1 net272 sky130_fd_sc_hd__clkbuf_4
XFILLER_93_218 vssd1 vssd1 vccd1 vccd1 sky130_fd_sc_hd__fill_4
Xfanout294 net296 vssd1 vssd1 vccd1 vccd1 net294 sky130_fd_sc_hd__buf_1
X_13872_ clknet_leaf_17_clk _00844_ net625 vssd1 vssd1 vccd1 vccd1 cell2.CB_1.config_dataB\[21\]
+ sky130_fd_sc_hd__dfstp_2
XANTENNA__07191__B1 _02251_ vssd1 vssd1 vccd1 vccd1 sky130_fd_sc_hd__diode_2
X_12823_ cell2.SB0.route_sel\[65\] cell2.SB0.route_sel\[64\] net815 vssd1 vssd1 vccd1
+ vccd1 _01252_ sky130_fd_sc_hd__mux2_1
XFILLER_15_521 vssd1 vssd1 vccd1 vccd1 sky130_fd_sc_hd__fill_1
XPHY_EDGE_ROW_141_Right_141 vssd1 vssd1 vccd1 vccd1 sky130_fd_sc_hd__decap_3
X_12754_ cell3.CB_0.config_dataA\[21\] cell3.CB_0.config_dataA\[20\] net930 vssd1
+ vssd1 vccd1 vccd1 _01183_ sky130_fd_sc_hd__mux2_1
XFILLER_43_841 vssd1 vssd1 vccd1 vccd1 sky130_fd_sc_hd__fill_1
XANTENNA__08684__B _03529_ vssd1 vssd1 vccd1 vccd1 sky130_fd_sc_hd__diode_2
XFILLER_98_9 vccd1 vssd1 vccd1 vssd1 sky130_ef_sc_hd__decap_40_12
XFILLER_91_53 vssd1 vssd1 vccd1 vccd1 sky130_fd_sc_hd__fill_1
X_11705_ net1208 cell0.LE_0B.config_data\[0\] net803 vssd1 vssd1 vccd1 vccd1 _00144_
+ sky130_fd_sc_hd__mux2_1
X_12685_ cell3.CB_1.config_dataA\[2\] net396 net937 vssd1 vssd1 vccd1 vccd1 _01114_
+ sky130_fd_sc_hd__mux2_1
XANTENNA_input91_X net91 vssd1 vssd1 vccd1 vccd1 sky130_fd_sc_hd__diode_2
X_14424_ clknet_leaf_55_clk _01396_ net718 vssd1 vssd1 vccd1 vccd1 cell3.LE_0A.config_data\[11\]
+ sky130_fd_sc_hd__dfrtp_1
X_11636_ cell0.CB_0.config_dataA\[7\] net517 net771 vssd1 vssd1 vccd1 vccd1 _00077_
+ sky130_fd_sc_hd__mux2_1
XFILLER_24_80 vssd1 vssd1 vccd1 vccd1 sky130_fd_sc_hd__fill_4
XANTENNA__11042__A2 _05847_ vssd1 vssd1 vccd1 vccd1 sky130_fd_sc_hd__diode_2
X_14355_ clknet_leaf_70_clk _01327_ net730 vssd1 vssd1 vccd1 vccd1 cell3.CB_1.config_dataB\[12\]
+ sky130_fd_sc_hd__dfstp_2
X_11567_ net1256 cell0.LE_1B.config_data\[7\] net802 vssd1 vssd1 vccd1 vccd1 _00008_
+ sky130_fd_sc_hd__mux2_1
XANTENNA__08443__B1 _03477_ vssd1 vssd1 vccd1 vccd1 sky130_fd_sc_hd__diode_2
X_10518_ _01711_ cell3.SB0.route_sel\[54\] vssd1 vssd1 vccd1 vccd1 _05476_ sky130_fd_sc_hd__nand2_1
X_14286_ clknet_leaf_21_clk _01258_ net610 vssd1 vssd1 vccd1 vccd1 cell2.SB0.route_sel\[71\]
+ sky130_fd_sc_hd__dfstp_1
X_13306_ clknet_leaf_102_clk _00278_ net676 vssd1 vssd1 vccd1 vccd1 cell1.CB_1.config_dataA\[22\]
+ sky130_fd_sc_hd__dfstp_1
X_11498_ _06332_ _04345_ vssd1 vssd1 vccd1 vccd1 net240 sky130_fd_sc_hd__and2b_1
X_13237_ clknet_leaf_122_clk _00209_ net586 vssd1 vssd1 vccd1 vccd1 cell0.LEI0.config_data\[22\]
+ sky130_fd_sc_hd__dfrtp_1
XFILLER_6_274 vssd1 vssd1 vccd1 vccd1 sky130_fd_sc_hd__fill_4
X_10449_ cell3.SB0.route_sel\[56\] cell3.SB0.route_sel\[57\] cell3.SB0.route_sel\[60\]
+ _01716_ _05439_ vssd1 vssd1 vccd1 vccd1 _05440_ sky130_fd_sc_hd__o221a_1
XANTENNA__08746__A1 _02444_ vssd1 vssd1 vccd1 vccd1 sky130_fd_sc_hd__diode_2
X_13168_ clknet_leaf_119_clk _00140_ net598 vssd1 vssd1 vccd1 vccd1 cell0.LE_1A.reset_mode
+ sky130_fd_sc_hd__dfrtp_1
XANTENNA_clkbuf_leaf_41_clk_A clknet_4_7_0_clk vssd1 vssd1 vccd1 vccd1 sky130_fd_sc_hd__diode_2
X_12119_ net1460 cell1.LEI0.config_data\[0\] net904 vssd1 vssd1 vccd1 vccd1 _00552_
+ sky130_fd_sc_hd__mux2_1
X_13099_ clknet_leaf_4_clk _00071_ net564 vssd1 vssd1 vccd1 vccd1 cell0.CB_0.config_dataA\[1\]
+ sky130_fd_sc_hd__dfstp_1
XANTENNA__07108__X _02171_ vssd1 vssd1 vccd1 vccd1 sky130_fd_sc_hd__diode_2
XFILLER_27_3 vccd1 vssd1 vccd1 vssd1 sky130_ef_sc_hd__decap_40_12
XFILLER_77_292 vssd1 vssd1 vccd1 vccd1 sky130_fd_sc_hd__fill_8
XFILLER_77_281 vssd1 vssd1 vccd1 vccd1 sky130_fd_sc_hd__fill_2
XANTENNA_clkbuf_leaf_56_clk_A clknet_4_13_0_clk vssd1 vssd1 vccd1 vccd1 sky130_fd_sc_hd__diode_2
XFILLER_1_51 vssd1 vssd1 vccd1 vccd1 sky130_fd_sc_hd__fill_4
X_07660_ net87 _02706_ _02707_ _02705_ vssd1 vssd1 vccd1 vccd1 _02708_ sky130_fd_sc_hd__a211o_1
XFILLER_80_402 vssd1 vssd1 vccd1 vccd1 sky130_fd_sc_hd__fill_4
X_06611_ cell1.CB_0.config_dataA\[12\] vssd1 vssd1 vccd1 vccd1 _01681_ sky130_fd_sc_hd__inv_2
X_07591_ _02050_ _02640_ vssd1 vssd1 vccd1 vccd1 _02641_ sky130_fd_sc_hd__nor2_1
XFILLER_37_167 vssd1 vssd1 vccd1 vccd1 sky130_fd_sc_hd__fill_1
X_06542_ cell2.SB0.route_sel\[51\] vssd1 vssd1 vccd1 vccd1 _01612_ sky130_fd_sc_hd__inv_2
X_09330_ cell3.SB0.route_sel\[24\] cell3.SB0.route_sel\[25\] vssd1 vssd1 vccd1 vccd1
+ _04355_ sky130_fd_sc_hd__nand2_2
XTAP_TAPCELL_ROW_36_847 vssd1 vccd1 sky130_fd_sc_hd__tapvpwrvgnd_1
X_09261_ _02710_ _04285_ _04286_ _02711_ vssd1 vssd1 vccd1 vccd1 _04287_ sky130_fd_sc_hd__o211ai_2
X_08212_ _02846_ _03233_ _03234_ _02807_ _03251_ vssd1 vssd1 vccd1 vccd1 _03252_ sky130_fd_sc_hd__a221o_1
X_06473_ cell1.SB0.route_sel\[102\] vssd1 vssd1 vccd1 vccd1 _01543_ sky130_fd_sc_hd__inv_2
X_09192_ _04218_ _04219_ vssd1 vssd1 vccd1 vccd1 _04220_ sky130_fd_sc_hd__nor2_1
XANTENNA_clkbuf_leaf_114_clk_A clknet_4_9_0_clk vssd1 vssd1 vccd1 vccd1 sky130_fd_sc_hd__diode_2
XTAP_TAPCELL_ROW_134_2319 vssd1 vccd1 sky130_fd_sc_hd__tapvpwrvgnd_1
X_08143_ _03181_ _03182_ cell0.CB_1.config_dataA\[2\] vssd1 vssd1 vccd1 vccd1 _03183_
+ sky130_fd_sc_hd__or3b_1
Xclkload130 clknet_leaf_65_clk vssd1 vssd1 vccd1 vccd1 clkload130/Y sky130_fd_sc_hd__clkinv_8
X_08074_ cell0.CB_0.config_dataB\[14\] _03101_ _03115_ vssd1 vssd1 vccd1 vccd1 _03116_
+ sky130_fd_sc_hd__nand3b_1
XFILLER_106_139 vssd1 vssd1 vccd1 vccd1 sky130_fd_sc_hd__fill_1
X_07025_ net301 _02085_ vssd1 vssd1 vccd1 vccd1 _02090_ sky130_fd_sc_hd__nor2_1
Xclkload141 clknet_1_1__leaf_cell1.LE_0A.sel_clk vssd1 vssd1 vccd1 vccd1 clkload141/X
+ sky130_fd_sc_hd__clkbuf_4
XFILLER_136_27 vssd1 vssd1 vccd1 vccd1 sky130_fd_sc_hd__fill_1
XANTENNA_clkbuf_leaf_129_clk_A clknet_4_2_0_clk vssd1 vssd1 vccd1 vccd1 sky130_fd_sc_hd__diode_2
XFILLER_115_673 vssd1 vssd1 vccd1 vccd1 sky130_fd_sc_hd__fill_1
XTAP_TAPCELL_ROW_58_1181 vssd1 vccd1 sky130_fd_sc_hd__tapvpwrvgnd_1
Xhold14 cell2.LE_1B.dff0_out vssd1 vssd1 vccd1 vccd1 net973 sky130_fd_sc_hd__dlygate4sd3_1
Xhold25 cell2.LE_1A.config_data\[2\] vssd1 vssd1 vccd1 vccd1 net984 sky130_fd_sc_hd__dlygate4sd3_1
XTAP_TAPCELL_ROW_71_1370 vssd1 vccd1 sky130_fd_sc_hd__tapvpwrvgnd_1
X_08976_ cell1.LE_0A.config_data\[1\] cell1.LE_0A.config_data\[0\] _03936_ vssd1 vssd1
+ vccd1 vccd1 _04008_ sky130_fd_sc_hd__mux2_1
XANTENNA__07960__A2 bus2_0\[10\] vssd1 vssd1 vccd1 vccd1 sky130_fd_sc_hd__diode_2
Xhold47 _00497_ vssd1 vssd1 vccd1 vccd1 net1006 sky130_fd_sc_hd__dlygate4sd3_1
Xhold36 cell1.LE_1A.config_data\[5\] vssd1 vssd1 vccd1 vccd1 net995 sky130_fd_sc_hd__dlygate4sd3_1
Xhold58 cell3.LE_0B.config_data\[5\] vssd1 vssd1 vccd1 vccd1 net1017 sky130_fd_sc_hd__dlygate4sd3_1
X_07927_ _02966_ _02967_ _02969_ _02970_ vssd1 vssd1 vccd1 vccd1 _02971_ sky130_fd_sc_hd__o22a_1
XANTENNA_fanout755_A net756 vssd1 vssd1 vccd1 vccd1 sky130_fd_sc_hd__diode_2
Xhold69 _00240_ vssd1 vssd1 vccd1 vccd1 net1028 sky130_fd_sc_hd__dlygate4sd3_1
XANTENNA__06857__X _01926_ vssd1 vssd1 vccd1 vccd1 sky130_fd_sc_hd__diode_2
X_07858_ _02630_ _02901_ vssd1 vssd1 vccd1 vccd1 _02902_ sky130_fd_sc_hd__nor2_4
X_07789_ net343 _01863_ _02121_ vssd1 vssd1 vccd1 vccd1 _02834_ sky130_fd_sc_hd__or3_2
XFILLER_56_498 vssd1 vssd1 vccd1 vccd1 sky130_fd_sc_hd__fill_1
XFILLER_16_307 vssd1 vssd1 vccd1 vccd1 sky130_fd_sc_hd__fill_1
XFILLER_16_318 vssd1 vssd1 vccd1 vccd1 sky130_fd_sc_hd__fill_1
X_06809_ cell1.SB0.route_sel\[53\] cell1.SB0.route_sel\[52\] vssd1 vssd1 vccd1 vccd1
+ _01879_ sky130_fd_sc_hd__nand2_1
X_09528_ _04547_ net281 _04546_ vssd1 vssd1 vccd1 vccd1 _04548_ sky130_fd_sc_hd__mux2_1
XFILLER_45_57 vssd1 vssd1 vccd1 vccd1 sky130_fd_sc_hd__fill_1
XFILLER_43_137 vssd1 vssd1 vccd1 vccd1 sky130_fd_sc_hd__fill_1
XFILLER_12_502 vssd1 vssd1 vccd1 vccd1 sky130_fd_sc_hd__fill_1
XTAP_TAPCELL_ROW_14_519 vssd1 vccd1 sky130_fd_sc_hd__tapvpwrvgnd_1
X_09459_ net15 _04479_ _04480_ vssd1 vssd1 vccd1 vccd1 _04481_ sky130_fd_sc_hd__o21ba_1
XFILLER_12_524 vssd1 vssd1 vccd1 vccd1 sky130_fd_sc_hd__fill_4
XFILLER_131_3 vccd1 vssd1 vccd1 vssd1 sky130_ef_sc_hd__decap_40_12
X_12470_ net1179 cell2.LE_0A.config_data\[6\] net814 vssd1 vssd1 vccd1 vccd1 _00900_
+ sky130_fd_sc_hd__mux2_1
XANTENNA__14085__SET_B net675 vssd1 vssd1 vccd1 vccd1 sky130_fd_sc_hd__diode_2
X_11421_ cell0.SB0.route_sel\[104\] _01479_ vssd1 vssd1 vccd1 vccd1 _06281_ sky130_fd_sc_hd__nand2_1
X_14140_ clknet_leaf_77_clk _01112_ net726 vssd1 vssd1 vccd1 vccd1 cell3.CB_1.config_dataA\[0\]
+ sky130_fd_sc_hd__dfstp_1
X_11352_ _04657_ _04658_ _06241_ _04660_ vssd1 vssd1 vccd1 vccd1 net186 sky130_fd_sc_hd__a31o_1
XFILLER_6_29 vccd1 vssd1 vccd1 vssd1 sky130_ef_sc_hd__decap_40_12
XFILLER_4_701 vccd1 vssd1 vccd1 vssd1 sky130_ef_sc_hd__decap_40_12
XANTENNA__07779__A2 net360 vssd1 vssd1 vccd1 vccd1 sky130_fd_sc_hd__diode_2
X_10303_ _05097_ _05281_ _05282_ _05093_ vssd1 vssd1 vccd1 vccd1 _05302_ sky130_fd_sc_hd__a2bb2o_1
X_11283_ _02001_ _02394_ _05103_ vssd1 vssd1 vccd1 vccd1 _06210_ sky130_fd_sc_hd__o21ai_1
X_14071_ clknet_leaf_14_clk _01043_ net629 vssd1 vssd1 vccd1 vccd1 cell3.SB0.route_sel\[79\]
+ sky130_fd_sc_hd__dfstp_1
XANTENNA_hold588_X net1547 vssd1 vssd1 vccd1 vccd1 sky130_fd_sc_hd__diode_2
XANTENNA_input51_A CBnorth_in[26] vssd1 vssd1 vccd1 vccd1 sky130_fd_sc_hd__diode_2
X_13022_ net1189 net1381 net948 vssd1 vssd1 vccd1 vccd1 _01450_ sky130_fd_sc_hd__mux2_1
X_10234_ net411 net413 vssd1 vssd1 vccd1 vccd1 _05235_ sky130_fd_sc_hd__and2b_1
XFILLER_105_161 vssd1 vssd1 vccd1 vccd1 sky130_fd_sc_hd__fill_1
XFILLER_3_277 vssd1 vssd1 vccd1 vccd1 sky130_fd_sc_hd__fill_2
X_10165_ net421 _05131_ _05165_ net420 vssd1 vssd1 vccd1 vccd1 _05166_ sky130_fd_sc_hd__o211a_1
X_10096_ _02106_ _05096_ vssd1 vssd1 vccd1 vccd1 _05097_ sky130_fd_sc_hd__nand2_1
X_13924_ clknet_leaf_25_clk net1058 net608 vssd1 vssd1 vccd1 vccd1 cell2.LE_0A.config_data\[3\]
+ sky130_fd_sc_hd__dfrtp_1
XTAP_TAPCELL_ROW_89_1642 vssd1 vccd1 sky130_fd_sc_hd__tapvpwrvgnd_1
XANTENNA__07164__B1 bus3_1\[10\] vssd1 vssd1 vccd1 vccd1 sky130_fd_sc_hd__diode_2
XFILLER_47_443 vssd1 vssd1 vccd1 vccd1 sky130_fd_sc_hd__fill_4
X_13855_ clknet_leaf_44_clk _00827_ net632 vssd1 vssd1 vccd1 vccd1 cell2.CB_1.config_dataB\[4\]
+ sky130_fd_sc_hd__dfstp_1
XFILLER_74_273 vssd1 vssd1 vccd1 vccd1 sky130_fd_sc_hd__fill_1
X_12806_ cell2.SB0.route_sel\[48\] cell2.SB0.route_sel\[47\] net812 vssd1 vssd1 vccd1
+ vccd1 _01235_ sky130_fd_sc_hd__mux2_1
X_10998_ net45 _05933_ _05935_ net46 cell3.CB_0.config_dataA\[8\] vssd1 vssd1 vccd1
+ vccd1 _05952_ sky130_fd_sc_hd__a221o_1
X_13786_ clknet_leaf_109_clk _00758_ net651 vssd1 vssd1 vccd1 vccd1 cell1.SB0.route_sel\[63\]
+ sky130_fd_sc_hd__dfstp_1
XANTENNA__11799__A0 net1347 vssd1 vssd1 vccd1 vccd1 sky130_fd_sc_hd__diode_2
XTAP_TAPCELL_ROW_33_806 vssd1 vccd1 sky130_fd_sc_hd__tapvpwrvgnd_1
X_12737_ cell3.CB_0.config_dataA\[4\] cell3.CB_0.config_dataA\[3\] net925 vssd1 vssd1
+ vccd1 vccd1 _01166_ sky130_fd_sc_hd__mux2_1
X_12668_ net1202 cell3.LE_1B.config_data\[4\] net958 vssd1 vssd1 vccd1 vccd1 _01097_
+ sky130_fd_sc_hd__mux2_1
XANTENNA__10562__A_N net262 vssd1 vssd1 vccd1 vccd1 sky130_fd_sc_hd__diode_2
X_14407_ clknet_leaf_61_clk _01379_ net739 vssd1 vssd1 vccd1 vccd1 cell3.LE_0B.config_data\[16\]
+ sky130_fd_sc_hd__dfrtp_1
XANTENNA__11015__A2 net56 vssd1 vssd1 vccd1 vccd1 sky130_fd_sc_hd__diode_2
X_11619_ cell0.CB_0.config_dataB\[15\] cell0.CB_0.config_dataB\[14\] net769 vssd1
+ vssd1 vccd1 vccd1 _00060_ sky130_fd_sc_hd__mux2_1
XFILLER_30_365 vssd1 vssd1 vccd1 vccd1 sky130_fd_sc_hd__fill_1
XTAP_TAPCELL_ROW_116_2049 vssd1 vccd1 sky130_fd_sc_hd__tapvpwrvgnd_1
X_12599_ cell3.SB0.route_sel\[64\] cell3.SB0.route_sel\[63\] net909 vssd1 vssd1 vccd1
+ vccd1 _01028_ sky130_fd_sc_hd__mux2_1
Xhold517 cell3.LEI0.config_data\[5\] vssd1 vssd1 vccd1 vccd1 net1476 sky130_fd_sc_hd__dlygate4sd3_1
XANTENNA__10774__A1 net18 vssd1 vssd1 vccd1 vccd1 sky130_fd_sc_hd__diode_2
X_14338_ clknet_leaf_18_clk _01310_ net627 vssd1 vssd1 vccd1 vccd1 cell2.SB0.route_sel\[123\]
+ sky130_fd_sc_hd__dfstp_1
XFILLER_7_594 vssd1 vssd1 vccd1 vccd1 sky130_fd_sc_hd__fill_1
XFILLER_7_561 vssd1 vssd1 vccd1 vccd1 sky130_fd_sc_hd__fill_4
Xhold506 _00220_ vssd1 vssd1 vccd1 vccd1 net1465 sky130_fd_sc_hd__dlygate4sd3_1
Xhold528 cell2.LE_1B.dff1_out vssd1 vssd1 vccd1 vccd1 net1487 sky130_fd_sc_hd__dlygate4sd3_1
X_14269_ clknet_leaf_24_clk _01241_ net606 vssd1 vssd1 vccd1 vccd1 cell2.SB0.route_sel\[54\]
+ sky130_fd_sc_hd__dfstp_1
Xmax_cap269 _04194_ vssd1 vssd1 vccd1 vccd1 net269 sky130_fd_sc_hd__clkbuf_2
Xhold539 cell0.LE_1A.config_data\[0\] vssd1 vssd1 vccd1 vccd1 net1498 sky130_fd_sc_hd__dlygate4sd3_1
XANTENNA__10471__Y bus3_2\[14\] vssd1 vssd1 vccd1 vccd1 sky130_fd_sc_hd__diode_2
XANTENNA__09377__D1 _04387_ vssd1 vssd1 vccd1 vccd1 sky130_fd_sc_hd__diode_2
XANTENNA__08719__B2 _03473_ vssd1 vssd1 vccd1 vccd1 sky130_fd_sc_hd__diode_2
XANTENNA__08719__A1 _03477_ vssd1 vssd1 vccd1 vccd1 sky130_fd_sc_hd__diode_2
X_08830_ _02780_ _03861_ vssd1 vssd1 vccd1 vccd1 _03862_ sky130_fd_sc_hd__and2_2
XANTENNA__08195__A2 bus1_0\[14\] vssd1 vssd1 vccd1 vccd1 sky130_fd_sc_hd__diode_2
XTAP_TAPCELL_ROW_111_1971 vssd1 vccd1 sky130_fd_sc_hd__tapvpwrvgnd_1
X_08761_ _03784_ _03785_ _03793_ _03794_ vssd1 vssd1 vccd1 vccd1 _03795_ sky130_fd_sc_hd__o22a_1
XFILLER_122_29 vccd1 vssd1 vccd1 vssd1 sky130_ef_sc_hd__decap_40_12
X_07712_ cell0.SB0.route_sel\[28\] cell0.SB0.route_sel\[29\] vssd1 vssd1 vccd1 vccd1
+ _02759_ sky130_fd_sc_hd__nor2_1
X_08692_ _01654_ _03721_ _03722_ _03725_ vssd1 vssd1 vccd1 vccd1 _03726_ sky130_fd_sc_hd__o2bb2a_1
XFILLER_81_722 vssd1 vssd1 vccd1 vccd1 sky130_fd_sc_hd__fill_4
XFILLER_53_402 vssd1 vssd1 vccd1 vccd1 sky130_fd_sc_hd__fill_2
X_07643_ _02151_ _02646_ vssd1 vssd1 vccd1 vccd1 _02692_ sky130_fd_sc_hd__or2_1
XFILLER_38_498 vssd1 vssd1 vccd1 vccd1 sky130_fd_sc_hd__fill_1
XANTENNA__11235__S _06076_ vssd1 vssd1 vccd1 vccd1 sky130_fd_sc_hd__diode_2
X_09313_ net317 _04327_ _04329_ _04337_ _04334_ vssd1 vssd1 vccd1 vccd1 _04338_ sky130_fd_sc_hd__o221a_1
X_07574_ cell0.CB_0.config_dataB\[22\] cell0.CB_0.config_dataB\[23\] vssd1 vssd1 vccd1
+ vccd1 _02624_ sky130_fd_sc_hd__or2_2
XFILLER_15_27 vccd1 vssd1 vccd1 vssd1 sky130_ef_sc_hd__decap_40_12
XFILLER_25_159 vssd1 vssd1 vccd1 vccd1 sky130_fd_sc_hd__fill_1
XANTENNA__09998__A3 bus3_2\[11\] vssd1 vssd1 vccd1 vccd1 sky130_fd_sc_hd__diode_2
X_06525_ cell2.SB0.route_sel\[30\] vssd1 vssd1 vccd1 vccd1 _01595_ sky130_fd_sc_hd__inv_2
XANTENNA__08655__A0 net31 vssd1 vssd1 vccd1 vccd1 sky130_fd_sc_hd__diode_2
XANTENNA_fanout336_A net337 vssd1 vssd1 vccd1 vccd1 sky130_fd_sc_hd__diode_2
Xclkbuf_leaf_60_clk clknet_4_15_0_clk vssd1 vssd1 vccd1 vccd1 clknet_leaf_60_clk sky130_fd_sc_hd__clkbuf_8
X_09244_ _04270_ net282 _04268_ vssd1 vssd1 vccd1 vccd1 _04271_ sky130_fd_sc_hd__mux2_1
X_06456_ cell1.SB0.route_sel\[67\] vssd1 vssd1 vccd1 vccd1 _01526_ sky130_fd_sc_hd__inv_2
XANTENNA__14158__SET_B net733 vssd1 vssd1 vccd1 vccd1 sky130_fd_sc_hd__diode_2
X_09175_ cell3.SB0.route_sel\[4\] cell3.SB0.route_sel\[5\] _02652_ _04202_ _02648_
+ vssd1 vssd1 vccd1 vccd1 _04203_ sky130_fd_sc_hd__a221o_1
XFILLER_31_15 vccd1 vssd1 vccd1 vssd1 sky130_ef_sc_hd__decap_40_12
XANTENNA__08958__A1 bus3_1\[13\] vssd1 vssd1 vccd1 vccd1 sky130_fd_sc_hd__diode_2
X_08126_ net546 _02211_ _03165_ net544 vssd1 vssd1 vccd1 vccd1 _03166_ sky130_fd_sc_hd__o211a_1
X_06387_ cell0.SB0.route_sel\[53\] vssd1 vssd1 vccd1 vccd1 _01457_ sky130_fd_sc_hd__inv_2
XFILLER_107_437 vssd1 vssd1 vccd1 vccd1 sky130_fd_sc_hd__fill_1
XFILLER_135_779 vssd1 vssd1 vccd1 vccd1 sky130_fd_sc_hd__fill_4
X_08057_ bus2_0\[8\] bus2_0\[9\] bus2_0\[10\] bus2_0\[11\] net528 net526 vssd1 vssd1
+ vccd1 vccd1 _03099_ sky130_fd_sc_hd__mux4_1
XPHY_EDGE_ROW_1_Right_1 vssd1 vssd1 vccd1 vccd1 sky130_fd_sc_hd__decap_3
XANTENNA__09228__X _04255_ vssd1 vssd1 vccd1 vccd1 sky130_fd_sc_hd__diode_2
XTAP_TAPCELL_ROW_73_1410 vssd1 vccd1 sky130_fd_sc_hd__tapvpwrvgnd_1
XANTENNA__07684__A net330 vssd1 vssd1 vccd1 vccd1 sky130_fd_sc_hd__diode_2
XFILLER_1_726 vssd1 vssd1 vccd1 vccd1 sky130_fd_sc_hd__fill_2
X_07008_ cell0.SB0.route_sel\[69\] _01467_ cell0.SB0.route_sel\[67\] cell0.SB0.route_sel\[66\]
+ _02072_ vssd1 vssd1 vccd1 vccd1 _02073_ sky130_fd_sc_hd__o221a_2
XFILLER_88_321 vssd1 vssd1 vccd1 vccd1 sky130_fd_sc_hd__fill_1
XFILLER_0_225 vssd1 vssd1 vccd1 vccd1 sky130_fd_sc_hd__fill_1
Xinput115 SBwest_in[26] vssd1 vssd1 vccd1 vccd1 net115 sky130_fd_sc_hd__buf_1
Xinput104 SBwest_in[16] vssd1 vssd1 vccd1 vccd1 net104 sky130_fd_sc_hd__dlymetal6s2s_1
Xinput126 SBwest_in[7] vssd1 vssd1 vccd1 vccd1 net126 sky130_fd_sc_hd__buf_1
X_08959_ cell1.CB_0.config_dataA\[17\] _03990_ vssd1 vssd1 vccd1 vccd1 _03991_ sky130_fd_sc_hd__nand2_1
X_11970_ cell0.SB0.route_sel\[76\] cell0.SB0.route_sel\[75\] net766 vssd1 vssd1 vccd1
+ vccd1 _00407_ sky130_fd_sc_hd__mux2_1
X_10921_ net379 _05874_ vssd1 vssd1 vccd1 vccd1 _05875_ sky130_fd_sc_hd__nor2_1
XFILLER_84_571 vssd1 vssd1 vccd1 vccd1 sky130_fd_sc_hd__fill_4
XANTENNA__10296__A3 net39 vssd1 vssd1 vccd1 vccd1 sky130_fd_sc_hd__diode_2
XFILLER_71_232 vssd1 vssd1 vccd1 vccd1 sky130_fd_sc_hd__fill_2
X_13640_ clknet_leaf_38_clk _00612_ net648 vssd1 vssd1 vccd1 vccd1 cell2.LE_1B.config_data\[12\]
+ sky130_fd_sc_hd__dfrtp_1
X_10852_ _05804_ _05805_ _05806_ cell3.CB_1.config_dataB\[16\] _05807_ vssd1 vssd1
+ vccd1 vccd1 _05808_ sky130_fd_sc_hd__a221o_1
XTAP_TAPCELL_ROW_84_1561 vssd1 vccd1 sky130_fd_sc_hd__tapvpwrvgnd_1
X_10783_ net368 _05738_ vssd1 vssd1 vccd1 vccd1 _05739_ sky130_fd_sc_hd__nand2_1
XTAP_TAPCELL_ROW_84_1572 vssd1 vccd1 sky130_fd_sc_hd__tapvpwrvgnd_1
X_13571_ clknet_leaf_83_clk _00543_ net670 vssd1 vssd1 vccd1 vccd1 cell1.LE_0A.config_data\[14\]
+ sky130_fd_sc_hd__dfrtp_1
X_12522_ net1542 net1529 net839 vssd1 vssd1 vccd1 vccd1 _00951_ sky130_fd_sc_hd__mux2_1
Xclkbuf_leaf_51_clk clknet_4_13_0_clk vssd1 vssd1 vccd1 vccd1 clknet_leaf_51_clk sky130_fd_sc_hd__clkbuf_8
XANTENNA__08962__B _03820_ vssd1 vssd1 vccd1 vccd1 sky130_fd_sc_hd__diode_2
XANTENNA__12484__B _05276_ vssd1 vssd1 vccd1 vccd1 sky130_fd_sc_hd__diode_2
XANTENNA__06763__A net303 vssd1 vssd1 vccd1 vccd1 sky130_fd_sc_hd__diode_2
XANTENNA_input99_A SBwest_in[11] vssd1 vssd1 vccd1 vccd1 sky130_fd_sc_hd__diode_2
X_12453_ net1273 net1231 net842 vssd1 vssd1 vccd1 vccd1 _00884_ sky130_fd_sc_hd__mux2_1
XANTENNA__08949__A1 _03871_ vssd1 vssd1 vccd1 vccd1 sky130_fd_sc_hd__diode_2
XFILLER_12_398 vssd1 vssd1 vccd1 vccd1 sky130_fd_sc_hd__fill_1
XFILLER_126_735 vssd1 vssd1 vccd1 vccd1 sky130_fd_sc_hd__fill_1
XANTENNA__08949__B2 _03868_ vssd1 vssd1 vccd1 vccd1 sky130_fd_sc_hd__diode_2
X_12384_ cell1.SB0.route_sel\[122\] cell1.SB0.route_sel\[121\] net872 vssd1 vssd1
+ vccd1 vccd1 _00817_ sky130_fd_sc_hd__mux2_1
X_11404_ cell0.SB0.route_sel\[86\] cell0.SB0.route_sel\[87\] _01473_ cell0.SB0.route_sel\[82\]
+ _06269_ vssd1 vssd1 vccd1 vccd1 _06270_ sky130_fd_sc_hd__o221a_1
X_14123_ clknet_leaf_64_clk _01095_ net748 vssd1 vssd1 vccd1 vccd1 cell3.LE_1B.config_data\[3\]
+ sky130_fd_sc_hd__dfrtp_1
X_11335_ _05901_ net277 _04413_ vssd1 vssd1 vccd1 vccd1 _06233_ sky130_fd_sc_hd__mux2_1
XANTENNA__09793__B _04583_ vssd1 vssd1 vccd1 vccd1 sky130_fd_sc_hd__diode_2
XANTENNA__12704__S net940 vssd1 vssd1 vccd1 vccd1 sky130_fd_sc_hd__diode_2
XANTENNA_input54_X net54 vssd1 vssd1 vccd1 vccd1 sky130_fd_sc_hd__diode_2
XFILLER_137_81 vccd1 vssd1 vccd1 vssd1 sky130_ef_sc_hd__decap_40_12
X_11266_ _06200_ vssd1 vssd1 vccd1 vccd1 _06201_ sky130_fd_sc_hd__inv_2
X_14054_ clknet_leaf_45_clk _01026_ net629 vssd1 vssd1 vccd1 vccd1 cell3.SB0.route_sel\[62\]
+ sky130_fd_sc_hd__dfstp_1
X_13005_ net1443 net1457 net951 vssd1 vssd1 vccd1 vccd1 _01433_ sky130_fd_sc_hd__mux2_1
X_10217_ net415 net414 _05139_ _05217_ cell2.CB_0.config_dataA\[12\] vssd1 vssd1 vccd1
+ vccd1 _05218_ sky130_fd_sc_hd__o311a_1
XANTENNA_output255_A net255 vssd1 vssd1 vccd1 vccd1 sky130_fd_sc_hd__diode_2
XANTENNA__08177__A2 _02560_ vssd1 vssd1 vccd1 vccd1 sky130_fd_sc_hd__diode_2
XANTENNA__10508__A1 net335 vssd1 vssd1 vccd1 vccd1 sky130_fd_sc_hd__diode_2
XANTENNA__11181__B2 _05921_ vssd1 vssd1 vccd1 vccd1 sky130_fd_sc_hd__diode_2
X_11197_ net45 _06145_ _06147_ net46 cell3.CB_0.config_dataB\[18\] vssd1 vssd1 vccd1
+ vccd1 _06149_ sky130_fd_sc_hd__a221o_1
X_10148_ net418 _05148_ _05145_ net417 vssd1 vssd1 vccd1 vccd1 _05149_ sky130_fd_sc_hd__o211a_1
XFILLER_0_781 vssd1 vssd1 vccd1 vccd1 sky130_fd_sc_hd__fill_1
X_10079_ cell3.SB0.route_sel\[0\] cell3.SB0.route_sel\[1\] cell3.SB0.route_sel\[4\]
+ _01677_ _05080_ vssd1 vssd1 vccd1 vccd1 _05081_ sky130_fd_sc_hd__o221a_1
X_13907_ clknet_leaf_35_clk net1368 net636 vssd1 vssd1 vccd1 vccd1 cell2.LE_0B.config_data\[8\]
+ sky130_fd_sc_hd__dfrtp_1
XANTENNA__13648__SET_B net635 vssd1 vssd1 vccd1 vccd1 sky130_fd_sc_hd__diode_2
X_13838_ clknet_leaf_96_clk _00810_ net678 vssd1 vssd1 vccd1 vccd1 cell1.SB0.route_sel\[115\]
+ sky130_fd_sc_hd__dfstp_1
XFILLER_90_596 vssd1 vssd1 vccd1 vccd1 sky130_fd_sc_hd__fill_1
XTAP_TAPCELL_ROW_46_997 vssd1 vccd1 sky130_fd_sc_hd__tapvpwrvgnd_1
X_13769_ clknet_leaf_110_clk _00741_ net653 vssd1 vssd1 vccd1 vccd1 cell1.SB0.route_sel\[46\]
+ sky130_fd_sc_hd__dfstp_1
XFILLER_22_129 vssd1 vssd1 vccd1 vccd1 sky130_fd_sc_hd__fill_2
Xclkbuf_leaf_42_clk clknet_4_6_0_clk vssd1 vssd1 vccd1 vccd1 clknet_leaf_42_clk sky130_fd_sc_hd__clkbuf_8
XANTENNA__08101__A2 _02235_ vssd1 vssd1 vccd1 vccd1 sky130_fd_sc_hd__diode_2
X_07290_ cell0.SB0.route_sel\[96\] _01476_ cell0.SB0.route_sel\[101\] cell0.SB0.route_sel\[100\]
+ _02347_ vssd1 vssd1 vccd1 vccd1 _02348_ sky130_fd_sc_hd__o221a_1
XANTENNA__07121__X _02184_ vssd1 vssd1 vccd1 vccd1 sky130_fd_sc_hd__diode_2
XANTENNA__10995__A1 net41 vssd1 vssd1 vccd1 vccd1 sky130_fd_sc_hd__diode_2
XANTENNA__13279__Q cell1.LE_1B.config_data\[15\] vssd1 vssd1 vccd1 vccd1 sky130_fd_sc_hd__diode_2
Xhold314 cell2.LE_0B.config_data\[13\] vssd1 vssd1 vccd1 vccd1 net1273 sky130_fd_sc_hd__dlygate4sd3_1
Xhold325 cell2.LE_1A.config_data\[13\] vssd1 vssd1 vccd1 vccd1 net1284 sky130_fd_sc_hd__dlygate4sd3_1
Xhold303 cell0.LE_1B.config_data\[13\] vssd1 vssd1 vccd1 vccd1 net1262 sky130_fd_sc_hd__dlygate4sd3_1
Xhold347 cell3.LE_0A.config_data\[14\] vssd1 vssd1 vccd1 vccd1 net1306 sky130_fd_sc_hd__dlygate4sd3_1
Xhold336 _00603_ vssd1 vssd1 vccd1 vccd1 net1295 sky130_fd_sc_hd__dlygate4sd3_1
Xhold358 _00941_ vssd1 vssd1 vccd1 vccd1 net1317 sky130_fd_sc_hd__dlygate4sd3_1
X_09931_ net409 _04498_ _04934_ vssd1 vssd1 vccd1 vccd1 _04935_ sky130_fd_sc_hd__a21o_1
XFILLER_89_118 vssd1 vssd1 vccd1 vccd1 sky130_fd_sc_hd__fill_2
Xhold369 cell0.LEI0.config_data\[29\] vssd1 vssd1 vccd1 vccd1 net1328 sky130_fd_sc_hd__dlygate4sd3_1
Xfanout816 net817 vssd1 vssd1 vccd1 vccd1 net816 sky130_fd_sc_hd__clkbuf_4
Xfanout805 net806 vssd1 vssd1 vccd1 vccd1 net805 sky130_fd_sc_hd__buf_2
XTAP_TAPCELL_ROW_55_1140 vssd1 vccd1 sky130_fd_sc_hd__tapvpwrvgnd_1
XANTENNA__14412__RESET_B net754 vssd1 vssd1 vccd1 vccd1 sky130_fd_sc_hd__diode_2
Xfanout827 net828 vssd1 vssd1 vccd1 vccd1 net827 sky130_fd_sc_hd__buf_2
XANTENNA__11172__A1 _05898_ vssd1 vssd1 vccd1 vccd1 sky130_fd_sc_hd__diode_2
Xfanout849 net854 vssd1 vssd1 vccd1 vccd1 net849 sky130_fd_sc_hd__clkbuf_2
Xfanout838 net845 vssd1 vssd1 vccd1 vccd1 net838 sky130_fd_sc_hd__clkbuf_4
X_09862_ cell2.LEI0.config_data\[32\] _04865_ _04867_ vssd1 vssd1 vccd1 vccd1 _04868_
+ sky130_fd_sc_hd__or3_1
XFILLER_98_663 vssd1 vssd1 vccd1 vccd1 sky130_fd_sc_hd__fill_1
XFILLER_97_151 vssd1 vssd1 vccd1 vccd1 sky130_fd_sc_hd__fill_2
XFILLER_140_793 vccd1 vssd1 vccd1 vssd1 sky130_ef_sc_hd__decap_40_12
XFILLER_133_39 vccd1 vssd1 vccd1 vssd1 sky130_ef_sc_hd__decap_40_12
X_09793_ net448 _04583_ vssd1 vssd1 vccd1 vccd1 _04799_ sky130_fd_sc_hd__or2_1
XFILLER_86_847 vssd1 vssd1 vccd1 vccd1 sky130_fd_sc_hd__fill_1
X_08813_ net470 _03844_ vssd1 vssd1 vccd1 vccd1 _03845_ sky130_fd_sc_hd__nand2_1
XANTENNA__07009__A _02037_ vssd1 vssd1 vccd1 vccd1 sky130_fd_sc_hd__diode_2
XANTENNA_fanout286_A cell3.CB_0.le_outA vssd1 vssd1 vccd1 vccd1 sky130_fd_sc_hd__diode_2
XFILLER_100_657 vssd1 vssd1 vccd1 vccd1 sky130_fd_sc_hd__fill_1
X_08744_ net452 _03489_ vssd1 vssd1 vccd1 vccd1 _03778_ sky130_fd_sc_hd__nand2_1
XANTENNA__10683__A0 _05519_ vssd1 vssd1 vccd1 vccd1 sky130_fd_sc_hd__diode_2
XFILLER_54_755 vssd1 vssd1 vccd1 vccd1 sky130_fd_sc_hd__fill_1
X_08675_ net460 net461 _03498_ vssd1 vssd1 vccd1 vccd1 _03709_ sky130_fd_sc_hd__or3_1
XFILLER_81_552 vssd1 vssd1 vccd1 vccd1 sky130_fd_sc_hd__fill_1
XANTENNA__07015__Y _02080_ vssd1 vssd1 vccd1 vccd1 sky130_fd_sc_hd__diode_2
XANTENNA__08340__A2 net349 vssd1 vssd1 vccd1 vccd1 sky130_fd_sc_hd__diode_2
X_07626_ cell0.SB0.route_sel\[9\] cell0.SB0.route_sel\[8\] _02668_ _02674_ net781
+ vssd1 vssd1 vccd1 vccd1 _02675_ sky130_fd_sc_hd__a311o_4
XFILLER_26_468 vssd1 vssd1 vccd1 vccd1 sky130_fd_sc_hd__fill_8
XFILLER_26_479 vssd1 vssd1 vccd1 vccd1 sky130_fd_sc_hd__fill_1
XANTENNA_fanout620_A net621 vssd1 vssd1 vccd1 vccd1 sky130_fd_sc_hd__diode_2
X_07557_ cell0.CB_1.config_dataA\[22\] cell0.CB_1.config_dataA\[23\] vssd1 vssd1 vccd1
+ vccd1 _02607_ sky130_fd_sc_hd__or2_1
Xclkbuf_leaf_33_clk clknet_4_7_0_clk vssd1 vssd1 vccd1 vccd1 clknet_leaf_33_clk sky130_fd_sc_hd__clkbuf_8
XTAP_TAPCELL_ROW_66_1291 vssd1 vccd1 sky130_fd_sc_hd__tapvpwrvgnd_1
XANTENNA_fanout339_X net339 vssd1 vssd1 vccd1 vccd1 sky130_fd_sc_hd__diode_2
X_06508_ cell0.SB0.route_sel\[4\] vssd1 vssd1 vccd1 vccd1 _01578_ sky130_fd_sc_hd__inv_2
XTAP_TAPCELL_ROW_24_669 vssd1 vccd1 sky130_fd_sc_hd__tapvpwrvgnd_1
X_07488_ _02538_ _02540_ vssd1 vssd1 vccd1 vccd1 bus2_0\[14\] sky130_fd_sc_hd__and2_2
X_09227_ net306 net44 _04252_ vssd1 vssd1 vccd1 vccd1 _04254_ sky130_fd_sc_hd__mux2_1
X_06439_ cell1.SB0.route_sel\[27\] vssd1 vssd1 vccd1 vccd1 _01509_ sky130_fd_sc_hd__inv_2
X_09158_ cell2.SB0.route_sel\[3\] cell2.SB0.route_sel\[2\] _04184_ _04185_ _04181_
+ vssd1 vssd1 vccd1 vccd1 _04186_ sky130_fd_sc_hd__a41o_1
XANTENNA__10738__B2 _05531_ vssd1 vssd1 vccd1 vccd1 sky130_fd_sc_hd__diode_2
XANTENNA__08800__B1 _03830_ vssd1 vssd1 vccd1 vccd1 sky130_fd_sc_hd__diode_2
X_09089_ cell1.CB_0.config_dataB\[14\] _04091_ _04107_ _04118_ vssd1 vssd1 vccd1 vccd1
+ _04119_ sky130_fd_sc_hd__a31oi_1
X_08109_ _01560_ _01561_ cell0.CB_0.config_dataB\[19\] _03126_ _03150_ vssd1 vssd1
+ vccd1 vccd1 _03151_ sky130_fd_sc_hd__a41o_1
XFILLER_123_716 vssd1 vssd1 vccd1 vccd1 sky130_fd_sc_hd__fill_1
X_11120_ _05921_ _06048_ _06070_ _06071_ vssd1 vssd1 vccd1 vccd1 _06072_ sky130_fd_sc_hd__a211oi_1
XANTENNA__09356__A1 net303 vssd1 vssd1 vccd1 vccd1 sky130_fd_sc_hd__diode_2
XANTENNA__11163__A1 _05856_ vssd1 vssd1 vccd1 vccd1 sky130_fd_sc_hd__diode_2
X_11051_ _05874_ _05871_ net373 vssd1 vssd1 vccd1 vccd1 _06005_ sky130_fd_sc_hd__mux2_1
XFILLER_103_451 vssd1 vssd1 vccd1 vccd1 sky130_fd_sc_hd__fill_2
XANTENNA__11163__B2 _05861_ vssd1 vssd1 vccd1 vccd1 sky130_fd_sc_hd__diode_2
X_10002_ net404 _04583_ _05005_ net402 vssd1 vssd1 vccd1 vccd1 _05006_ sky130_fd_sc_hd__o211a_1
XANTENNA__07906__A2 _02894_ vssd1 vssd1 vccd1 vccd1 sky130_fd_sc_hd__diode_2
XFILLER_67_55 vssd1 vssd1 vccd1 vccd1 sky130_fd_sc_hd__fill_1
XANTENNA__10910__A1 net54 vssd1 vssd1 vccd1 vccd1 sky130_fd_sc_hd__diode_2
XFILLER_88_195 vssd1 vssd1 vccd1 vccd1 sky130_fd_sc_hd__fill_1
XANTENNA__07861__B _02904_ vssd1 vssd1 vccd1 vccd1 sky130_fd_sc_hd__diode_2
XTAP_TAPCELL_ROW_86_1601 vssd1 vccd1 sky130_fd_sc_hd__tapvpwrvgnd_1
XANTENNA__06758__A net347 vssd1 vssd1 vccd1 vccd1 sky130_fd_sc_hd__diode_2
XTAP_TAPCELL_ROW_4_372 vssd1 vccd1 sky130_fd_sc_hd__tapvpwrvgnd_1
XTAP_TAPCELL_ROW_4_361 vssd1 vccd1 sky130_fd_sc_hd__tapvpwrvgnd_1
XANTENNA_input14_A CBeast_in[21] vssd1 vssd1 vccd1 vccd1 sky130_fd_sc_hd__diode_2
X_11953_ cell0.SB0.route_sel\[59\] cell0.SB0.route_sel\[58\] net761 vssd1 vssd1 vccd1
+ vccd1 _00390_ sky130_fd_sc_hd__mux2_1
X_10904_ net379 net378 vssd1 vssd1 vccd1 vccd1 _05858_ sky130_fd_sc_hd__or2_1
XPHY_EDGE_ROW_103_Left_246 vssd1 vssd1 vccd1 vccd1 sky130_fd_sc_hd__decap_3
XFILLER_83_54 vssd1 vssd1 vccd1 vccd1 sky130_fd_sc_hd__fill_2
X_11884_ net465 cell1.CB_0.config_dataA\[14\] net882 vssd1 vssd1 vccd1 vccd1 _00321_
+ sky130_fd_sc_hd__mux2_1
X_10835_ cell3.LEI0.config_data\[34\] _05790_ cell3.LEI0.config_data\[35\] vssd1 vssd1
+ vccd1 vccd1 _05791_ sky130_fd_sc_hd__a21oi_1
XANTENNA__09421__X _04444_ vssd1 vssd1 vccd1 vccd1 sky130_fd_sc_hd__diode_2
X_13623_ clknet_leaf_95_clk net1277 net687 vssd1 vssd1 vccd1 vccd1 cell1.LEI0.config_data\[44\]
+ sky130_fd_sc_hd__dfrtp_1
Xclkbuf_leaf_24_clk clknet_4_4_0_clk vssd1 vssd1 vccd1 vccd1 clknet_leaf_24_clk sky130_fd_sc_hd__clkbuf_8
XTAP_TAPCELL_ROW_43_956 vssd1 vccd1 sky130_fd_sc_hd__tapvpwrvgnd_1
X_10766_ cell3.CB_1.config_dataB\[4\] _05703_ _05718_ _05721_ vssd1 vssd1 vccd1 vccd1
+ _05722_ sky130_fd_sc_hd__o31ai_4
X_13554_ clknet_leaf_99_clk _00526_ net681 vssd1 vssd1 vccd1 vccd1 cell1.LE_0B.reset_mode
+ sky130_fd_sc_hd__dfrtp_1
X_12505_ net1310 cell2.LEI0.config_data\[18\] net850 vssd1 vssd1 vccd1 vccd1 _00934_
+ sky130_fd_sc_hd__mux2_1
X_10697_ _05478_ _05475_ net391 vssd1 vssd1 vccd1 vccd1 _05655_ sky130_fd_sc_hd__mux2_1
X_13485_ clknet_leaf_10_clk _00457_ net592 vssd1 vssd1 vccd1 vccd1 cell0.SB0.route_sel\[126\]
+ sky130_fd_sc_hd__dfstp_1
XFILLER_8_133 vssd1 vssd1 vccd1 vccd1 sky130_fd_sc_hd__fill_4
XFILLER_12_195 vssd1 vssd1 vccd1 vccd1 sky130_fd_sc_hd__fill_1
X_12436_ cell2.LE_1A.reset_mode net1504 net846 vssd1 vssd1 vccd1 vccd1 _00868_ sky130_fd_sc_hd__mux2_1
XTAP_TAPCELL_ROW_113_2008 vssd1 vccd1 sky130_fd_sc_hd__tapvpwrvgnd_1
XTAP_TAPCELL_ROW_97_1763 vssd1 vccd1 sky130_fd_sc_hd__tapvpwrvgnd_1
XANTENNA__08398__A2 bus1_0\[2\] vssd1 vssd1 vccd1 vccd1 sky130_fd_sc_hd__diode_2
XFILLER_126_576 vssd1 vssd1 vccd1 vccd1 sky130_fd_sc_hd__fill_1
XPHY_EDGE_ROW_112_Left_255 vssd1 vssd1 vccd1 vccd1 sky130_fd_sc_hd__decap_3
X_14106_ clknet_leaf_78_clk _01078_ net713 vssd1 vssd1 vccd1 vccd1 cell3.SB0.route_sel\[114\]
+ sky130_fd_sc_hd__dfstp_1
X_12367_ cell1.SB0.route_sel\[105\] cell1.SB0.route_sel\[104\] net874 vssd1 vssd1
+ vccd1 vccd1 _00800_ sky130_fd_sc_hd__mux2_1
X_11318_ net293 _06224_ _04619_ vssd1 vssd1 vccd1 vccd1 net153 sky130_fd_sc_hd__mux2_1
XANTENNA__11558__B net268 vssd1 vssd1 vccd1 vccd1 sky130_fd_sc_hd__diode_2
X_12298_ cell1.SB0.route_sel\[36\] cell1.SB0.route_sel\[35\] net860 vssd1 vssd1 vccd1
+ vccd1 _00731_ sky130_fd_sc_hd__mux2_1
X_14037_ clknet_leaf_82_clk _01009_ net670 vssd1 vssd1 vccd1 vccd1 cell3.SB0.route_sel\[45\]
+ sky130_fd_sc_hd__dfstp_2
X_11249_ clknet_leaf_117_clk cell1.LE_0A.edge_mode vssd1 vssd1 vccd1 vccd1 cell1.LE_0A.sel_clk
+ sky130_fd_sc_hd__xnor2_2
XANTENNA__07358__B1 _02409_ vssd1 vssd1 vccd1 vccd1 sky130_fd_sc_hd__diode_2
XANTENNA__08570__A2 net2 vssd1 vssd1 vccd1 vccd1 sky130_fd_sc_hd__diode_2
XANTENNA__13876__RESET_B net752 vssd1 vssd1 vccd1 vccd1 sky130_fd_sc_hd__diode_2
X_06790_ net93 _01858_ _01859_ vssd1 vssd1 vccd1 vccd1 _01860_ sky130_fd_sc_hd__a21oi_1
XPHY_EDGE_ROW_121_Left_264 vssd1 vssd1 vccd1 vccd1 sky130_fd_sc_hd__decap_3
XANTENNA__10665__A0 net8 vssd1 vssd1 vccd1 vccd1 sky130_fd_sc_hd__diode_2
X_08460_ cell1.SB0.route_sel\[101\] cell1.SB0.route_sel\[100\] vssd1 vssd1 vccd1 vccd1
+ _03496_ sky130_fd_sc_hd__or2_1
X_07411_ _02465_ net309 _02464_ vssd1 vssd1 vccd1 vccd1 _02466_ sky130_fd_sc_hd__mux2_1
X_08391_ net500 _02277_ _03428_ vssd1 vssd1 vccd1 vccd1 _03429_ sky130_fd_sc_hd__a21o_1
X_07342_ net305 _02395_ _02398_ vssd1 vssd1 vccd1 vccd1 _02399_ sky130_fd_sc_hd__a21oi_1
XTAP_TAPCELL_ROW_106_1892 vssd1 vccd1 sky130_fd_sc_hd__tapvpwrvgnd_1
Xclkbuf_leaf_15_clk clknet_4_6_0_clk vssd1 vssd1 vccd1 vccd1 clknet_leaf_15_clk sky130_fd_sc_hd__clkbuf_8
XANTENNA__09822__A2 net315 vssd1 vssd1 vccd1 vccd1 sky130_fd_sc_hd__diode_2
XTAP_TAPCELL_ROW_21_617 vssd1 vccd1 sky130_fd_sc_hd__tapvpwrvgnd_1
XTAP_TAPCELL_ROW_21_628 vssd1 vccd1 sky130_fd_sc_hd__tapvpwrvgnd_1
XTAP_TAPCELL_ROW_139_2391 vssd1 vccd1 sky130_fd_sc_hd__tapvpwrvgnd_1
XANTENNA__07833__A1 bus2_0\[9\] vssd1 vssd1 vccd1 vccd1 sky130_fd_sc_hd__diode_2
X_07273_ cell0.SB0.route_sel\[99\] cell0.SB0.route_sel\[98\] vssd1 vssd1 vccd1 vccd1
+ _02331_ sky130_fd_sc_hd__nand2_1
XPHY_EDGE_ROW_130_Left_273 vssd1 vssd1 vccd1 vccd1 sky130_fd_sc_hd__decap_3
X_09012_ _01670_ _04039_ _04041_ vssd1 vssd1 vccd1 vccd1 _04042_ sky130_fd_sc_hd__a21oi_1
Xhold100 cell0.LE_0A.config_data\[7\] vssd1 vssd1 vccd1 vccd1 net1059 sky130_fd_sc_hd__dlygate4sd3_1
Xhold111 cell3.LE_0B.config_data\[11\] vssd1 vssd1 vccd1 vccd1 net1070 sky130_fd_sc_hd__dlygate4sd3_1
XFILLER_117_565 vssd1 vssd1 vccd1 vccd1 sky130_fd_sc_hd__fill_1
Xhold122 cell3.LE_1A.config_data\[10\] vssd1 vssd1 vccd1 vccd1 net1081 sky130_fd_sc_hd__dlygate4sd3_1
XFILLER_105_727 vssd1 vssd1 vccd1 vccd1 sky130_fd_sc_hd__fill_1
Xhold144 cell1.LEI0.config_data\[20\] vssd1 vssd1 vccd1 vccd1 net1103 sky130_fd_sc_hd__dlygate4sd3_1
Xhold133 cell0.LEI0.config_data\[16\] vssd1 vssd1 vccd1 vccd1 net1092 sky130_fd_sc_hd__dlygate4sd3_1
XFILLER_2_309 vccd1 vssd1 vccd1 vssd1 sky130_ef_sc_hd__decap_40_12
Xhold155 cell2.LE_1A.config_data\[1\] vssd1 vssd1 vccd1 vccd1 net1114 sky130_fd_sc_hd__dlygate4sd3_1
Xhold166 _00901_ vssd1 vssd1 vccd1 vccd1 net1125 sky130_fd_sc_hd__dlygate4sd3_1
Xhold177 cell0.LE_1B.config_data\[3\] vssd1 vssd1 vccd1 vccd1 net1136 sky130_fd_sc_hd__dlygate4sd3_1
XFILLER_132_568 vssd1 vssd1 vccd1 vccd1 sky130_fd_sc_hd__fill_1
X_09914_ _04912_ _04919_ _04908_ vssd1 vssd1 vccd1 vccd1 _04920_ sky130_fd_sc_hd__mux2_1
Xfanout613 net616 vssd1 vssd1 vccd1 vccd1 net613 sky130_fd_sc_hd__clkbuf_4
XFILLER_104_259 vssd1 vssd1 vccd1 vccd1 sky130_fd_sc_hd__fill_1
Xfanout624 net626 vssd1 vssd1 vccd1 vccd1 net624 sky130_fd_sc_hd__clkbuf_4
Xhold199 cell1.LE_0B.config_data\[10\] vssd1 vssd1 vccd1 vccd1 net1158 sky130_fd_sc_hd__dlygate4sd3_1
Xfanout602 net650 vssd1 vssd1 vccd1 vccd1 net602 sky130_fd_sc_hd__clkbuf_4
Xhold188 cell0.LE_1A.config_data\[8\] vssd1 vssd1 vccd1 vccd1 net1147 sky130_fd_sc_hd__dlygate4sd3_1
Xfanout646 net649 vssd1 vssd1 vccd1 vccd1 net646 sky130_fd_sc_hd__clkbuf_2
Xfanout635 net640 vssd1 vssd1 vccd1 vccd1 net635 sky130_fd_sc_hd__clkbuf_4
XANTENNA_input6_A CBeast_in[14] vssd1 vssd1 vccd1 vccd1 sky130_fd_sc_hd__diode_2
X_09845_ bus3_2\[0\] bus3_2\[2\] bus3_2\[1\] bus3_2\[3\] net440 net441 vssd1 vssd1
+ vccd1 vccd1 _04851_ sky130_fd_sc_hd__mux4_1
Xfanout657 net675 vssd1 vssd1 vccd1 vccd1 net657 sky130_fd_sc_hd__clkbuf_2
XFILLER_85_132 vssd1 vssd1 vccd1 vccd1 sky130_fd_sc_hd__fill_2
Xfanout668 net669 vssd1 vssd1 vccd1 vccd1 net668 sky130_fd_sc_hd__clkbuf_4
XANTENNA__11484__A cell1.SB0.config_data_out vssd1 vssd1 vccd1 vccd1 sky130_fd_sc_hd__diode_2
Xfanout679 net682 vssd1 vssd1 vccd1 vccd1 net679 sky130_fd_sc_hd__clkbuf_4
X_09776_ _04445_ _04757_ _04759_ _04399_ vssd1 vssd1 vccd1 vccd1 _04782_ sky130_fd_sc_hd__o2bb2a_1
XFILLER_86_688 vssd1 vssd1 vccd1 vccd1 sky130_fd_sc_hd__fill_2
XFILLER_85_165 vssd1 vssd1 vccd1 vccd1 sky130_fd_sc_hd__fill_2
XANTENNA__08269__S _03231_ vssd1 vssd1 vccd1 vccd1 sky130_fd_sc_hd__diode_2
X_06988_ cell1.SB0.route_sel\[66\] cell1.SB0.route_sel\[67\] net333 _02052_ vssd1
+ vssd1 vccd1 vccd1 _02054_ sky130_fd_sc_hd__a22o_1
XFILLER_100_498 vssd1 vssd1 vccd1 vccd1 sky130_fd_sc_hd__fill_1
XTAP_TAPCELL_ROW_68_1331 vssd1 vccd1 sky130_fd_sc_hd__tapvpwrvgnd_1
XTAP_TAPCELL_ROW_1_320 vssd1 vccd1 sky130_fd_sc_hd__tapvpwrvgnd_1
XTAP_TAPCELL_ROW_29_739 vssd1 vccd1 sky130_fd_sc_hd__tapvpwrvgnd_1
X_08727_ net454 _01658_ _03494_ _03760_ vssd1 vssd1 vccd1 vccd1 _03761_ sky130_fd_sc_hd__o31a_1
X_08658_ net458 _03486_ _03691_ net457 vssd1 vssd1 vccd1 vccd1 _03692_ sky130_fd_sc_hd__o211ai_1
XANTENNA__13694__SET_B net621 vssd1 vssd1 vccd1 vccd1 sky130_fd_sc_hd__diode_2
X_07609_ _02109_ _02607_ vssd1 vssd1 vccd1 vccd1 _02658_ sky130_fd_sc_hd__or2_2
XANTENNA__08793__A _02444_ vssd1 vssd1 vccd1 vccd1 sky130_fd_sc_hd__diode_2
XANTENNA_fanout623_X net623 vssd1 vssd1 vccd1 vccd1 sky130_fd_sc_hd__diode_2
XTAP_TAPCELL_ROW_81_1520 vssd1 vccd1 sky130_fd_sc_hd__tapvpwrvgnd_1
XFILLER_14_449 vssd1 vssd1 vccd1 vccd1 sky130_fd_sc_hd__fill_1
X_08589_ net1 net12 net23 net26 net488 net487 vssd1 vssd1 vccd1 vccd1 _03625_ sky130_fd_sc_hd__mux4_1
X_10620_ net273 _05548_ _05566_ vssd1 vssd1 vccd1 vccd1 _05578_ sky130_fd_sc_hd__a21oi_1
XANTENNA__09274__B1 net314 vssd1 vssd1 vccd1 vccd1 sky130_fd_sc_hd__diode_2
XTAP_TAPCELL_ROW_40_915 vssd1 vccd1 sky130_fd_sc_hd__tapvpwrvgnd_1
XTAP_TAPCELL_ROW_40_904 vssd1 vccd1 sky130_fd_sc_hd__tapvpwrvgnd_1
X_10551_ _01688_ cell3.SB0.route_sel\[15\] _05508_ vssd1 vssd1 vccd1 vccd1 _05509_
+ sky130_fd_sc_hd__o21ai_2
XFILLER_139_167 vssd1 vssd1 vccd1 vccd1 sky130_fd_sc_hd__fill_1
X_10482_ net589 cell0.LE_0A.reset_mode vssd1 vssd1 vccd1 vccd1 _10482_/X sky130_fd_sc_hd__xor2_2
X_13270_ clknet_leaf_93_clk net1508 net693 vssd1 vssd1 vccd1 vccd1 cell1.LE_1B.config_data\[6\]
+ sky130_fd_sc_hd__dfrtp_1
X_12221_ cell2.CB_0.config_dataB\[9\] cell2.CB_0.config_dataB\[8\] net825 vssd1 vssd1
+ vccd1 vccd1 _00654_ sky130_fd_sc_hd__mux2_1
XFILLER_5_125 vccd1 vssd1 vccd1 vssd1 sky130_ef_sc_hd__decap_40_12
XFILLER_10_699 vssd1 vssd1 vccd1 vccd1 sky130_fd_sc_hd__fill_1
XFILLER_135_351 vssd1 vssd1 vccd1 vccd1 sky130_fd_sc_hd__fill_1
XANTENNA__10187__A2 _05096_ vssd1 vssd1 vccd1 vccd1 sky130_fd_sc_hd__diode_2
XTAP_TAPCELL_ROW_79_1493 vssd1 vccd1 sky130_fd_sc_hd__tapvpwrvgnd_1
XANTENNA__09041__A3 bus3_1\[15\] vssd1 vssd1 vccd1 vccd1 sky130_fd_sc_hd__diode_2
XFILLER_118_61 vssd1 vssd1 vccd1 vccd1 sky130_fd_sc_hd__fill_2
X_12152_ net1237 net1184 net900 vssd1 vssd1 vccd1 vccd1 _00585_ sky130_fd_sc_hd__mux2_1
XTAP_TAPCELL_ROW_9_442 vssd1 vccd1 sky130_fd_sc_hd__tapvpwrvgnd_1
XFILLER_2_843 vssd1 vssd1 vccd1 vccd1 sky130_fd_sc_hd__fill_1
X_11103_ _01796_ _05871_ cell3.CB_0.config_dataB\[1\] vssd1 vssd1 vccd1 vccd1 _06055_
+ sky130_fd_sc_hd__o21ai_1
XFILLER_96_419 vssd1 vssd1 vccd1 vccd1 sky130_fd_sc_hd__fill_1
XTAP_TAPCELL_ROW_92_1682 vssd1 vccd1 sky130_fd_sc_hd__tapvpwrvgnd_1
X_12083_ net1097 net1158 net938 vssd1 vssd1 vccd1 vccd1 _00518_ sky130_fd_sc_hd__mux2_1
X_11034_ _05921_ _05965_ _05986_ cell3.CB_0.config_dataA\[11\] cell3.CB_0.config_dataA\[12\]
+ vssd1 vssd1 vccd1 vccd1 _05988_ sky130_fd_sc_hd__a221o_1
XTAP_TAPCELL_ROW_92_1693 vssd1 vccd1 sky130_fd_sc_hd__tapvpwrvgnd_1
XFILLER_77_611 vssd1 vssd1 vccd1 vccd1 sky130_fd_sc_hd__fill_1
XFILLER_94_53 vccd1 vssd1 vccd1 vssd1 sky130_ef_sc_hd__decap_40_12
XFILLER_91_102 vssd1 vssd1 vccd1 vccd1 sky130_fd_sc_hd__fill_1
XANTENNA_input17_X net17 vssd1 vssd1 vccd1 vccd1 sky130_fd_sc_hd__diode_2
X_12985_ net1454 net1476 net945 vssd1 vssd1 vccd1 vccd1 _01413_ sky130_fd_sc_hd__mux2_1
XANTENNA__12636__A1 cell3.SB0.route_sel\[100\] vssd1 vssd1 vccd1 vccd1 sky130_fd_sc_hd__diode_2
XANTENNA_output218_A net218 vssd1 vssd1 vccd1 vccd1 sky130_fd_sc_hd__diode_2
X_11936_ cell0.SB0.route_sel\[42\] cell0.SB0.route_sel\[41\] net757 vssd1 vssd1 vccd1
+ vccd1 _00373_ sky130_fd_sc_hd__mux2_1
XFILLER_45_596 vssd1 vssd1 vccd1 vccd1 sky130_fd_sc_hd__fill_1
X_11867_ cell1.CB_0.config_dataB\[23\] cell1.CB_0.config_dataB\[22\] net874 vssd1
+ vssd1 vccd1 vccd1 _00304_ sky130_fd_sc_hd__mux2_1
XFILLER_17_298 vssd1 vssd1 vccd1 vccd1 sky130_fd_sc_hd__fill_1
XANTENNA_max_cap299_A _01874_ vssd1 vssd1 vccd1 vccd1 sky130_fd_sc_hd__diode_2
X_10818_ _05513_ _05763_ vssd1 vssd1 vccd1 vccd1 _05774_ sky130_fd_sc_hd__nor2_1
X_11798_ net1379 net548 _06376_ vssd1 vssd1 vccd1 vccd1 _00235_ sky130_fd_sc_hd__a21bo_1
X_13606_ clknet_leaf_86_clk net1484 net686 vssd1 vssd1 vccd1 vccd1 cell1.LEI0.config_data\[27\]
+ sky130_fd_sc_hd__dfrtp_1
XANTENNA__08068__A1 bus2_0\[7\] vssd1 vssd1 vccd1 vccd1 sky130_fd_sc_hd__diode_2
XFILLER_20_419 vssd1 vssd1 vccd1 vccd1 sky130_fd_sc_hd__fill_1
X_10749_ _01778_ _05475_ _05704_ net370 vssd1 vssd1 vccd1 vccd1 _05705_ sky130_fd_sc_hd__o211a_1
X_13537_ clknet_leaf_90_clk _00509_ net697 vssd1 vssd1 vccd1 vccd1 cell1.LE_0B.config_data\[2\]
+ sky130_fd_sc_hd__dfrtp_1
XANTENNA__07112__A net114 vssd1 vssd1 vccd1 vccd1 sky130_fd_sc_hd__diode_2
XFILLER_127_841 vssd1 vssd1 vccd1 vccd1 sky130_fd_sc_hd__fill_1
XANTENNA__07028__C1 _02092_ vssd1 vssd1 vccd1 vccd1 sky130_fd_sc_hd__diode_2
X_13468_ clknet_leaf_0_clk _00440_ net554 vssd1 vssd1 vccd1 vccd1 cell0.SB0.route_sel\[109\]
+ sky130_fd_sc_hd__dfstp_1
X_12419_ net984 net1114 net849 vssd1 vssd1 vccd1 vccd1 _00851_ sky130_fd_sc_hd__mux2_1
XANTENNA__12572__A0 cell3.SB0.route_sel\[37\] vssd1 vssd1 vccd1 vccd1 sky130_fd_sc_hd__diode_2
Xoutput205 net205 vssd1 vssd1 vccd1 vccd1 SBsouth_out[16] sky130_fd_sc_hd__buf_2
Xoutput216 net216 vssd1 vssd1 vccd1 vccd1 SBsouth_out[26] sky130_fd_sc_hd__buf_2
X_13399_ clknet_leaf_1_clk _00371_ net553 vssd1 vssd1 vccd1 vccd1 cell0.SB0.route_sel\[40\]
+ sky130_fd_sc_hd__dfstp_1
Xoutput249 net249 vssd1 vssd1 vccd1 vccd1 SBwest_out[27] sky130_fd_sc_hd__buf_2
Xoutput238 net238 vssd1 vssd1 vccd1 vccd1 SBwest_out[17] sky130_fd_sc_hd__buf_2
Xoutput227 net227 vssd1 vssd1 vccd1 vccd1 SBsouth_out[7] sky130_fd_sc_hd__buf_2
X_07960_ bus2_0\[8\] bus2_0\[9\] bus2_0\[10\] bus2_0\[11\] net513 cell0.CB_0.config_dataA\[16\]
+ vssd1 vssd1 vccd1 vccd1 _03004_ sky130_fd_sc_hd__mux4_1
Xclkbuf_leaf_4_clk clknet_4_1_0_clk vssd1 vssd1 vccd1 vccd1 clknet_leaf_4_clk sky130_fd_sc_hd__clkbuf_8
X_06911_ cell1.SB0.route_sel\[56\] cell1.SB0.route_sel\[57\] _01969_ _01978_ net858
+ vssd1 vssd1 vccd1 vccd1 _01979_ sky130_fd_sc_hd__a311oi_4
XFILLER_68_666 vssd1 vssd1 vccd1 vccd1 sky130_fd_sc_hd__fill_1
XFILLER_67_132 vssd1 vssd1 vccd1 vccd1 sky130_fd_sc_hd__fill_1
X_07891_ _02456_ _02920_ _02921_ _02388_ _01569_ vssd1 vssd1 vccd1 vccd1 _02935_ sky130_fd_sc_hd__a221o_1
XFILLER_95_474 vssd1 vssd1 vccd1 vccd1 sky130_fd_sc_hd__fill_4
X_09630_ net363 net362 vssd1 vssd1 vccd1 vccd1 _04646_ sky130_fd_sc_hd__nand2_1
XFILLER_83_603 vccd1 vssd1 vccd1 vssd1 sky130_ef_sc_hd__decap_40_12
XFILLER_68_699 vssd1 vssd1 vccd1 vccd1 sky130_fd_sc_hd__fill_1
XFILLER_68_677 vssd1 vssd1 vccd1 vccd1 sky130_fd_sc_hd__fill_1
X_06842_ cell0.SB0.route_sel\[51\] cell0.SB0.route_sel\[50\] vssd1 vssd1 vccd1 vccd1
+ _01911_ sky130_fd_sc_hd__nor2_1
XTAP_TAPCELL_ROW_108_1932 vssd1 vccd1 sky130_fd_sc_hd__tapvpwrvgnd_1
XTAP_TAPCELL_ROW_108_1921 vssd1 vccd1 sky130_fd_sc_hd__tapvpwrvgnd_1
X_06773_ _01841_ _01842_ vssd1 vssd1 vccd1 vccd1 _01843_ sky130_fd_sc_hd__nor2_1
X_09561_ _03838_ _03839_ _03840_ _02230_ _02225_ vssd1 vssd1 vccd1 vccd1 _04579_ sky130_fd_sc_hd__a311o_1
X_08512_ net494 _03504_ _03547_ net493 vssd1 vssd1 vccd1 vccd1 _03548_ sky130_fd_sc_hd__o211a_1
XFILLER_130_29 vccd1 vssd1 vccd1 vssd1 sky130_ef_sc_hd__decap_40_12
XFILLER_91_680 vssd1 vssd1 vccd1 vccd1 sky130_fd_sc_hd__fill_1
X_09492_ _04505_ _04512_ _04507_ vssd1 vssd1 vccd1 vccd1 _04513_ sky130_fd_sc_hd__a21oi_1
XANTENNA__10653__A3 net20 vssd1 vssd1 vccd1 vccd1 sky130_fd_sc_hd__diode_2
X_08443_ _03473_ _03474_ _03477_ _03478_ cell1.CB_1.config_dataA\[2\] vssd1 vssd1
+ vccd1 vccd1 _03479_ sky130_fd_sc_hd__a221o_1
XTAP_TAPCELL_ROW_63_1250 vssd1 vccd1 sky130_fd_sc_hd__tapvpwrvgnd_1
X_08374_ cell0.CB_1.config_dataB\[14\] _03384_ _03403_ vssd1 vssd1 vccd1 vccd1 _03412_
+ sky130_fd_sc_hd__nand3_1
XFILLER_11_408 vssd1 vssd1 vccd1 vccd1 sky130_fd_sc_hd__fill_1
XFILLER_23_27 vccd1 vssd1 vccd1 vssd1 sky130_ef_sc_hd__decap_40_12
XFILLER_23_279 vssd1 vssd1 vccd1 vccd1 sky130_fd_sc_hd__fill_1
XFILLER_139_27 vccd1 vssd1 vccd1 vssd1 sky130_ef_sc_hd__decap_40_12
X_07325_ bus3_2\[12\] _02380_ _02381_ vssd1 vssd1 vccd1 vccd1 _02382_ sky130_fd_sc_hd__a21o_1
XFILLER_128_9 vccd1 vssd1 vccd1 vssd1 sky130_ef_sc_hd__decap_40_12
X_07256_ _02000_ _02096_ net35 vssd1 vssd1 vccd1 vccd1 _02315_ sky130_fd_sc_hd__a21o_1
XFILLER_133_811 vssd1 vssd1 vccd1 vccd1 sky130_fd_sc_hd__fill_8
X_07187_ _01919_ _02097_ vssd1 vssd1 vccd1 vccd1 _02248_ sky130_fd_sc_hd__nor2_1
XFILLER_3_629 vccd1 vssd1 vccd1 vssd1 sky130_ef_sc_hd__decap_40_12
XFILLER_105_546 vssd1 vssd1 vccd1 vccd1 sky130_fd_sc_hd__fill_1
XTAP_TAPCELL_ROW_6_401 vssd1 vccd1 sky130_fd_sc_hd__tapvpwrvgnd_1
XFILLER_2_139 vssd1 vssd1 vccd1 vccd1 sky130_fd_sc_hd__fill_1
Xfanout432 cell2.CB_0.config_dataB\[5\] vssd1 vssd1 vccd1 vccd1 net432 sky130_fd_sc_hd__clkbuf_2
XFILLER_132_365 vssd1 vssd1 vccd1 vccd1 sky130_fd_sc_hd__fill_1
Xfanout421 net422 vssd1 vssd1 vccd1 vccd1 net421 sky130_fd_sc_hd__clkbuf_2
Xfanout410 cell2.CB_1.config_dataB\[0\] vssd1 vssd1 vccd1 vccd1 net410 sky130_fd_sc_hd__dlymetal6s2s_1
XANTENNA__09236__X _04263_ vssd1 vssd1 vccd1 vccd1 sky130_fd_sc_hd__diode_2
XFILLER_78_419 vssd1 vssd1 vccd1 vccd1 sky130_fd_sc_hd__fill_1
XANTENNA_input9_X net9 vssd1 vssd1 vccd1 vccd1 sky130_fd_sc_hd__diode_2
XANTENNA_fanout952_A net959 vssd1 vssd1 vccd1 vccd1 sky130_fd_sc_hd__diode_2
Xfanout443 cell2.CB_1.config_dataA\[6\] vssd1 vssd1 vccd1 vccd1 net443 sky130_fd_sc_hd__buf_2
XFILLER_59_655 vssd1 vssd1 vccd1 vccd1 sky130_fd_sc_hd__fill_1
Xfanout465 cell1.CB_0.config_dataA\[15\] vssd1 vssd1 vccd1 vccd1 net465 sky130_fd_sc_hd__clkbuf_2
Xfanout454 cell1.CB_1.config_dataB\[11\] vssd1 vssd1 vccd1 vccd1 net454 sky130_fd_sc_hd__buf_2
XPHY_EDGE_ROW_122_Right_122 vssd1 vssd1 vccd1 vccd1 sky130_fd_sc_hd__decap_3
X_09828_ net441 _04696_ _04833_ net440 vssd1 vssd1 vccd1 vccd1 _04834_ sky130_fd_sc_hd__o211a_1
Xfanout476 cell1.CB_0.config_dataB\[15\] vssd1 vssd1 vccd1 vccd1 net476 sky130_fd_sc_hd__buf_2
Xfanout498 cell1.CB_1.config_dataA\[0\] vssd1 vssd1 vccd1 vccd1 net498 sky130_fd_sc_hd__clkbuf_2
Xfanout487 cell1.CB_1.config_dataA\[16\] vssd1 vssd1 vccd1 vccd1 net487 sky130_fd_sc_hd__buf_2
X_09759_ net445 _04696_ cell2.CB_1.config_dataA\[6\] vssd1 vssd1 vccd1 vccd1 _04765_
+ sky130_fd_sc_hd__o21ai_1
XFILLER_73_113 vssd1 vssd1 vccd1 vccd1 sky130_fd_sc_hd__fill_1
XFILLER_104_85 vssd1 vssd1 vccd1 vccd1 sky130_fd_sc_hd__fill_4
XANTENNA__08794__Y _03826_ vssd1 vssd1 vccd1 vccd1 sky130_fd_sc_hd__diode_2
X_12770_ cell2.SB0.route_sel\[12\] cell2.SB0.route_sel\[11\] net829 vssd1 vssd1 vccd1
+ vccd1 _01199_ sky130_fd_sc_hd__mux2_1
XANTENNA_input116_A SBwest_in[27] vssd1 vssd1 vccd1 vccd1 sky130_fd_sc_hd__diode_2
XANTENNA__12094__A2 net550 vssd1 vssd1 vccd1 vccd1 sky130_fd_sc_hd__diode_2
XFILLER_42_511 vssd1 vssd1 vccd1 vccd1 sky130_fd_sc_hd__fill_1
X_11721_ cell0.LE_0B.edge_mode cell0.LE_0B.config_data\[16\] net796 vssd1 vssd1 vccd1
+ vccd1 _00160_ sky130_fd_sc_hd__mux2_1
X_14440_ clknet_leaf_59_clk _01412_ net734 vssd1 vssd1 vccd1 vccd1 cell3.LEI0.config_data\[5\]
+ sky130_fd_sc_hd__dfrtp_1
X_11652_ cell0.CB_0.config_dataA\[23\] cell0.CB_0.config_dataA\[22\] net777 vssd1
+ vssd1 vccd1 vccd1 _00093_ sky130_fd_sc_hd__mux2_1
X_14371_ clknet_leaf_65_clk _01343_ net744 vssd1 vssd1 vccd1 vccd1 cell3.LE_1A.config_data\[2\]
+ sky130_fd_sc_hd__dfrtp_1
X_10603_ cell3.CB_1.config_dataA\[9\] _05516_ _05557_ _05560_ vssd1 vssd1 vccd1 vccd1
+ _05561_ sky130_fd_sc_hd__o31a_1
XANTENNA__09798__A1 bus3_2\[9\] vssd1 vssd1 vccd1 vccd1 sky130_fd_sc_hd__diode_2
XFILLER_80_77 vssd1 vssd1 vccd1 vccd1 sky130_fd_sc_hd__fill_4
X_13322_ clknet_leaf_89_clk _00294_ net689 vssd1 vssd1 vccd1 vccd1 cell1.CB_0.config_dataB\[13\]
+ sky130_fd_sc_hd__dfstp_1
X_11583_ cell0.CB_1.config_dataA\[4\] cell0.CB_1.config_dataA\[3\] net788 vssd1 vssd1
+ vccd1 vccd1 _00024_ sky130_fd_sc_hd__mux2_1
XANTENNA_input81_A SBsouth_in[24] vssd1 vssd1 vccd1 vccd1 sky130_fd_sc_hd__diode_2
XFILLER_109_841 vssd1 vssd1 vccd1 vccd1 sky130_fd_sc_hd__fill_1
X_10534_ _05483_ _05486_ _05489_ _05491_ cell3.CB_1.config_dataA\[7\] vssd1 vssd1
+ vccd1 vccd1 _05492_ sky130_fd_sc_hd__o221a_1
XFILLER_6_434 vccd1 vssd1 vccd1 vssd1 sky130_ef_sc_hd__decap_40_12
XFILLER_124_811 vssd1 vssd1 vccd1 vccd1 sky130_fd_sc_hd__fill_1
X_10465_ _04662_ _05450_ vssd1 vssd1 vccd1 vccd1 bus3_2\[12\] sky130_fd_sc_hd__and2_2
XTAP_TAPCELL_ROW_94_1722 vssd1 vccd1 sky130_fd_sc_hd__tapvpwrvgnd_1
XTAP_TAPCELL_ROW_94_1711 vssd1 vccd1 sky130_fd_sc_hd__tapvpwrvgnd_1
X_13253_ clknet_leaf_11_clk _00225_ net586 vssd1 vssd1 vccd1 vccd1 cell0.LEI0.config_data\[38\]
+ sky130_fd_sc_hd__dfrtp_1
X_10396_ _05393_ _05394_ _01761_ vssd1 vssd1 vccd1 vccd1 _05395_ sky130_fd_sc_hd__mux2_1
X_12204_ cell2.CB_1.config_dataA\[17\] net437 net834 vssd1 vssd1 vccd1 vccd1 _00637_
+ sky130_fd_sc_hd__mux2_1
X_13184_ clknet_leaf_13_clk net1255 net600 vssd1 vssd1 vccd1 vccd1 cell0.LE_0B.config_data\[13\]
+ sky130_fd_sc_hd__dfrtp_1
XANTENNA_output168_A net168 vssd1 vssd1 vccd1 vccd1 sky130_fd_sc_hd__diode_2
X_12135_ net1064 net1140 net896 vssd1 vssd1 vccd1 vccd1 _00568_ sky130_fd_sc_hd__mux2_1
XFILLER_123_365 vssd1 vssd1 vccd1 vccd1 sky130_fd_sc_hd__fill_1
XANTENNA__09146__X _04174_ vssd1 vssd1 vccd1 vccd1 sky130_fd_sc_hd__diode_2
XFILLER_1_161 vssd1 vssd1 vccd1 vccd1 sky130_fd_sc_hd__fill_4
X_12066_ cell1.LE_1A.edge_mode cell1.LE_1A.config_data\[16\] net903 vssd1 vssd1 vccd1
+ vccd1 _00502_ sky130_fd_sc_hd__mux2_1
X_11017_ _05874_ _05871_ cell3.CB_0.config_dataA\[10\] vssd1 vssd1 vccd1 vccd1 _05971_
+ sky130_fd_sc_hd__mux2_1
XTAP_TAPCELL_ROW_121_2118 vssd1 vccd1 sky130_fd_sc_hd__tapvpwrvgnd_1
XANTENNA__10669__A_N _05513_ vssd1 vssd1 vccd1 vccd1 sky130_fd_sc_hd__diode_2
X_12968_ net1150 net1107 net928 vssd1 vssd1 vccd1 vccd1 _01396_ sky130_fd_sc_hd__mux2_1
XTAP_TAPCELL_ROW_121_2129 vssd1 vccd1 sky130_fd_sc_hd__tapvpwrvgnd_1
XFILLER_18_563 vssd1 vssd1 vccd1 vccd1 sky130_fd_sc_hd__fill_1
XFILLER_18_585 vssd1 vssd1 vccd1 vccd1 sky130_fd_sc_hd__fill_2
X_12899_ cell3.CB_1.config_dataB\[13\] cell3.CB_1.config_dataB\[12\] net941 vssd1
+ vssd1 vccd1 vccd1 _01328_ sky130_fd_sc_hd__mux2_1
X_11919_ cell0.SB0.route_sel\[25\] cell0.SB0.route_sel\[24\] net760 vssd1 vssd1 vccd1
+ vccd1 _00356_ sky130_fd_sc_hd__mux2_1
XANTENNA_clkbuf_leaf_0_clk_A clknet_4_0_0_clk vssd1 vssd1 vccd1 vccd1 sky130_fd_sc_hd__diode_2
XTAP_TAPCELL_ROW_103_1851 vssd1 vccd1 sky130_fd_sc_hd__tapvpwrvgnd_1
XFILLER_21_706 vssd1 vssd1 vccd1 vccd1 sky130_fd_sc_hd__fill_1
XANTENNA__09789__A1 bus3_2\[14\] vssd1 vssd1 vccd1 vccd1 sky130_fd_sc_hd__diode_2
XFILLER_20_216 vssd1 vssd1 vccd1 vccd1 sky130_fd_sc_hd__fill_1
X_07110_ _02126_ _02132_ _02171_ vssd1 vssd1 vccd1 vccd1 _02173_ sky130_fd_sc_hd__or3_1
XTAP_TAPCELL_ROW_31_767 vssd1 vccd1 sky130_fd_sc_hd__tapvpwrvgnd_1
XTAP_TAPCELL_ROW_31_778 vssd1 vccd1 sky130_fd_sc_hd__tapvpwrvgnd_1
XTAP_TAPCELL_ROW_136_2350 vssd1 vccd1 sky130_fd_sc_hd__tapvpwrvgnd_1
X_08090_ cell0.CB_0.config_dataB\[18\] cell0.CB_0.config_dataB\[17\] vssd1 vssd1 vccd1
+ vccd1 _03132_ sky130_fd_sc_hd__or2_1
Xclkload20 clknet_leaf_133_clk vssd1 vssd1 vccd1 vccd1 clkload20/Y sky130_fd_sc_hd__bufinv_16
Xclkload53 clknet_leaf_30_clk vssd1 vssd1 vccd1 vccd1 clkload53/Y sky130_fd_sc_hd__clkinv_4
X_07041_ _02079_ _02080_ _02093_ _02105_ net551 vssd1 vssd1 vccd1 vccd1 _02106_ sky130_fd_sc_hd__o311a_4
Xclkload42 clknet_leaf_122_clk vssd1 vssd1 vccd1 vccd1 clkload42/Y sky130_fd_sc_hd__clkinv_8
XTAP_TAPCELL_ROW_11_480 vssd1 vccd1 sky130_fd_sc_hd__tapvpwrvgnd_1
Xclkload31 clknet_leaf_125_clk vssd1 vssd1 vccd1 vccd1 clkload31/Y sky130_fd_sc_hd__inv_6
Xclkload64 clknet_leaf_35_clk vssd1 vssd1 vccd1 vccd1 clkload64/Y sky130_fd_sc_hd__inv_8
XFILLER_127_671 vssd1 vssd1 vccd1 vccd1 sky130_fd_sc_hd__fill_1
XFILLER_114_321 vssd1 vssd1 vccd1 vccd1 sky130_fd_sc_hd__fill_1
XANTENNA__09410__B1 _02839_ vssd1 vssd1 vccd1 vccd1 sky130_fd_sc_hd__diode_2
Xclkload75 clknet_leaf_110_clk vssd1 vssd1 vccd1 vccd1 clkload75/Y sky130_fd_sc_hd__inv_6
Xclkload86 clknet_leaf_97_clk vssd1 vssd1 vccd1 vccd1 clkload86/Y sky130_fd_sc_hd__inv_6
Xclkload97 clknet_leaf_91_clk vssd1 vssd1 vccd1 vccd1 clkload97/Y sky130_fd_sc_hd__inv_4
XANTENNA__08764__A2 net336 vssd1 vssd1 vccd1 vccd1 sky130_fd_sc_hd__diode_2
X_08992_ bus3_1\[0\] bus3_1\[1\] bus3_1\[2\] bus3_1\[3\] net482 net481 vssd1 vssd1
+ vccd1 vccd1 _04022_ sky130_fd_sc_hd__mux4_1
XFILLER_130_847 vssd1 vssd1 vccd1 vccd1 sky130_fd_sc_hd__fill_1
X_07943_ bus2_0\[4\] _02983_ _02984_ bus2_0\[5\] cell0.CB_0.config_dataA\[18\] vssd1
+ vssd1 vccd1 vccd1 _02987_ sky130_fd_sc_hd__a221o_1
XANTENNA__09713__A1 net262 vssd1 vssd1 vccd1 vccd1 sky130_fd_sc_hd__diode_2
XFILLER_68_474 vssd1 vssd1 vccd1 vccd1 sky130_fd_sc_hd__fill_2
X_07874_ net522 _01986_ vssd1 vssd1 vccd1 vccd1 _02918_ sky130_fd_sc_hd__nand2_1
XANTENNA__08516__A2 net23 vssd1 vssd1 vccd1 vccd1 sky130_fd_sc_hd__diode_2
X_09613_ net552 _04629_ vssd1 vssd1 vccd1 vccd1 _04630_ sky130_fd_sc_hd__nand2_1
XFILLER_55_113 vssd1 vssd1 vccd1 vccd1 sky130_fd_sc_hd__fill_1
X_06825_ _01894_ net329 _01886_ vssd1 vssd1 vccd1 vccd1 _01895_ sky130_fd_sc_hd__mux2_1
XANTENNA__07724__B1 _02770_ vssd1 vssd1 vccd1 vccd1 sky130_fd_sc_hd__diode_2
XFILLER_141_39 vccd1 vssd1 vccd1 vssd1 sky130_ef_sc_hd__decap_40_12
XFILLER_43_308 vssd1 vssd1 vccd1 vccd1 sky130_fd_sc_hd__fill_1
XFILLER_83_477 vssd1 vssd1 vccd1 vccd1 sky130_fd_sc_hd__fill_1
X_06756_ net289 vssd1 vssd1 vccd1 vccd1 _01826_ sky130_fd_sc_hd__inv_2
X_09544_ _04559_ _04561_ _04562_ vssd1 vssd1 vccd1 vccd1 _04563_ sky130_fd_sc_hd__a21oi_1
XFILLER_71_628 vssd1 vssd1 vccd1 vccd1 sky130_fd_sc_hd__fill_1
XTAP_TAPCELL_ROW_39_889 vssd1 vccd1 sky130_fd_sc_hd__tapvpwrvgnd_1
X_06687_ cell2.CB_0.config_dataB\[7\] vssd1 vssd1 vccd1 vccd1 _01757_ sky130_fd_sc_hd__inv_2
X_09475_ _01617_ cell2.SB0.route_sel\[63\] cell2.SB0.route_sel\[60\] cell2.SB0.route_sel\[61\]
+ _04495_ vssd1 vssd1 vccd1 vccd1 _04496_ sky130_fd_sc_hd__o221a_1
XTAP_TAPCELL_ROW_19_591 vssd1 vccd1 sky130_fd_sc_hd__tapvpwrvgnd_1
XFILLER_34_26 vssd1 vssd1 vccd1 vccd1 sky130_fd_sc_hd__fill_2
XANTENNA__09229__B1 _04255_ vssd1 vssd1 vccd1 vccd1 sky130_fd_sc_hd__diode_2
X_08426_ cell0.LE_1B.config_data\[16\] _03461_ _03462_ net351 vssd1 vssd1 vccd1 vccd1
+ cell0.CB_1.le_outB sky130_fd_sc_hd__o211a_2
XANTENNA_fanout700_A net750 vssd1 vssd1 vccd1 vccd1 sky130_fd_sc_hd__diode_2
Xclkload3 clknet_4_3_0_clk vssd1 vssd1 vccd1 vccd1 clkload3/Y sky130_fd_sc_hd__clkinvlp_4
X_08357_ _03394_ _03390_ cell0.CB_1.config_dataB\[13\] vssd1 vssd1 vccd1 vccd1 _03395_
+ sky130_fd_sc_hd__or3b_1
X_07308_ _02057_ _02365_ vssd1 vssd1 vccd1 vccd1 _02366_ sky130_fd_sc_hd__or2_1
X_08288_ _03325_ _03321_ cell0.CB_1.config_dataB\[8\] vssd1 vssd1 vccd1 vccd1 _03326_
+ sky130_fd_sc_hd__or3b_1
X_07239_ cell0.SB0.route_sel\[94\] cell0.SB0.route_sel\[95\] vssd1 vssd1 vccd1 vccd1
+ _02298_ sky130_fd_sc_hd__nand2b_1
XANTENNA__11002__A _05924_ vssd1 vssd1 vccd1 vccd1 sky130_fd_sc_hd__diode_2
X_10250_ net412 _05107_ _05250_ net411 vssd1 vssd1 vccd1 vccd1 _05251_ sky130_fd_sc_hd__o211a_1
XTAP_TAPCELL_ROW_76_1452 vssd1 vccd1 sky130_fd_sc_hd__tapvpwrvgnd_1
XTAP_TAPCELL_ROW_76_1441 vssd1 vccd1 sky130_fd_sc_hd__tapvpwrvgnd_1
XFILLER_105_343 vssd1 vssd1 vccd1 vccd1 sky130_fd_sc_hd__fill_1
XFILLER_79_717 vssd1 vssd1 vccd1 vccd1 sky130_fd_sc_hd__fill_1
XANTENNA__07693__Y bus1_0\[2\] vssd1 vssd1 vccd1 vccd1 sky130_fd_sc_hd__diode_2
X_10181_ net421 _05103_ vssd1 vssd1 vccd1 vccd1 _05182_ sky130_fd_sc_hd__nand2_1
XFILLER_121_847 vssd1 vssd1 vccd1 vccd1 sky130_fd_sc_hd__fill_1
X_13940_ clknet_leaf_34_clk _00912_ net636 vssd1 vssd1 vccd1 vccd1 cell2.LE_0A.reset_mode
+ sky130_fd_sc_hd__dfrtp_1
XFILLER_115_51 vssd1 vssd1 vccd1 vccd1 sky130_fd_sc_hd__fill_1
XFILLER_87_783 vssd1 vssd1 vccd1 vccd1 sky130_fd_sc_hd__fill_1
Xfanout284 cell3.CB_0.le_outA vssd1 vssd1 vccd1 vccd1 net284 sky130_fd_sc_hd__buf_1
Xfanout295 net296 vssd1 vssd1 vccd1 vccd1 net295 sky130_fd_sc_hd__buf_2
XFILLER_75_55 vssd1 vssd1 vccd1 vccd1 sky130_fd_sc_hd__fill_1
X_13871_ clknet_leaf_17_clk _00843_ net625 vssd1 vssd1 vccd1 vccd1 cell2.CB_1.config_dataB\[20\]
+ sky130_fd_sc_hd__dfstp_2
X_12822_ cell2.SB0.route_sel\[64\] cell2.SB0.route_sel\[63\] net809 vssd1 vssd1 vccd1
+ vccd1 _01251_ sky130_fd_sc_hd__mux2_1
XFILLER_62_628 vssd1 vssd1 vccd1 vccd1 sky130_fd_sc_hd__fill_1
XANTENNA__06766__A bus3_1\[4\] vssd1 vssd1 vccd1 vccd1 sky130_fd_sc_hd__diode_2
XANTENNA_input119_X net119 vssd1 vssd1 vccd1 vccd1 sky130_fd_sc_hd__diode_2
X_12753_ cell3.CB_0.config_dataA\[20\] cell3.CB_0.config_dataA\[19\] net932 vssd1
+ vssd1 vccd1 vccd1 _01182_ sky130_fd_sc_hd__mux2_1
X_11704_ net1301 cell0.LE_1B.reset_mode net803 vssd1 vssd1 vccd1 vccd1 _00143_ sky130_fd_sc_hd__mux2_1
XFILLER_42_363 vssd1 vssd1 vccd1 vccd1 sky130_fd_sc_hd__fill_1
X_14423_ clknet_leaf_38_clk net1108 net718 vssd1 vssd1 vccd1 vccd1 cell3.LE_0A.config_data\[10\]
+ sky130_fd_sc_hd__dfrtp_1
X_12684_ net397 net398 net937 vssd1 vssd1 vccd1 vccd1 _01113_ sky130_fd_sc_hd__mux2_1
XFILLER_42_385 vssd1 vssd1 vccd1 vccd1 sky130_fd_sc_hd__fill_1
XANTENNA__12707__S net936 vssd1 vssd1 vccd1 vccd1 sky130_fd_sc_hd__diode_2
XANTENNA__11611__S net773 vssd1 vssd1 vccd1 vccd1 sky130_fd_sc_hd__diode_2
X_11635_ net517 net518 net771 vssd1 vssd1 vccd1 vccd1 _00076_ sky130_fd_sc_hd__mux2_1
XFILLER_30_569 vssd1 vssd1 vccd1 vccd1 sky130_fd_sc_hd__fill_1
X_14354_ clknet_leaf_70_clk _01326_ net730 vssd1 vssd1 vccd1 vccd1 cell3.CB_1.config_dataB\[11\]
+ sky130_fd_sc_hd__dfstp_1
XANTENNA__07597__A net330 vssd1 vssd1 vccd1 vccd1 sky130_fd_sc_hd__diode_2
X_11566_ net1259 net1188 net802 vssd1 vssd1 vccd1 vccd1 _00007_ sky130_fd_sc_hd__mux2_1
XFILLER_7_721 vssd1 vssd1 vccd1 vccd1 sky130_fd_sc_hd__fill_4
XANTENNA_input84_X net84 vssd1 vssd1 vccd1 vccd1 sky130_fd_sc_hd__diode_2
XFILLER_11_794 vssd1 vssd1 vccd1 vccd1 sky130_fd_sc_hd__fill_1
XANTENNA__08443__A1 _03473_ vssd1 vssd1 vccd1 vccd1 sky130_fd_sc_hd__diode_2
XTAP_TAPCELL_ROW_118_2080 vssd1 vccd1 sky130_fd_sc_hd__tapvpwrvgnd_1
X_10517_ _04506_ _04513_ _04520_ _05474_ vssd1 vssd1 vccd1 vccd1 _05475_ sky130_fd_sc_hd__a211o_4
X_14285_ clknet_leaf_21_clk _01257_ net610 vssd1 vssd1 vccd1 vccd1 cell2.SB0.route_sel\[70\]
+ sky130_fd_sc_hd__dfstp_1
XANTENNA__08994__A2 _03858_ vssd1 vssd1 vccd1 vccd1 sky130_fd_sc_hd__diode_2
XFILLER_6_242 vssd1 vssd1 vccd1 vccd1 sky130_fd_sc_hd__fill_1
X_13305_ clknet_leaf_102_clk _00277_ net676 vssd1 vssd1 vccd1 vccd1 cell1.CB_1.config_dataA\[21\]
+ sky130_fd_sc_hd__dfstp_1
XFILLER_109_671 vssd1 vssd1 vccd1 vccd1 sky130_fd_sc_hd__fill_1
X_11497_ cell2.SB0.route_sel\[24\] cell2.SB0.route_sel\[25\] _01596_ cell2.SB0.route_sel\[28\]
+ _06331_ vssd1 vssd1 vccd1 vccd1 _06332_ sky130_fd_sc_hd__o221a_1
X_13236_ clknet_leaf_122_clk _00208_ net587 vssd1 vssd1 vccd1 vccd1 cell0.LEI0.config_data\[21\]
+ sky130_fd_sc_hd__dfrtp_1
XFILLER_7_787 vssd1 vssd1 vccd1 vccd1 sky130_fd_sc_hd__fill_1
X_10448_ _01714_ cell3.SB0.route_sel\[58\] vssd1 vssd1 vccd1 vccd1 _05439_ sky130_fd_sc_hd__nand2_1
X_10379_ cell2.CB_0.config_dataB\[14\] _05348_ _05356_ vssd1 vssd1 vccd1 vccd1 _05378_
+ sky130_fd_sc_hd__nand3_1
XTAP_TAPCELL_ROW_131_2280 vssd1 vccd1 sky130_fd_sc_hd__tapvpwrvgnd_1
XFILLER_97_503 vssd1 vssd1 vccd1 vccd1 sky130_fd_sc_hd__fill_1
X_13167_ clknet_leaf_118_clk _00139_ net598 vssd1 vssd1 vccd1 vccd1 cell0.LE_1A.reset_val
+ sky130_fd_sc_hd__dfrtp_1
XANTENNA__08746__A2 _03493_ vssd1 vssd1 vccd1 vccd1 sky130_fd_sc_hd__diode_2
XFILLER_112_847 vssd1 vssd1 vccd1 vccd1 sky130_fd_sc_hd__fill_1
XFILLER_111_335 vssd1 vssd1 vccd1 vccd1 sky130_fd_sc_hd__fill_1
X_12118_ net1494 cell1.LE_1A.reset_mode net904 vssd1 vssd1 vccd1 vccd1 _00551_ sky130_fd_sc_hd__mux2_1
X_13098_ clknet_leaf_4_clk _00070_ net564 vssd1 vssd1 vccd1 vccd1 cell0.CB_0.config_dataA\[0\]
+ sky130_fd_sc_hd__dfstp_1
X_12049_ net1327 cell1.LE_0B.reset_mode net889 vssd1 vssd1 vccd1 vccd1 _00485_ sky130_fd_sc_hd__mux2_1
XANTENNA__07182__A1 net303 vssd1 vssd1 vccd1 vccd1 sky130_fd_sc_hd__diode_2
X_06610_ cell1.LEI0.config_data\[26\] vssd1 vssd1 vccd1 vccd1 _01680_ sky130_fd_sc_hd__inv_2
X_07590_ cell1.CB_1.config_dataA\[23\] cell1.CB_1.config_dataA\[22\] vssd1 vssd1 vccd1
+ vccd1 _02640_ sky130_fd_sc_hd__or2_1
X_06541_ cell2.SB0.route_sel\[48\] vssd1 vssd1 vccd1 vccd1 _01611_ sky130_fd_sc_hd__inv_2
XTAP_TAPCELL_ROW_47_1020 vssd1 vccd1 sky130_fd_sc_hd__tapvpwrvgnd_1
XTAP_TAPCELL_ROW_36_848 vssd1 vccd1 sky130_fd_sc_hd__tapvpwrvgnd_1
X_09260_ cell2.SB0.route_sel\[21\] cell2.SB0.route_sel\[20\] vssd1 vssd1 vccd1 vccd1
+ _04286_ sky130_fd_sc_hd__nand2_1
XTAP_TAPCELL_ROW_16_550 vssd1 vccd1 sky130_fd_sc_hd__tapvpwrvgnd_1
XFILLER_21_503 vssd1 vssd1 vccd1 vccd1 sky130_fd_sc_hd__fill_1
X_06472_ cell1.SB0.route_sel\[100\] vssd1 vssd1 vccd1 vccd1 _01542_ sky130_fd_sc_hd__inv_2
X_08211_ net539 _01877_ _03250_ net538 vssd1 vssd1 vccd1 vccd1 _03251_ sky130_fd_sc_hd__o211a_1
X_09191_ cell3.CB_0.config_dataA\[22\] cell3.CB_0.config_dataA\[23\] vssd1 vssd1 vccd1
+ vccd1 _04219_ sky130_fd_sc_hd__or2_1
X_08142_ _02846_ _03167_ _03169_ _02807_ vssd1 vssd1 vccd1 vccd1 _03182_ sky130_fd_sc_hd__a22o_1
XANTENNA__10241__A1 _05136_ vssd1 vssd1 vccd1 vccd1 sky130_fd_sc_hd__diode_2
Xclkload131 clknet_leaf_67_clk vssd1 vssd1 vccd1 vccd1 clkload131/Y sky130_fd_sc_hd__inv_8
Xclkload120 clknet_leaf_74_clk vssd1 vssd1 vccd1 vccd1 clkload120/Y sky130_fd_sc_hd__clkinvlp_4
X_08073_ _03105_ _03109_ _03114_ _01559_ _03113_ vssd1 vssd1 vccd1 vccd1 _03115_ sky130_fd_sc_hd__a221o_1
XANTENNA__10792__A2 _05501_ vssd1 vssd1 vccd1 vccd1 sky130_fd_sc_hd__diode_2
X_07024_ _02087_ _02088_ vssd1 vssd1 vccd1 vccd1 _02089_ sky130_fd_sc_hd__or2_1
Xclkload142 clknet_1_1__leaf_cell1.LE_0B.sel_clk vssd1 vssd1 vccd1 vccd1 clkload142/X
+ sky130_fd_sc_hd__clkbuf_4
XTAP_TAPCELL_ROW_58_1171 vssd1 vccd1 sky130_fd_sc_hd__tapvpwrvgnd_1
XTAP_TAPCELL_ROW_58_1182 vssd1 vccd1 sky130_fd_sc_hd__tapvpwrvgnd_1
XANTENNA__08737__A2 _03465_ vssd1 vssd1 vccd1 vccd1 sky130_fd_sc_hd__diode_2
X_08975_ cell1.LE_0A.config_data\[3\] cell1.LE_0A.config_data\[2\] _03936_ vssd1 vssd1
+ vccd1 vccd1 _04007_ sky130_fd_sc_hd__mux2_1
XFILLER_0_429 vssd1 vssd1 vccd1 vccd1 sky130_fd_sc_hd__fill_1
XFILLER_29_15 vccd1 vssd1 vccd1 vssd1 sky130_ef_sc_hd__decap_40_12
Xhold15 cell3.LE_0B.dff0_out vssd1 vssd1 vccd1 vccd1 net974 sky130_fd_sc_hd__dlygate4sd3_1
Xhold26 _00852_ vssd1 vssd1 vccd1 vccd1 net985 sky130_fd_sc_hd__dlygate4sd3_1
XTAP_TAPCELL_ROW_71_1371 vssd1 vccd1 sky130_fd_sc_hd__tapvpwrvgnd_1
X_07926_ _02074_ _02951_ _02952_ _02172_ cell0.CB_0.config_dataA\[12\] vssd1 vssd1
+ vccd1 vccd1 _02970_ sky130_fd_sc_hd__a221o_1
XANTENNA__07960__A3 bus2_0\[11\] vssd1 vssd1 vccd1 vccd1 sky130_fd_sc_hd__diode_2
Xhold37 _00490_ vssd1 vssd1 vccd1 vccd1 net996 sky130_fd_sc_hd__dlygate4sd3_1
XFILLER_84_731 vssd1 vssd1 vccd1 vccd1 sky130_fd_sc_hd__fill_2
Xhold59 cell0.LE_0A.config_data\[13\] vssd1 vssd1 vccd1 vccd1 net1018 sky130_fd_sc_hd__dlygate4sd3_1
Xhold48 cell1.LE_1A.config_data\[14\] vssd1 vssd1 vccd1 vccd1 net1007 sky130_fd_sc_hd__dlygate4sd3_1
XANTENNA_fanout748_A net749 vssd1 vssd1 vccd1 vccd1 sky130_fd_sc_hd__diode_2
XANTENNA_fanout650_A net133 vssd1 vssd1 vccd1 vccd1 sky130_fd_sc_hd__diode_2
X_07857_ cell0.SB0.route_sel\[3\] cell0.SB0.route_sel\[2\] _01578_ cell0.SB0.route_sel\[5\]
+ _02900_ vssd1 vssd1 vccd1 vccd1 _02901_ sky130_fd_sc_hd__o221a_2
XANTENNA__09233__Y _04260_ vssd1 vssd1 vccd1 vccd1 sky130_fd_sc_hd__diode_2
XFILLER_83_285 vssd1 vssd1 vccd1 vccd1 sky130_fd_sc_hd__fill_2
X_07788_ _01863_ _02121_ vssd1 vssd1 vccd1 vccd1 _02833_ sky130_fd_sc_hd__nor2_1
X_06808_ net361 net360 net299 _01876_ vssd1 vssd1 vccd1 vccd1 _01878_ sky130_fd_sc_hd__o211ai_2
X_06739_ cell3.CB_0.config_dataA\[7\] vssd1 vssd1 vccd1 vccd1 _01809_ sky130_fd_sc_hd__inv_2
X_09527_ net49 net278 _04544_ vssd1 vssd1 vccd1 vccd1 _04547_ sky130_fd_sc_hd__mux2_1
XFILLER_24_363 vssd1 vssd1 vccd1 vccd1 sky130_fd_sc_hd__fill_1
X_09458_ _01826_ _04479_ vssd1 vssd1 vccd1 vccd1 _04480_ sky130_fd_sc_hd__and2_1
XFILLER_24_396 vssd1 vssd1 vccd1 vccd1 sky130_fd_sc_hd__fill_1
X_09389_ _04215_ _04412_ vssd1 vssd1 vccd1 vccd1 _04413_ sky130_fd_sc_hd__nor2_1
X_08409_ net344 net347 cell0.CB_1.le_outA cell0.CB_1.le_outB cell0.LEI0.config_data\[45\]
+ cell0.LEI0.config_data\[46\] vssd1 vssd1 vccd1 vccd1 _03447_ sky130_fd_sc_hd__mux4_1
X_11420_ _02346_ _06280_ vssd1 vssd1 vccd1 vccd1 net233 sky130_fd_sc_hd__and2_2
X_11351_ _04662_ _05855_ _04655_ vssd1 vssd1 vccd1 vccd1 _06241_ sky130_fd_sc_hd__a21o_1
X_10302_ net63 net64 net34 net35 net432 net430 vssd1 vssd1 vccd1 vccd1 _05301_ sky130_fd_sc_hd__mux4_1
XFILLER_4_713 vccd1 vssd1 vccd1 vssd1 sky130_ef_sc_hd__decap_40_12
X_11282_ _06209_ net309 _02533_ vssd1 vssd1 vccd1 vccd1 net171 sky130_fd_sc_hd__mux2_2
X_14070_ clknet_leaf_14_clk _01042_ net629 vssd1 vssd1 vccd1 vccd1 cell3.SB0.route_sel\[78\]
+ sky130_fd_sc_hd__dfstp_1
XFILLER_4_757 vccd1 vssd1 vccd1 vssd1 sky130_ef_sc_hd__decap_40_12
XFILLER_3_223 vssd1 vssd1 vccd1 vccd1 sky130_fd_sc_hd__fill_1
XANTENNA__08189__A0 net342 vssd1 vssd1 vccd1 vccd1 sky130_fd_sc_hd__diode_2
X_13021_ net1381 net1469 net949 vssd1 vssd1 vccd1 vccd1 _01449_ sky130_fd_sc_hd__mux2_1
X_10233_ net412 _05148_ vssd1 vssd1 vccd1 vccd1 _05234_ sky130_fd_sc_hd__or2_1
XANTENNA_input44_A CBnorth_in[1] vssd1 vssd1 vccd1 vccd1 sky130_fd_sc_hd__diode_2
X_10164_ net421 _05128_ vssd1 vssd1 vccd1 vccd1 _05165_ sky130_fd_sc_hd__nand2_1
XFILLER_86_21 vssd1 vssd1 vccd1 vccd1 sky130_fd_sc_hd__fill_4
XFILLER_10_83 vssd1 vssd1 vccd1 vccd1 sky130_fd_sc_hd__fill_1
XFILLER_94_517 vssd1 vssd1 vccd1 vccd1 sky130_fd_sc_hd__fill_2
XFILLER_86_98 vssd1 vssd1 vccd1 vccd1 sky130_fd_sc_hd__fill_1
X_10095_ _01621_ cell2.SB0.route_sel\[71\] _01623_ cell2.SB0.route_sel\[68\] _05095_
+ vssd1 vssd1 vccd1 vccd1 _05096_ sky130_fd_sc_hd__a221o_2
XANTENNA__10299__B2 _05111_ vssd1 vssd1 vccd1 vccd1 sky130_fd_sc_hd__diode_2
X_13923_ clknet_leaf_25_clk _00895_ net608 vssd1 vssd1 vccd1 vccd1 cell2.LE_0A.config_data\[2\]
+ sky130_fd_sc_hd__dfrtp_1
XTAP_TAPCELL_ROW_89_1643 vssd1 vccd1 sky130_fd_sc_hd__tapvpwrvgnd_1
XFILLER_75_742 vssd1 vssd1 vccd1 vccd1 sky130_fd_sc_hd__fill_1
XFILLER_59_293 vssd1 vssd1 vccd1 vccd1 sky130_fd_sc_hd__fill_1
X_13854_ clknet_leaf_45_clk _00826_ net630 vssd1 vssd1 vccd1 vccd1 cell2.CB_1.config_dataB\[3\]
+ sky130_fd_sc_hd__dfstp_1
XFILLER_35_617 vssd1 vssd1 vccd1 vccd1 sky130_fd_sc_hd__fill_1
X_12805_ cell2.SB0.route_sel\[47\] cell2.SB0.route_sel\[46\] net812 vssd1 vssd1 vccd1
+ vccd1 _01234_ sky130_fd_sc_hd__mux2_1
XANTENNA_output200_A net200 vssd1 vssd1 vccd1 vccd1 sky130_fd_sc_hd__diode_2
X_10997_ net47 net48 net377 vssd1 vssd1 vccd1 vccd1 _05951_ sky130_fd_sc_hd__mux2_1
X_13785_ clknet_leaf_109_clk _00757_ net651 vssd1 vssd1 vccd1 vccd1 cell1.SB0.route_sel\[62\]
+ sky130_fd_sc_hd__dfstp_1
XTAP_TAPCELL_ROW_33_807 vssd1 vccd1 sky130_fd_sc_hd__tapvpwrvgnd_1
XANTENNA__12460__A2 net549 vssd1 vssd1 vccd1 vccd1 sky130_fd_sc_hd__diode_2
X_12736_ cell3.CB_0.config_dataA\[3\] cell3.CB_0.config_dataA\[2\] net924 vssd1 vssd1
+ vccd1 vccd1 _01165_ sky130_fd_sc_hd__mux2_1
XTAP_TAPCELL_ROW_100_1810 vssd1 vccd1 sky130_fd_sc_hd__tapvpwrvgnd_1
X_12667_ net1313 cell3.LE_1B.config_data\[3\] net958 vssd1 vssd1 vccd1 vccd1 _01096_
+ sky130_fd_sc_hd__mux2_1
X_14406_ clknet_leaf_61_clk _01378_ net739 vssd1 vssd1 vccd1 vccd1 cell3.LE_0B.config_data\[15\]
+ sky130_fd_sc_hd__dfrtp_1
XANTENNA__11015__A3 net57 vssd1 vssd1 vccd1 vccd1 sky130_fd_sc_hd__diode_2
X_11618_ cell0.CB_0.config_dataB\[14\] cell0.CB_0.config_dataB\[13\] net769 vssd1
+ vssd1 vccd1 vccd1 _00059_ sky130_fd_sc_hd__mux2_1
X_14337_ clknet_leaf_18_clk _01309_ net614 vssd1 vssd1 vccd1 vccd1 cell2.SB0.route_sel\[122\]
+ sky130_fd_sc_hd__dfstp_1
X_12598_ cell3.SB0.route_sel\[63\] cell3.SB0.route_sel\[62\] net834 vssd1 vssd1 vccd1
+ vccd1 _01027_ sky130_fd_sc_hd__mux2_1
Xhold518 cell3.LEI0.config_data\[37\] vssd1 vssd1 vccd1 vccd1 net1477 sky130_fd_sc_hd__dlygate4sd3_1
XANTENNA__10774__A2 net19 vssd1 vssd1 vccd1 vccd1 sky130_fd_sc_hd__diode_2
Xhold507 cell0.LE_1B.config_data\[0\] vssd1 vssd1 vccd1 vccd1 net1466 sky130_fd_sc_hd__dlygate4sd3_1
X_11549_ _06366_ net265 vssd1 vssd1 vccd1 vccd1 net220 sky130_fd_sc_hd__and2b_1
Xhold529 cell3.LE_1A.config_data\[7\] vssd1 vssd1 vccd1 vccd1 net1488 sky130_fd_sc_hd__dlygate4sd3_1
X_14268_ clknet_leaf_24_clk _01240_ net606 vssd1 vssd1 vccd1 vccd1 cell2.SB0.route_sel\[53\]
+ sky130_fd_sc_hd__dfstp_1
X_14199_ clknet_leaf_54_clk _01171_ net716 vssd1 vssd1 vccd1 vccd1 cell3.CB_0.config_dataA\[9\]
+ sky130_fd_sc_hd__dfstp_1
XFILLER_112_600 vssd1 vssd1 vccd1 vccd1 sky130_fd_sc_hd__fill_2
X_13219_ clknet_leaf_13_clk net1491 net589 vssd1 vssd1 vccd1 vccd1 cell0.LEI0.config_data\[4\]
+ sky130_fd_sc_hd__dfrtp_1
XANTENNA__08222__Y _03262_ vssd1 vssd1 vccd1 vccd1 sky130_fd_sc_hd__diode_2
XANTENNA__08195__A3 bus1_0\[15\] vssd1 vssd1 vccd1 vccd1 sky130_fd_sc_hd__diode_2
XTAP_TAPCELL_ROW_111_1972 vssd1 vccd1 sky130_fd_sc_hd__tapvpwrvgnd_1
XFILLER_111_132 vssd1 vssd1 vccd1 vccd1 sky130_fd_sc_hd__fill_1
XFILLER_97_366 vssd1 vssd1 vccd1 vccd1 sky130_fd_sc_hd__fill_1
XANTENNA__07790__A _02834_ vssd1 vssd1 vccd1 vccd1 sky130_fd_sc_hd__diode_2
X_08760_ _03540_ _03772_ _03773_ _03537_ _01660_ vssd1 vssd1 vccd1 vccd1 _03794_ sky130_fd_sc_hd__a221o_1
XFILLER_65_241 vssd1 vssd1 vccd1 vccd1 sky130_fd_sc_hd__fill_1
X_08691_ cell1.CB_1.config_dataB\[1\] _03723_ _03724_ vssd1 vssd1 vccd1 vccd1 _03725_
+ sky130_fd_sc_hd__a21oi_1
X_07711_ _02744_ _02752_ _02757_ net760 vssd1 vssd1 vccd1 vccd1 _02758_ sky130_fd_sc_hd__a211oi_2
XANTENNA__07155__A1 net83 vssd1 vssd1 vccd1 vccd1 sky130_fd_sc_hd__diode_2
XFILLER_81_701 vssd1 vssd1 vccd1 vccd1 sky130_fd_sc_hd__fill_1
X_07642_ _02682_ _02683_ _02684_ _02690_ vssd1 vssd1 vccd1 vccd1 _02691_ sky130_fd_sc_hd__a31o_1
XFILLER_53_447 vssd1 vssd1 vccd1 vccd1 sky130_fd_sc_hd__fill_1
XFILLER_19_691 vssd1 vssd1 vccd1 vccd1 sky130_fd_sc_hd__fill_1
XFILLER_25_127 vssd1 vssd1 vccd1 vccd1 sky130_fd_sc_hd__fill_1
XFILLER_25_149 vssd1 vssd1 vccd1 vccd1 sky130_fd_sc_hd__fill_8
X_09312_ _01993_ _04176_ bus3_2\[3\] vssd1 vssd1 vccd1 vccd1 _04337_ sky130_fd_sc_hd__o21a_1
XFILLER_80_255 vssd1 vssd1 vccd1 vccd1 sky130_fd_sc_hd__fill_4
XANTENNA__07789__X _02834_ vssd1 vssd1 vccd1 vccd1 sky130_fd_sc_hd__diode_2
X_07573_ cell0.CB_0.config_dataB\[22\] cell0.CB_0.config_dataB\[23\] vssd1 vssd1 vccd1
+ vccd1 _02623_ sky130_fd_sc_hd__nor2_1
XFILLER_15_39 vccd1 vssd1 vccd1 vssd1 sky130_ef_sc_hd__decap_40_12
X_06524_ cell2.SB0.route_sel\[27\] vssd1 vssd1 vccd1 vccd1 _01594_ sky130_fd_sc_hd__inv_2
XANTENNA__08655__A1 net32 vssd1 vssd1 vccd1 vccd1 sky130_fd_sc_hd__diode_2
X_09243_ net278 net41 _04266_ vssd1 vssd1 vccd1 vccd1 _04270_ sky130_fd_sc_hd__mux2_1
X_06455_ cell1.SB0.route_sel\[66\] vssd1 vssd1 vccd1 vccd1 _01525_ sky130_fd_sc_hd__inv_2
Xclkbuf_1_0__f_cell0.LE_0A.sel_clk clknet_0_cell0.LE_0A.sel_clk vssd1 vssd1 vccd1
+ vccd1 clknet_1_0__leaf_cell0.LE_0A.sel_clk sky130_fd_sc_hd__clkbuf_16
XANTENNA_fanout329_A cell1.CB_0.le_outA vssd1 vssd1 vccd1 vccd1 sky130_fd_sc_hd__diode_2
X_09174_ _02061_ _02649_ _02655_ _03866_ vssd1 vssd1 vccd1 vccd1 _04202_ sky130_fd_sc_hd__a211o_1
X_06386_ cell0.SB0.route_sel\[48\] vssd1 vssd1 vccd1 vccd1 _01456_ sky130_fd_sc_hd__inv_2
XANTENNA__08958__A2 bus3_1\[14\] vssd1 vssd1 vccd1 vccd1 sky130_fd_sc_hd__diode_2
X_08125_ net546 _02277_ vssd1 vssd1 vccd1 vccd1 _03165_ sky130_fd_sc_hd__nand2_1
XFILLER_31_27 vccd1 vssd1 vccd1 vssd1 sky130_ef_sc_hd__decap_40_12
XFILLER_110_9 vccd1 vssd1 vccd1 vssd1 sky130_ef_sc_hd__decap_40_12
XTAP_TAPCELL_ROW_73_1400 vssd1 vccd1 sky130_fd_sc_hd__tapvpwrvgnd_1
X_08056_ bus2_0\[12\] bus2_0\[13\] bus2_0\[14\] bus2_0\[15\] net528 net526 vssd1 vssd1
+ vccd1 vccd1 _03098_ sky130_fd_sc_hd__mux4_1
XANTENNA__07630__A2 _02675_ vssd1 vssd1 vccd1 vccd1 sky130_fd_sc_hd__diode_2
XFILLER_103_600 vssd1 vssd1 vccd1 vccd1 sky130_fd_sc_hd__fill_1
XANTENNA_fanout698_A net700 vssd1 vssd1 vccd1 vccd1 sky130_fd_sc_hd__diode_2
X_07007_ cell0.SB0.route_sel\[70\] cell0.SB0.route_sel\[71\] vssd1 vssd1 vccd1 vccd1
+ _02072_ sky130_fd_sc_hd__nand2b_1
Xinput116 SBwest_in[27] vssd1 vssd1 vccd1 vccd1 net116 sky130_fd_sc_hd__buf_1
Xinput105 SBwest_in[17] vssd1 vssd1 vccd1 vccd1 net105 sky130_fd_sc_hd__dlymetal6s2s_1
XFILLER_0_259 vssd1 vssd1 vccd1 vccd1 sky130_fd_sc_hd__fill_2
Xinput127 SBwest_in[8] vssd1 vssd1 vccd1 vccd1 net127 sky130_fd_sc_hd__buf_1
X_08958_ bus3_1\[12\] bus3_1\[13\] bus3_1\[14\] bus3_1\[15\] net465 net463 vssd1 vssd1
+ vccd1 vccd1 _03990_ sky130_fd_sc_hd__mux4_1
XFILLER_29_422 vssd1 vssd1 vccd1 vccd1 sky130_fd_sc_hd__fill_1
XANTENNA__09244__X _04271_ vssd1 vssd1 vccd1 vccd1 sky130_fd_sc_hd__diode_2
X_08889_ net472 _03919_ _03920_ vssd1 vssd1 vccd1 vccd1 _03921_ sky130_fd_sc_hd__a21o_1
X_07909_ _02902_ _02951_ _02952_ _02905_ cell0.CB_0.config_dataA\[12\] vssd1 vssd1
+ vccd1 vccd1 _02953_ sky130_fd_sc_hd__a221o_1
X_10920_ _04589_ _04595_ _04601_ _05873_ vssd1 vssd1 vccd1 vccd1 _05874_ sky130_fd_sc_hd__a211o_2
XFILLER_17_617 vssd1 vssd1 vccd1 vccd1 sky130_fd_sc_hd__fill_1
XFILLER_112_41 vccd1 vssd1 vccd1 vssd1 sky130_ef_sc_hd__decap_40_12
X_10851_ net17 _05796_ _05798_ net18 cell3.CB_1.config_dataB\[17\] vssd1 vssd1 vccd1
+ vccd1 _05807_ sky130_fd_sc_hd__a221o_1
XTAP_TAPCELL_ROW_84_1562 vssd1 vccd1 sky130_fd_sc_hd__tapvpwrvgnd_1
X_10782_ _05475_ _05478_ _01780_ vssd1 vssd1 vccd1 vccd1 _05738_ sky130_fd_sc_hd__mux2_1
XTAP_TAPCELL_ROW_84_1573 vssd1 vccd1 sky130_fd_sc_hd__tapvpwrvgnd_1
X_13570_ clknet_leaf_82_clk _00542_ net670 vssd1 vssd1 vccd1 vccd1 cell1.LE_0A.config_data\[13\]
+ sky130_fd_sc_hd__dfrtp_1
X_12521_ net1529 cell2.LEI0.config_data\[34\] net838 vssd1 vssd1 vccd1 vccd1 _00950_
+ sky130_fd_sc_hd__mux2_1
XANTENNA_clkbuf_leaf_40_clk_A clknet_4_7_0_clk vssd1 vssd1 vccd1 vccd1 sky130_fd_sc_hd__diode_2
X_12452_ net1231 cell2.LE_0B.config_data\[11\] net842 vssd1 vssd1 vccd1 vccd1 _00883_
+ sky130_fd_sc_hd__mux2_1
XANTENNA__10205__A1 _02106_ vssd1 vssd1 vccd1 vccd1 sky130_fd_sc_hd__diode_2
X_11403_ cell0.SB0.route_sel\[81\] cell0.SB0.route_sel\[80\] vssd1 vssd1 vccd1 vccd1
+ _06269_ sky130_fd_sc_hd__nand2b_1
XANTENNA__10205__B2 _05093_ vssd1 vssd1 vccd1 vccd1 sky130_fd_sc_hd__diode_2
X_12383_ cell1.SB0.route_sel\[121\] cell1.SB0.route_sel\[120\] net872 vssd1 vssd1
+ vccd1 vccd1 _00816_ sky130_fd_sc_hd__mux2_1
XANTENNA_clkbuf_leaf_55_clk_A clknet_4_13_0_clk vssd1 vssd1 vccd1 vccd1 sky130_fd_sc_hd__diode_2
X_14122_ clknet_leaf_64_clk net1222 net747 vssd1 vssd1 vccd1 vccd1 cell3.LE_1B.config_data\[2\]
+ sky130_fd_sc_hd__dfrtp_1
X_11334_ _04367_ _06232_ _04369_ vssd1 vssd1 vccd1 vccd1 net176 sky130_fd_sc_hd__o21ai_2
XFILLER_141_739 vccd1 vssd1 vccd1 vssd1 sky130_ef_sc_hd__decap_40_12
XFILLER_141_717 vssd1 vssd1 vccd1 vccd1 sky130_fd_sc_hd__fill_1
X_11265_ net305 _05128_ _02002_ vssd1 vssd1 vccd1 vccd1 _06200_ sky130_fd_sc_hd__mux2_1
X_14053_ clknet_leaf_46_clk _01025_ net629 vssd1 vssd1 vccd1 vccd1 cell3.SB0.route_sel\[61\]
+ sky130_fd_sc_hd__dfstp_1
XFILLER_137_93 vssd1 vssd1 vccd1 vccd1 sky130_fd_sc_hd__fill_8
X_13004_ net1457 net1462 net951 vssd1 vssd1 vccd1 vccd1 _01432_ sky130_fd_sc_hd__mux2_1
X_10216_ _05136_ _05200_ vssd1 vssd1 vccd1 vccd1 _05217_ sky130_fd_sc_hd__nand2_1
XFILLER_4_587 vssd1 vssd1 vccd1 vccd1 sky130_fd_sc_hd__fill_1
XANTENNA_input47_X net47 vssd1 vssd1 vccd1 vccd1 sky130_fd_sc_hd__diode_2
XANTENNA_output248_A net248 vssd1 vssd1 vccd1 vccd1 sky130_fd_sc_hd__diode_2
X_11196_ _01802_ cell3.CB_0.config_dataB\[16\] vssd1 vssd1 vccd1 vccd1 _06148_ sky130_fd_sc_hd__or2_1
XFILLER_95_815 vssd1 vssd1 vccd1 vccd1 sky130_fd_sc_hd__fill_1
XANTENNA_output150_A net150 vssd1 vssd1 vccd1 vccd1 sky130_fd_sc_hd__diode_2
XANTENNA__07385__A1 bus3_1\[13\] vssd1 vssd1 vccd1 vccd1 sky130_fd_sc_hd__diode_2
XANTENNA__12720__S net932 vssd1 vssd1 vccd1 vccd1 sky130_fd_sc_hd__diode_2
XFILLER_94_325 vssd1 vssd1 vccd1 vccd1 sky130_fd_sc_hd__fill_1
X_10147_ _05147_ _04295_ vssd1 vssd1 vccd1 vccd1 _05148_ sky130_fd_sc_hd__and2b_4
X_10078_ _01674_ cell3.SB0.route_sel\[2\] vssd1 vssd1 vccd1 vccd1 _05080_ sky130_fd_sc_hd__nand2_1
XANTENNA_clkbuf_leaf_113_clk_A clknet_4_8_0_clk vssd1 vssd1 vccd1 vccd1 sky130_fd_sc_hd__diode_2
X_13906_ clknet_leaf_35_clk net1054 net636 vssd1 vssd1 vccd1 vccd1 cell2.LE_0B.config_data\[7\]
+ sky130_fd_sc_hd__dfrtp_1
XANTENNA__14164__SET_B net727 vssd1 vssd1 vccd1 vccd1 sky130_fd_sc_hd__diode_2
XANTENNA__12130__A1 cell1.LEI0.config_data\[11\] vssd1 vssd1 vccd1 vccd1 sky130_fd_sc_hd__diode_2
XFILLER_90_542 vssd1 vssd1 vccd1 vccd1 sky130_fd_sc_hd__fill_1
XFILLER_90_564 vssd1 vssd1 vccd1 vccd1 sky130_fd_sc_hd__fill_2
X_13837_ clknet_leaf_113_clk _00809_ net674 vssd1 vssd1 vccd1 vccd1 cell1.SB0.route_sel\[114\]
+ sky130_fd_sc_hd__dfstp_1
XANTENNA__09834__A0 bus3_2\[8\] vssd1 vssd1 vccd1 vccd1 sky130_fd_sc_hd__diode_2
XTAP_TAPCELL_ROW_46_998 vssd1 vccd1 sky130_fd_sc_hd__tapvpwrvgnd_1
XFILLER_15_171 vssd1 vssd1 vccd1 vccd1 sky130_fd_sc_hd__fill_1
XANTENNA_clkbuf_leaf_128_clk_A clknet_4_2_0_clk vssd1 vssd1 vccd1 vccd1 sky130_fd_sc_hd__diode_2
X_13768_ clknet_leaf_109_clk _00740_ net653 vssd1 vssd1 vccd1 vccd1 cell1.SB0.route_sel\[45\]
+ sky130_fd_sc_hd__dfstp_1
X_12719_ net384 net385 net932 vssd1 vssd1 vccd1 vccd1 _01148_ sky130_fd_sc_hd__mux2_1
Xclkbuf_0_clk clk vssd1 vssd1 vccd1 vccd1 clknet_0_clk sky130_fd_sc_hd__clkbuf_16
XFILLER_43_491 vssd1 vssd1 vccd1 vccd1 sky130_fd_sc_hd__fill_1
XANTENNA__10995__A2 net42 vssd1 vssd1 vccd1 vccd1 sky130_fd_sc_hd__diode_2
X_13699_ clknet_leaf_27_clk _00671_ net614 vssd1 vssd1 vccd1 vccd1 cell2.CB_0.config_dataA\[1\]
+ sky130_fd_sc_hd__dfstp_1
XFILLER_87_3 vccd1 vssd1 vccd1 vssd1 sky130_ef_sc_hd__decap_40_12
XFILLER_30_152 vssd1 vssd1 vccd1 vccd1 sky130_fd_sc_hd__fill_1
XANTENNA__09984__B net303 vssd1 vssd1 vccd1 vccd1 sky130_fd_sc_hd__diode_2
XANTENNA__09062__B2 _03849_ vssd1 vssd1 vccd1 vccd1 sky130_fd_sc_hd__diode_2
XANTENNA__09062__A1 _03853_ vssd1 vssd1 vccd1 vccd1 sky130_fd_sc_hd__diode_2
XFILLER_7_51 vssd1 vssd1 vccd1 vccd1 sky130_fd_sc_hd__fill_4
Xhold315 cell2.LE_1B.config_data\[4\] vssd1 vssd1 vccd1 vccd1 net1274 sky130_fd_sc_hd__dlygate4sd3_1
XANTENNA__09329__X _04354_ vssd1 vssd1 vccd1 vccd1 sky130_fd_sc_hd__diode_2
Xhold326 cell0.LE_0B.config_data\[8\] vssd1 vssd1 vccd1 vccd1 net1285 sky130_fd_sc_hd__dlygate4sd3_1
Xhold304 _00013_ vssd1 vssd1 vccd1 vccd1 net1263 sky130_fd_sc_hd__dlygate4sd3_1
XANTENNA__07073__B1 _02132_ vssd1 vssd1 vccd1 vccd1 sky130_fd_sc_hd__diode_2
Xhold348 _01400_ vssd1 vssd1 vccd1 vccd1 net1307 sky130_fd_sc_hd__dlygate4sd3_1
X_09930_ net409 _04472_ net408 vssd1 vssd1 vccd1 vccd1 _04934_ sky130_fd_sc_hd__o21ai_1
Xhold337 cell0.LE_1B.config_data\[2\] vssd1 vssd1 vccd1 vccd1 net1296 sky130_fd_sc_hd__dlygate4sd3_1
Xhold359 cell0.LE_1B.config_data\[15\] vssd1 vssd1 vccd1 vccd1 net1318 sky130_fd_sc_hd__dlygate4sd3_1
Xfanout806 net807 vssd1 vssd1 vccd1 vccd1 net806 sky130_fd_sc_hd__clkbuf_2
XTAP_TAPCELL_ROW_55_1130 vssd1 vccd1 sky130_fd_sc_hd__tapvpwrvgnd_1
XPHY_EDGE_ROW_15_Right_15 vssd1 vssd1 vccd1 vccd1 sky130_fd_sc_hd__decap_3
Xfanout828 net855 vssd1 vssd1 vccd1 vccd1 net828 sky130_fd_sc_hd__buf_2
Xfanout839 net840 vssd1 vssd1 vccd1 vccd1 net839 sky130_fd_sc_hd__clkbuf_2
X_09861_ cell2.LEI0.config_data\[30\] net316 _04866_ cell2.LEI0.config_data\[31\]
+ vssd1 vssd1 vccd1 vccd1 _04867_ sky130_fd_sc_hd__o211a_1
Xfanout817 net828 vssd1 vssd1 vccd1 vccd1 net817 sky130_fd_sc_hd__buf_2
X_09792_ _04671_ _04792_ _04794_ _04641_ vssd1 vssd1 vccd1 vccd1 _04798_ sky130_fd_sc_hd__o2bb2a_1
X_08812_ _02295_ _03843_ vssd1 vssd1 vccd1 vccd1 _03844_ sky130_fd_sc_hd__nor2_2
X_08743_ _03775_ _03776_ _01660_ vssd1 vssd1 vccd1 vccd1 _03777_ sky130_fd_sc_hd__mux2_1
XANTENNA_fanout279_A cell3.CB_0.le_outB vssd1 vssd1 vccd1 vccd1 sky130_fd_sc_hd__diode_2
XANTENNA__07025__A net301 vssd1 vssd1 vccd1 vccd1 sky130_fd_sc_hd__diode_2
X_08674_ net461 _03489_ _03707_ vssd1 vssd1 vccd1 vccd1 _03708_ sky130_fd_sc_hd__a21o_1
XFILLER_81_542 vssd1 vssd1 vccd1 vccd1 sky130_fd_sc_hd__fill_4
XANTENNA__08340__A3 net339 vssd1 vssd1 vccd1 vccd1 sky130_fd_sc_hd__diode_2
X_07625_ cell0.SB0.route_sel\[9\] cell0.SB0.route_sel\[8\] _02673_ vssd1 vssd1 vccd1
+ vccd1 _02674_ sky130_fd_sc_hd__a21oi_1
XPHY_EDGE_ROW_24_Right_24 vssd1 vssd1 vccd1 vccd1 sky130_fd_sc_hd__decap_3
X_07556_ cell0.CB_1.config_dataA\[22\] cell0.CB_1.config_dataA\[23\] vssd1 vssd1 vccd1
+ vccd1 _02606_ sky130_fd_sc_hd__nor2_1
XANTENNA__12077__S net940 vssd1 vssd1 vccd1 vccd1 sky130_fd_sc_hd__diode_2
XTAP_TAPCELL_ROW_66_1292 vssd1 vccd1 sky130_fd_sc_hd__tapvpwrvgnd_1
X_06507_ cell0.SB0.route_sel\[3\] vssd1 vssd1 vccd1 vccd1 _01577_ sky130_fd_sc_hd__inv_2
Xclkbuf_1_0__f_cell2.LE_0B.sel_clk clknet_0_cell2.LE_0B.sel_clk vssd1 vssd1 vccd1
+ vccd1 clknet_1_0__leaf_cell2.LE_0B.sel_clk sky130_fd_sc_hd__clkbuf_16
X_09226_ _02180_ _04189_ vssd1 vssd1 vccd1 vccd1 _04253_ sky130_fd_sc_hd__nor2_1
X_07487_ cell2.SB0.route_sel\[112\] _01644_ cell2.SB0.route_sel\[115\] _01646_ _02539_
+ vssd1 vssd1 vccd1 vccd1 _02540_ sky130_fd_sc_hd__a221o_1
XFILLER_22_675 vssd1 vssd1 vccd1 vccd1 sky130_fd_sc_hd__fill_1
XFILLER_6_819 vssd1 vssd1 vccd1 vccd1 sky130_fd_sc_hd__fill_1
X_06438_ cell1.SB0.route_sel\[22\] vssd1 vssd1 vccd1 vccd1 _01508_ sky130_fd_sc_hd__inv_2
X_09157_ _01566_ _01567_ net104 _04183_ vssd1 vssd1 vccd1 vccd1 _04185_ sky130_fd_sc_hd__o211ai_1
XFILLER_108_747 vssd1 vssd1 vccd1 vccd1 sky130_fd_sc_hd__fill_1
X_09088_ cell1.LEI0.config_data\[29\] _04117_ vssd1 vssd1 vccd1 vccd1 _04118_ sky130_fd_sc_hd__and2b_1
XANTENNA__08800__A1 _03826_ vssd1 vssd1 vccd1 vccd1 sky130_fd_sc_hd__diode_2
X_08108_ cell0.LEI0.config_data\[41\] _03149_ _01562_ _03148_ vssd1 vssd1 vccd1 vccd1
+ _03150_ sky130_fd_sc_hd__a2bb2o_1
XANTENNA__07695__A net339 vssd1 vssd1 vccd1 vccd1 sky130_fd_sc_hd__diode_2
X_08039_ net532 _03079_ _03080_ vssd1 vssd1 vccd1 vccd1 _03081_ sky130_fd_sc_hd__a21oi_1
XFILLER_1_502 vssd1 vssd1 vccd1 vccd1 sky130_fd_sc_hd__fill_2
XPHY_EDGE_ROW_33_Right_33 vssd1 vssd1 vccd1 vccd1 sky130_fd_sc_hd__decap_3
X_11050_ _01812_ _06003_ vssd1 vssd1 vccd1 vccd1 _06004_ sky130_fd_sc_hd__nand2_1
XFILLER_89_653 vssd1 vssd1 vccd1 vccd1 sky130_fd_sc_hd__fill_1
XFILLER_88_141 vssd1 vssd1 vccd1 vccd1 sky130_fd_sc_hd__fill_1
XFILLER_1_557 vssd1 vssd1 vccd1 vccd1 sky130_fd_sc_hd__fill_2
X_10001_ net404 _04608_ vssd1 vssd1 vccd1 vccd1 _05005_ sky130_fd_sc_hd__nand2_1
XFILLER_88_174 vssd1 vssd1 vccd1 vccd1 sky130_fd_sc_hd__fill_2
XFILLER_76_325 vssd1 vssd1 vccd1 vccd1 sky130_fd_sc_hd__fill_2
XANTENNA__12437__B1_N _06381_ vssd1 vssd1 vccd1 vccd1 sky130_fd_sc_hd__diode_2
XANTENNA__10910__A2 net56 vssd1 vssd1 vccd1 vccd1 sky130_fd_sc_hd__diode_2
XFILLER_92_807 vssd1 vssd1 vccd1 vccd1 sky130_fd_sc_hd__fill_1
XANTENNA__07119__A1 net305 vssd1 vssd1 vccd1 vccd1 sky130_fd_sc_hd__diode_2
XFILLER_123_51 vssd1 vssd1 vccd1 vccd1 sky130_fd_sc_hd__fill_4
XTAP_TAPCELL_ROW_86_1602 vssd1 vccd1 sky130_fd_sc_hd__tapvpwrvgnd_1
XTAP_TAPCELL_ROW_4_373 vssd1 vccd1 sky130_fd_sc_hd__tapvpwrvgnd_1
XTAP_TAPCELL_ROW_4_362 vssd1 vccd1 sky130_fd_sc_hd__tapvpwrvgnd_1
XFILLER_72_531 vssd1 vssd1 vccd1 vccd1 sky130_fd_sc_hd__fill_1
XPHY_EDGE_ROW_42_Right_42 vssd1 vssd1 vccd1 vccd1 sky130_fd_sc_hd__decap_3
X_11952_ cell0.SB0.route_sel\[58\] cell0.SB0.route_sel\[57\] net761 vssd1 vssd1 vccd1
+ vccd1 _00389_ sky130_fd_sc_hd__mux2_1
X_10903_ net379 net378 vssd1 vssd1 vccd1 vccd1 _05857_ sky130_fd_sc_hd__nor2_1
X_11883_ cell1.CB_0.config_dataA\[14\] cell1.CB_0.config_dataA\[13\] net892 vssd1
+ vssd1 vccd1 vccd1 _00320_ sky130_fd_sc_hd__mux2_1
XFILLER_17_447 vssd1 vssd1 vccd1 vccd1 sky130_fd_sc_hd__fill_1
X_10834_ _05789_ vssd1 vssd1 vccd1 vccd1 _05790_ sky130_fd_sc_hd__inv_2
X_13622_ clknet_leaf_95_clk _00594_ net687 vssd1 vssd1 vccd1 vccd1 cell1.LEI0.config_data\[43\]
+ sky130_fd_sc_hd__dfrtp_1
XANTENNA__09150__A net301 vssd1 vssd1 vccd1 vccd1 sky130_fd_sc_hd__diode_2
X_13553_ clknet_leaf_90_clk _00525_ net699 vssd1 vssd1 vccd1 vccd1 cell1.LE_0B.reset_val
+ sky130_fd_sc_hd__dfrtp_2
XTAP_TAPCELL_ROW_43_957 vssd1 vccd1 sky130_fd_sc_hd__tapvpwrvgnd_1
XTAP_TAPCELL_ROW_43_946 vssd1 vccd1 sky130_fd_sc_hd__tapvpwrvgnd_1
X_12504_ cell2.LEI0.config_data\[18\] cell2.LEI0.config_data\[17\] net850 vssd1 vssd1
+ vccd1 vccd1 _00933_ sky130_fd_sc_hd__mux2_1
X_10765_ _05720_ vssd1 vssd1 vccd1 vccd1 _05721_ sky130_fd_sc_hd__inv_2
X_10696_ net390 _05652_ _05653_ vssd1 vssd1 vccd1 vccd1 _05654_ sky130_fd_sc_hd__a21o_1
X_13484_ clknet_leaf_123_clk _00456_ net585 vssd1 vssd1 vccd1 vccd1 cell0.SB0.route_sel\[125\]
+ sky130_fd_sc_hd__dfstp_1
X_12435_ net1504 cell2.LE_1A.edge_mode net849 vssd1 vssd1 vccd1 vccd1 _00867_ sky130_fd_sc_hd__mux2_1
XPHY_EDGE_ROW_51_Right_51 vssd1 vssd1 vccd1 vccd1 sky130_fd_sc_hd__decap_3
XANTENNA_output198_A net198 vssd1 vssd1 vccd1 vccd1 sky130_fd_sc_hd__diode_2
XTAP_TAPCELL_ROW_113_2009 vssd1 vccd1 sky130_fd_sc_hd__tapvpwrvgnd_1
XTAP_TAPCELL_ROW_97_1764 vssd1 vccd1 sky130_fd_sc_hd__tapvpwrvgnd_1
X_12366_ cell1.SB0.route_sel\[104\] cell1.SB0.route_sel\[103\] net882 vssd1 vssd1
+ vccd1 vccd1 _00799_ sky130_fd_sc_hd__mux2_1
XANTENNA__08398__A3 bus1_0\[3\] vssd1 vssd1 vccd1 vccd1 sky130_fd_sc_hd__diode_2
XFILLER_141_503 vssd1 vssd1 vccd1 vccd1 sky130_fd_sc_hd__fill_1
XPHY_EDGE_ROW_136_Right_136 vssd1 vssd1 vccd1 vccd1 sky130_fd_sc_hd__decap_3
X_14105_ clknet_leaf_51_clk _01077_ net713 vssd1 vssd1 vccd1 vccd1 cell3.SB0.route_sel\[113\]
+ sky130_fd_sc_hd__dfstp_1
X_11317_ net288 _05544_ _04620_ vssd1 vssd1 vccd1 vccd1 _06224_ sky130_fd_sc_hd__mux2_1
X_12297_ cell1.SB0.route_sel\[35\] cell1.SB0.route_sel\[34\] net887 vssd1 vssd1 vccd1
+ vccd1 _00730_ sky130_fd_sc_hd__mux2_1
X_14036_ clknet_leaf_49_clk _01008_ net705 vssd1 vssd1 vccd1 vccd1 cell3.SB0.route_sel\[44\]
+ sky130_fd_sc_hd__dfstp_2
XANTENNA__08555__A0 net29 vssd1 vssd1 vccd1 vccd1 sky130_fd_sc_hd__diode_2
X_11248_ net680 cell1.LE_0B.reset_mode vssd1 vssd1 vccd1 vccd1 _11248_/X sky130_fd_sc_hd__xor2_2
X_11179_ _06125_ _06128_ _06130_ cell3.CB_0.config_dataB\[12\] vssd1 vssd1 vccd1 vccd1
+ _06131_ sky130_fd_sc_hd__o22a_1
XTAP_TAPCELL_ROW_128_2230 vssd1 vccd1 sky130_fd_sc_hd__tapvpwrvgnd_1
XANTENNA__08570__A3 net3 vssd1 vssd1 vccd1 vccd1 sky130_fd_sc_hd__diode_2
XPHY_EDGE_ROW_60_Right_60 vssd1 vssd1 vccd1 vccd1 sky130_fd_sc_hd__decap_3
XTAP_TAPCELL_ROW_50_1060 vssd1 vccd1 sky130_fd_sc_hd__tapvpwrvgnd_1
XTAP_TAPCELL_ROW_141_2430 vssd1 vccd1 sky130_fd_sc_hd__tapvpwrvgnd_1
XANTENNA__09044__B _03841_ vssd1 vssd1 vccd1 vccd1 sky130_fd_sc_hd__diode_2
XANTENNA__10665__A1 net9 vssd1 vssd1 vccd1 vccd1 sky130_fd_sc_hd__diode_2
X_07410_ net37 net307 _02463_ vssd1 vssd1 vccd1 vccd1 _02465_ sky130_fd_sc_hd__mux2_1
XFILLER_23_439 vssd1 vssd1 vccd1 vccd1 sky130_fd_sc_hd__fill_1
X_08390_ net500 _02211_ net499 vssd1 vssd1 vccd1 vccd1 _03428_ sky130_fd_sc_hd__o21ai_1
X_07341_ _02099_ _02397_ vssd1 vssd1 vccd1 vccd1 _02398_ sky130_fd_sc_hd__nor2_1
XTAP_TAPCELL_ROW_106_1893 vssd1 vccd1 sky130_fd_sc_hd__tapvpwrvgnd_1
XANTENNA__09283__A1 net10 vssd1 vssd1 vccd1 vccd1 sky130_fd_sc_hd__diode_2
XTAP_TAPCELL_ROW_21_618 vssd1 vccd1 sky130_fd_sc_hd__tapvpwrvgnd_1
XFILLER_137_809 vccd1 vssd1 vccd1 vssd1 sky130_ef_sc_hd__decap_40_12
XANTENNA__07833__A2 bus2_0\[10\] vssd1 vssd1 vccd1 vccd1 sky130_fd_sc_hd__diode_2
XTAP_TAPCELL_ROW_21_629 vssd1 vccd1 sky130_fd_sc_hd__tapvpwrvgnd_1
XANTENNA__06971__X _02037_ vssd1 vssd1 vccd1 vccd1 sky130_fd_sc_hd__diode_2
X_07272_ _02327_ _02329_ _02328_ vssd1 vssd1 vccd1 vccd1 _02330_ sky130_fd_sc_hd__o21bai_1
XTAP_TAPCELL_ROW_139_2392 vssd1 vccd1 sky130_fd_sc_hd__tapvpwrvgnd_1
X_09011_ cell1.CB_0.config_dataB\[7\] _04040_ cell1.CB_0.config_dataB\[8\] vssd1 vssd1
+ vccd1 vccd1 _04041_ sky130_fd_sc_hd__a21bo_1
XANTENNA__09035__B2 _03868_ vssd1 vssd1 vccd1 vccd1 sky130_fd_sc_hd__diode_2
XANTENNA__09035__A1 _03871_ vssd1 vssd1 vccd1 vccd1 sky130_fd_sc_hd__diode_2
XFILLER_12_29 vccd1 vssd1 vccd1 vssd1 sky130_ef_sc_hd__decap_40_12
XFILLER_128_29 vccd1 vssd1 vccd1 vssd1 sky130_ef_sc_hd__decap_40_12
Xhold101 _00172_ vssd1 vssd1 vccd1 vccd1 net1060 sky130_fd_sc_hd__dlygate4sd3_1
Xhold112 _01375_ vssd1 vssd1 vccd1 vccd1 net1071 sky130_fd_sc_hd__dlygate4sd3_1
XPHY_EDGE_ROW_103_Right_103 vssd1 vssd1 vccd1 vccd1 sky130_fd_sc_hd__decap_3
Xhold123 cell0.LE_0A.config_data\[14\] vssd1 vssd1 vccd1 vccd1 net1082 sky130_fd_sc_hd__dlygate4sd3_1
Xhold134 cell1.LE_1A.config_data\[2\] vssd1 vssd1 vccd1 vccd1 net1093 sky130_fd_sc_hd__dlygate4sd3_1
Xhold167 cell2.LE_1A.config_data\[9\] vssd1 vssd1 vccd1 vccd1 net1126 sky130_fd_sc_hd__dlygate4sd3_1
Xhold145 _00571_ vssd1 vssd1 vccd1 vccd1 net1104 sky130_fd_sc_hd__dlygate4sd3_1
Xhold156 cell1.LE_1A.config_data\[7\] vssd1 vssd1 vccd1 vccd1 net1115 sky130_fd_sc_hd__dlygate4sd3_1
X_09913_ _04915_ _04918_ _04870_ vssd1 vssd1 vccd1 vccd1 _04919_ sky130_fd_sc_hd__mux2_1
Xfanout614 net616 vssd1 vssd1 vccd1 vccd1 net614 sky130_fd_sc_hd__clkbuf_4
Xfanout603 net606 vssd1 vssd1 vccd1 vccd1 net603 sky130_fd_sc_hd__clkbuf_4
Xhold178 _00003_ vssd1 vssd1 vccd1 vccd1 net1137 sky130_fd_sc_hd__dlygate4sd3_1
Xhold189 cell1.LE_1A.config_data\[10\] vssd1 vssd1 vccd1 vccd1 net1148 sky130_fd_sc_hd__dlygate4sd3_1
Xfanout636 net640 vssd1 vssd1 vccd1 vccd1 net636 sky130_fd_sc_hd__clkbuf_4
Xfanout647 net649 vssd1 vssd1 vccd1 vccd1 net647 sky130_fd_sc_hd__clkbuf_4
X_09844_ _04260_ _04835_ _04836_ _04197_ cell2.CB_1.config_dataA\[12\] vssd1 vssd1
+ vccd1 vccd1 _04850_ sky130_fd_sc_hd__a221o_1
Xfanout625 net626 vssd1 vssd1 vccd1 vccd1 net625 sky130_fd_sc_hd__clkbuf_4
XANTENNA__08546__B1 _03581_ vssd1 vssd1 vccd1 vccd1 sky130_fd_sc_hd__diode_2
Xfanout658 net664 vssd1 vssd1 vccd1 vccd1 net658 sky130_fd_sc_hd__clkbuf_4
XFILLER_85_111 vssd1 vssd1 vccd1 vccd1 sky130_fd_sc_hd__fill_1
Xfanout669 net672 vssd1 vssd1 vccd1 vccd1 net669 sky130_fd_sc_hd__buf_2
XFILLER_37_15 vccd1 vssd1 vccd1 vssd1 sky130_ef_sc_hd__decap_40_12
X_09775_ net444 _04498_ _04780_ vssd1 vssd1 vccd1 vccd1 _04781_ sky130_fd_sc_hd__a21o_1
XFILLER_85_177 vssd1 vssd1 vccd1 vccd1 sky130_fd_sc_hd__fill_1
X_06987_ net321 _02046_ _02047_ _02050_ _02051_ vssd1 vssd1 vccd1 vccd1 _02053_ sky130_fd_sc_hd__o32a_1
XANTENNA_fanout563_A net602 vssd1 vssd1 vccd1 vccd1 sky130_fd_sc_hd__diode_2
XFILLER_85_199 vssd1 vssd1 vccd1 vccd1 sky130_fd_sc_hd__fill_2
XTAP_TAPCELL_ROW_68_1332 vssd1 vccd1 sky130_fd_sc_hd__tapvpwrvgnd_1
XTAP_TAPCELL_ROW_68_1321 vssd1 vccd1 sky130_fd_sc_hd__tapvpwrvgnd_1
XTAP_TAPCELL_ROW_1_321 vssd1 vccd1 sky130_fd_sc_hd__tapvpwrvgnd_1
X_08726_ net454 net455 _03498_ _03759_ cell1.CB_1.config_dataB\[12\] vssd1 vssd1 vccd1
+ vccd1 _03760_ sky130_fd_sc_hd__o311a_1
XANTENNA_fanout351_X net351 vssd1 vssd1 vccd1 vccd1 sky130_fd_sc_hd__diode_2
XFILLER_54_564 vssd1 vssd1 vccd1 vccd1 sky130_fd_sc_hd__fill_1
X_08657_ net458 _03489_ vssd1 vssd1 vccd1 vccd1 _03691_ sky130_fd_sc_hd__nand2_1
XANTENNA_fanout828_A net855 vssd1 vssd1 vccd1 vccd1 sky130_fd_sc_hd__diode_2
XFILLER_54_597 vssd1 vssd1 vccd1 vccd1 sky130_fd_sc_hd__fill_1
X_07608_ _02655_ _02657_ vssd1 vssd1 vccd1 vccd1 bus1_0\[0\] sky130_fd_sc_hd__and2b_2
XANTENNA__06865__Y _01933_ vssd1 vssd1 vccd1 vccd1 sky130_fd_sc_hd__diode_2
XTAP_TAPCELL_ROW_81_1521 vssd1 vccd1 sky130_fd_sc_hd__tapvpwrvgnd_1
X_08588_ _01667_ net487 vssd1 vssd1 vccd1 vccd1 _03624_ sky130_fd_sc_hd__nor2_1
XFILLER_139_113 vssd1 vssd1 vccd1 vccd1 sky130_fd_sc_hd__fill_8
X_07539_ cell2.SB0.route_sel\[120\] cell2.SB0.route_sel\[121\] vssd1 vssd1 vccd1 vccd1
+ _02590_ sky130_fd_sc_hd__nand2_1
XANTENNA__09274__B2 _04279_ vssd1 vssd1 vccd1 vccd1 sky130_fd_sc_hd__diode_2
XTAP_TAPCELL_ROW_40_905 vssd1 vccd1 sky130_fd_sc_hd__tapvpwrvgnd_1
X_10550_ cell3.SB0.route_sel\[8\] _01685_ cell3.SB0.route_sel\[12\] cell3.SB0.route_sel\[13\]
+ vssd1 vssd1 vccd1 vccd1 _05508_ sky130_fd_sc_hd__o22a_1
XFILLER_10_645 vccd1 vssd1 vccd1 vssd1 sky130_ef_sc_hd__decap_40_12
XFILLER_108_511 vssd1 vssd1 vccd1 vccd1 sky130_fd_sc_hd__fill_1
X_09209_ _04233_ _04235_ vssd1 vssd1 vccd1 vccd1 _04236_ sky130_fd_sc_hd__nor2_1
XANTENNA__12535__S net936 vssd1 vssd1 vccd1 vccd1 sky130_fd_sc_hd__diode_2
XANTENNA__09026__A1 _03890_ vssd1 vssd1 vccd1 vccd1 sky130_fd_sc_hd__diode_2
X_10481_ clknet_leaf_12_clk cell0.LE_0A.edge_mode vssd1 vssd1 vccd1 vccd1 cell0.LE_0A.sel_clk
+ sky130_fd_sc_hd__xnor2_2
X_12220_ cell2.CB_0.config_dataB\[8\] cell2.CB_0.config_dataB\[7\] net825 vssd1 vssd1
+ vccd1 vccd1 _00653_ sky130_fd_sc_hd__mux2_1
XFILLER_108_544 vssd1 vssd1 vccd1 vccd1 sky130_fd_sc_hd__fill_1
XANTENNA__09026__B2 _03894_ vssd1 vssd1 vccd1 vccd1 sky130_fd_sc_hd__diode_2
XFILLER_5_137 vssd1 vssd1 vccd1 vccd1 sky130_fd_sc_hd__fill_8
XFILLER_123_503 vssd1 vssd1 vccd1 vccd1 sky130_fd_sc_hd__fill_1
XANTENNA__12581__A1 cell3.SB0.route_sel\[45\] vssd1 vssd1 vccd1 vccd1 sky130_fd_sc_hd__diode_2
XTAP_TAPCELL_ROW_79_1494 vssd1 vccd1 sky130_fd_sc_hd__tapvpwrvgnd_1
XFILLER_78_33 vssd1 vssd1 vccd1 vccd1 sky130_fd_sc_hd__fill_1
X_12151_ net1184 net1074 net900 vssd1 vssd1 vccd1 vccd1 _00584_ sky130_fd_sc_hd__mux2_1
XTAP_TAPCELL_ROW_9_443 vssd1 vccd1 sky130_fd_sc_hd__tapvpwrvgnd_1
XFILLER_2_811 vssd1 vssd1 vccd1 vccd1 sky130_fd_sc_hd__fill_1
X_11102_ cell3.CB_0.config_dataB\[0\] _05874_ vssd1 vssd1 vccd1 vccd1 _06054_ sky130_fd_sc_hd__nor2_1
X_12082_ net1158 net1020 net938 vssd1 vssd1 vccd1 vccd1 _00517_ sky130_fd_sc_hd__mux2_1
X_11033_ _05924_ _05964_ vssd1 vssd1 vccd1 vccd1 _05987_ sky130_fd_sc_hd__nor2_1
XTAP_TAPCELL_ROW_92_1694 vssd1 vccd1 sky130_fd_sc_hd__tapvpwrvgnd_1
XTAP_TAPCELL_ROW_92_1683 vssd1 vccd1 sky130_fd_sc_hd__tapvpwrvgnd_1
XFILLER_77_601 vssd1 vssd1 vccd1 vccd1 sky130_fd_sc_hd__fill_1
XFILLER_131_591 vssd1 vssd1 vccd1 vccd1 sky130_fd_sc_hd__fill_1
XFILLER_94_21 vssd1 vssd1 vccd1 vccd1 sky130_fd_sc_hd__fill_4
X_12984_ net1476 net1458 net945 vssd1 vssd1 vccd1 vccd1 _01412_ sky130_fd_sc_hd__mux2_1
XFILLER_94_65 vccd1 vssd1 vccd1 vssd1 sky130_ef_sc_hd__decap_40_12
X_11935_ cell0.SB0.route_sel\[41\] cell0.SB0.route_sel\[40\] net757 vssd1 vssd1 vccd1
+ vccd1 _00372_ sky130_fd_sc_hd__mux2_1
XTAP_TAPCELL_ROW_123_2160 vssd1 vccd1 sky130_fd_sc_hd__tapvpwrvgnd_1
XANTENNA__11614__S net773 vssd1 vssd1 vccd1 vccd1 sky130_fd_sc_hd__diode_2
X_13605_ clknet_leaf_86_clk net1346 net686 vssd1 vssd1 vccd1 vccd1 cell1.LEI0.config_data\[26\]
+ sky130_fd_sc_hd__dfrtp_1
X_11866_ cell1.CB_0.config_dataB\[22\] cell1.CB_0.config_dataB\[21\] net881 vssd1
+ vssd1 vccd1 vccd1 _00303_ sky130_fd_sc_hd__mux2_1
XFILLER_32_236 vssd1 vssd1 vccd1 vccd1 sky130_fd_sc_hd__fill_1
XANTENNA__06866__A3 _01932_ vssd1 vssd1 vccd1 vccd1 sky130_fd_sc_hd__diode_2
X_10817_ _05501_ _05504_ net367 vssd1 vssd1 vccd1 vccd1 _05773_ sky130_fd_sc_hd__mux2_1
X_11797_ cell0.CB_0.config_data_inA net1385 net792 vssd1 vssd1 vccd1 vccd1 _00234_
+ sky130_fd_sc_hd__mux2_1
XFILLER_32_258 vssd1 vssd1 vccd1 vccd1 sky130_fd_sc_hd__fill_1
X_10748_ net371 _05478_ vssd1 vssd1 vccd1 vccd1 _05704_ sky130_fd_sc_hd__or2_1
X_13536_ clknet_leaf_89_clk net1195 net696 vssd1 vssd1 vccd1 vccd1 cell1.LE_0B.config_data\[1\]
+ sky130_fd_sc_hd__dfrtp_1
XFILLER_9_443 vssd1 vssd1 vccd1 vccd1 sky130_fd_sc_hd__fill_4
XANTENNA__12445__S net827 vssd1 vssd1 vccd1 vccd1 sky130_fd_sc_hd__diode_2
X_13467_ clknet_leaf_4_clk _00439_ net565 vssd1 vssd1 vccd1 vccd1 cell0.SB0.route_sel\[108\]
+ sky130_fd_sc_hd__dfstp_1
XFILLER_127_820 vssd1 vssd1 vccd1 vccd1 sky130_fd_sc_hd__fill_2
X_12418_ net1114 net1197 net852 vssd1 vssd1 vccd1 vccd1 _00850_ sky130_fd_sc_hd__mux2_1
X_10679_ _05630_ _05635_ _05636_ vssd1 vssd1 vccd1 vccd1 _05637_ sky130_fd_sc_hd__and3_1
XANTENNA__12021__A0 cell0.SB0.config_data_out vssd1 vssd1 vccd1 vccd1 sky130_fd_sc_hd__diode_2
XFILLER_126_363 vssd1 vssd1 vccd1 vccd1 sky130_fd_sc_hd__fill_1
Xoutput206 net206 vssd1 vssd1 vccd1 vccd1 SBsouth_out[17] sky130_fd_sc_hd__buf_2
Xoutput217 net217 vssd1 vssd1 vccd1 vccd1 SBsouth_out[27] sky130_fd_sc_hd__buf_2
X_13398_ clknet_leaf_0_clk _00370_ net553 vssd1 vssd1 vccd1 vccd1 cell0.SB0.route_sel\[39\]
+ sky130_fd_sc_hd__dfstp_1
XFILLER_142_845 vssd1 vssd1 vccd1 vccd1 sky130_fd_sc_hd__fill_2
Xoutput239 net239 vssd1 vssd1 vccd1 vccd1 SBwest_out[18] sky130_fd_sc_hd__buf_2
XFILLER_5_671 vssd1 vssd1 vccd1 vccd1 sky130_fd_sc_hd__fill_1
Xoutput228 net228 vssd1 vssd1 vccd1 vccd1 SBsouth_out[8] sky130_fd_sc_hd__buf_2
X_12349_ cell1.SB0.route_sel\[87\] cell1.SB0.route_sel\[86\] net871 vssd1 vssd1 vccd1
+ vccd1 _00782_ sky130_fd_sc_hd__mux2_1
XFILLER_141_333 vssd1 vssd1 vccd1 vccd1 sky130_fd_sc_hd__fill_1
XFILLER_99_247 vssd1 vssd1 vccd1 vccd1 sky130_fd_sc_hd__fill_1
XFILLER_4_41 vccd1 vssd1 vccd1 vssd1 sky130_ef_sc_hd__decap_40_12
X_14019_ clknet_leaf_81_clk _00991_ net702 vssd1 vssd1 vccd1 vccd1 cell3.SB0.route_sel\[27\]
+ sky130_fd_sc_hd__dfstp_1
XFILLER_4_85 vccd1 vssd1 vccd1 vssd1 sky130_ef_sc_hd__decap_40_12
X_06910_ cell1.SB0.route_sel\[56\] cell1.SB0.route_sel\[57\] _01977_ vssd1 vssd1 vccd1
+ vccd1 _01978_ sky130_fd_sc_hd__a21oi_1
X_07890_ net521 _02526_ _02933_ net520 vssd1 vssd1 vccd1 vccd1 _02934_ sky130_fd_sc_hd__o211a_1
X_06841_ cell2.SB0.route_sel\[51\] cell2.SB0.route_sel\[50\] _01909_ vssd1 vssd1 vccd1
+ vccd1 _01910_ sky130_fd_sc_hd__a21oi_1
XFILLER_83_615 vssd1 vssd1 vccd1 vccd1 sky130_fd_sc_hd__fill_1
XANTENNA__07751__A1 net91 vssd1 vssd1 vccd1 vccd1 sky130_fd_sc_hd__diode_2
XTAP_TAPCELL_ROW_108_1933 vssd1 vccd1 sky130_fd_sc_hd__tapvpwrvgnd_1
XTAP_TAPCELL_ROW_108_1922 vssd1 vccd1 sky130_fd_sc_hd__tapvpwrvgnd_1
X_09560_ _04576_ _04578_ vssd1 vssd1 vccd1 vccd1 bus3_1\[9\] sky130_fd_sc_hd__and2_2
X_06772_ cell1.CB_1.config_dataA\[23\] cell1.CB_1.config_dataA\[22\] vssd1 vssd1 vccd1
+ vccd1 _01842_ sky130_fd_sc_hd__nand2b_2
X_09491_ net293 _04511_ _04508_ vssd1 vssd1 vccd1 vccd1 _04512_ sky130_fd_sc_hd__mux2_1
XANTENNA__13134__SET_B net581 vssd1 vssd1 vccd1 vccd1 sky130_fd_sc_hd__diode_2
X_08511_ net494 _03509_ vssd1 vssd1 vccd1 vccd1 _03547_ sky130_fd_sc_hd__nand2_1
X_08442_ net497 net496 vssd1 vssd1 vccd1 vccd1 _03478_ sky130_fd_sc_hd__nor2_1
XFILLER_23_225 vssd1 vssd1 vccd1 vccd1 sky130_fd_sc_hd__fill_1
XANTENNA__09256__A1 bus3_2\[2\] vssd1 vssd1 vccd1 vccd1 sky130_fd_sc_hd__diode_2
XTAP_TAPCELL_ROW_63_1251 vssd1 vccd1 sky130_fd_sc_hd__tapvpwrvgnd_1
X_08373_ _03409_ _03410_ _03400_ _03407_ vssd1 vssd1 vccd1 vccd1 _03411_ sky130_fd_sc_hd__o211a_1
XANTENNA__07303__A net322 vssd1 vssd1 vccd1 vccd1 sky130_fd_sc_hd__diode_2
X_07324_ net301 _02380_ vssd1 vssd1 vccd1 vccd1 _02381_ sky130_fd_sc_hd__nor2_1
XFILLER_23_39 vccd1 vssd1 vccd1 vssd1 sky130_ef_sc_hd__decap_40_12
XFILLER_139_39 vccd1 vssd1 vccd1 vssd1 sky130_ef_sc_hd__decap_40_12
XFILLER_137_606 vssd1 vssd1 vccd1 vccd1 sky130_fd_sc_hd__fill_1
X_07255_ _02000_ _02096_ vssd1 vssd1 vccd1 vccd1 _02314_ sky130_fd_sc_hd__nand2_1
XANTENNA__09008__A1 _03830_ vssd1 vssd1 vccd1 vccd1 sky130_fd_sc_hd__diode_2
XANTENNA_fanout311_A net313 vssd1 vssd1 vccd1 vccd1 sky130_fd_sc_hd__diode_2
XANTENNA__09008__B2 _03826_ vssd1 vssd1 vccd1 vccd1 sky130_fd_sc_hd__diode_2
X_07186_ cell2.SB0.route_sel\[80\] cell2.SB0.route_sel\[81\] _02246_ vssd1 vssd1 vccd1
+ vccd1 _02247_ sky130_fd_sc_hd__nand3_1
XFILLER_133_823 vssd1 vssd1 vccd1 vccd1 sky130_fd_sc_hd__fill_1
XANTENNA__08231__A2 _02560_ vssd1 vssd1 vccd1 vccd1 sky130_fd_sc_hd__diode_2
XTAP_TAPCELL_ROW_6_402 vssd1 vccd1 sky130_fd_sc_hd__tapvpwrvgnd_1
XFILLER_120_506 vssd1 vssd1 vccd1 vccd1 sky130_fd_sc_hd__fill_1
Xfanout411 cell2.CB_0.config_dataA\[16\] vssd1 vssd1 vccd1 vccd1 net411 sky130_fd_sc_hd__clkbuf_2
XANTENNA__11118__A2 _05912_ vssd1 vssd1 vccd1 vccd1 sky130_fd_sc_hd__diode_2
Xfanout422 cell2.CB_0.config_dataA\[0\] vssd1 vssd1 vccd1 vccd1 net422 sky130_fd_sc_hd__clkbuf_2
Xfanout400 cell2.CB_1.config_dataB\[15\] vssd1 vssd1 vccd1 vccd1 net400 sky130_fd_sc_hd__buf_2
XANTENNA__08519__A0 net29 vssd1 vssd1 vccd1 vccd1 sky130_fd_sc_hd__diode_2
Xfanout433 cell2.CB_0.config_dataB\[1\] vssd1 vssd1 vccd1 vccd1 net433 sky130_fd_sc_hd__clkbuf_2
Xfanout444 cell2.CB_1.config_dataA\[5\] vssd1 vssd1 vccd1 vccd1 net444 sky130_fd_sc_hd__buf_2
Xfanout466 cell1.CB_0.config_dataA\[11\] vssd1 vssd1 vccd1 vccd1 net466 sky130_fd_sc_hd__buf_2
Xfanout455 cell1.CB_1.config_dataB\[10\] vssd1 vssd1 vccd1 vccd1 net455 sky130_fd_sc_hd__buf_2
XANTENNA_fanout945_A net952 vssd1 vssd1 vccd1 vccd1 sky130_fd_sc_hd__diode_2
X_09827_ net441 _04724_ vssd1 vssd1 vccd1 vccd1 _04833_ sky130_fd_sc_hd__nand2_1
XFILLER_86_475 vssd1 vssd1 vccd1 vccd1 sky130_fd_sc_hd__fill_1
Xfanout477 cell1.CB_0.config_dataB\[15\] vssd1 vssd1 vccd1 vccd1 net477 sky130_fd_sc_hd__clkbuf_2
XFILLER_19_509 vssd1 vssd1 vccd1 vccd1 sky130_fd_sc_hd__fill_4
Xfanout488 cell1.CB_1.config_dataA\[15\] vssd1 vssd1 vccd1 vccd1 net488 sky130_fd_sc_hd__clkbuf_4
Xfanout499 cell0.CB_1.config_dataB\[16\] vssd1 vssd1 vccd1 vccd1 net499 sky130_fd_sc_hd__clkbuf_2
X_09758_ _04763_ _04762_ cell2.CB_1.config_dataA\[7\] vssd1 vssd1 vccd1 vccd1 _04764_
+ sky130_fd_sc_hd__mux2_1
XANTENNA__13485__SET_B net592 vssd1 vssd1 vccd1 vccd1 sky130_fd_sc_hd__diode_2
XANTENNA__10629__B2 net14 vssd1 vssd1 vccd1 vccd1 sky130_fd_sc_hd__diode_2
XANTENNA__10629__A1 net13 vssd1 vssd1 vccd1 vccd1 sky130_fd_sc_hd__diode_2
X_08709_ net27 _03737_ _03738_ net28 cell1.CB_1.config_dataB\[13\] vssd1 vssd1 vccd1
+ vccd1 _03743_ sky130_fd_sc_hd__a221o_1
XANTENNA_fanout733_X net733 vssd1 vssd1 vccd1 vccd1 sky130_fd_sc_hd__diode_2
X_09689_ _01826_ _04700_ _04702_ vssd1 vssd1 vccd1 vccd1 _04703_ sky130_fd_sc_hd__a21oi_1
X_11720_ cell0.LE_0B.config_data\[16\] net1366 net797 vssd1 vssd1 vccd1 vccd1 _00159_
+ sky130_fd_sc_hd__mux2_1
XFILLER_120_41 vccd1 vssd1 vccd1 vssd1 sky130_ef_sc_hd__decap_40_12
XANTENNA_input109_A SBwest_in[20] vssd1 vssd1 vccd1 vccd1 sky130_fd_sc_hd__diode_2
X_11651_ cell0.CB_0.config_dataA\[22\] cell0.CB_0.config_dataA\[21\] net777 vssd1
+ vssd1 vccd1 vccd1 _00092_ sky130_fd_sc_hd__mux2_1
X_14370_ clknet_leaf_65_clk net1411 net744 vssd1 vssd1 vccd1 vccd1 cell3.LE_1A.config_data\[1\]
+ sky130_fd_sc_hd__dfrtp_1
X_10602_ _01789_ _05486_ _05493_ _05559_ cell3.LEI0.config_data\[20\] vssd1 vssd1
+ vccd1 vccd1 _05560_ sky130_fd_sc_hd__o32a_1
XANTENNA__09798__A2 bus3_2\[10\] vssd1 vssd1 vccd1 vccd1 sky130_fd_sc_hd__diode_2
X_11582_ cell0.CB_1.config_dataA\[3\] cell0.CB_1.config_dataA\[2\] net788 vssd1 vssd1
+ vccd1 vccd1 _00023_ sky130_fd_sc_hd__mux2_1
XFILLER_127_105 vssd1 vssd1 vccd1 vccd1 sky130_fd_sc_hd__fill_1
X_10533_ net395 net394 vssd1 vssd1 vccd1 vccd1 _05491_ sky130_fd_sc_hd__or2_1
X_13321_ clknet_leaf_87_clk _00293_ net689 vssd1 vssd1 vccd1 vccd1 cell1.CB_0.config_dataB\[12\]
+ sky130_fd_sc_hd__dfstp_2
XANTENNA__10574__A _05531_ vssd1 vssd1 vccd1 vccd1 sky130_fd_sc_hd__diode_2
XFILLER_10_475 vssd1 vssd1 vccd1 vccd1 sky130_fd_sc_hd__fill_1
XFILLER_129_61 vssd1 vssd1 vccd1 vccd1 sky130_fd_sc_hd__fill_2
XTAP_TAPCELL_ROW_94_1723 vssd1 vccd1 sky130_fd_sc_hd__tapvpwrvgnd_1
X_10464_ _01737_ cell3.SB0.route_sel\[98\] cell3.SB0.route_sel\[101\] _01740_ _05449_
+ vssd1 vssd1 vccd1 vccd1 _05450_ sky130_fd_sc_hd__a221o_1
XTAP_TAPCELL_ROW_94_1712 vssd1 vccd1 sky130_fd_sc_hd__tapvpwrvgnd_1
XFILLER_89_43 vssd1 vssd1 vccd1 vccd1 sky130_fd_sc_hd__fill_2
X_13252_ clknet_leaf_11_clk _00224_ net586 vssd1 vssd1 vccd1 vccd1 cell0.LEI0.config_data\[37\]
+ sky130_fd_sc_hd__dfrtp_1
XANTENNA_input74_A SBsouth_in[18] vssd1 vssd1 vccd1 vccd1 sky130_fd_sc_hd__diode_2
X_10395_ net63 net64 net34 net35 net425 cell2.CB_0.config_dataB\[16\] vssd1 vssd1
+ vccd1 vccd1 _05394_ sky130_fd_sc_hd__mux4_1
X_12203_ net437 net439 net834 vssd1 vssd1 vccd1 vccd1 _00636_ sky130_fd_sc_hd__mux2_1
X_13183_ clknet_leaf_14_clk _00155_ net600 vssd1 vssd1 vccd1 vccd1 cell0.LE_0B.config_data\[12\]
+ sky130_fd_sc_hd__dfrtp_1
XANTENNA__09970__A2 _04724_ vssd1 vssd1 vccd1 vccd1 sky130_fd_sc_hd__diode_2
X_12134_ net1140 net1183 net896 vssd1 vssd1 vccd1 vccd1 _00567_ sky130_fd_sc_hd__mux2_1
XFILLER_2_641 vssd1 vssd1 vccd1 vccd1 sky130_fd_sc_hd__fill_2
XANTENNA__11109__A2 _05890_ vssd1 vssd1 vccd1 vccd1 sky130_fd_sc_hd__diode_2
XFILLER_111_539 vssd1 vssd1 vccd1 vccd1 sky130_fd_sc_hd__fill_1
XFILLER_49_111 vssd1 vssd1 vccd1 vccd1 sky130_fd_sc_hd__fill_1
XPHY_EDGE_ROW_8_Left_151 vssd1 vssd1 vccd1 vccd1 sky130_fd_sc_hd__decap_3
X_12065_ cell1.LE_1A.config_data\[16\] net1000 net890 vssd1 vssd1 vccd1 vccd1 _00501_
+ sky130_fd_sc_hd__mux2_1
X_11016_ _05968_ _05969_ cell3.CB_0.config_dataA\[12\] vssd1 vssd1 vccd1 vccd1 _05970_
+ sky130_fd_sc_hd__mux2_1
XANTENNA_output230_A net230 vssd1 vssd1 vccd1 vccd1 sky130_fd_sc_hd__diode_2
XANTENNA__06786__X _01856_ vssd1 vssd1 vccd1 vccd1 sky130_fd_sc_hd__diode_2
XANTENNA__06941__C1 net551 vssd1 vssd1 vccd1 vccd1 sky130_fd_sc_hd__diode_2
XANTENNA__11817__A0 net1547 vssd1 vssd1 vccd1 vccd1 sky130_fd_sc_hd__diode_2
XFILLER_18_531 vssd1 vssd1 vccd1 vccd1 sky130_fd_sc_hd__fill_1
X_12967_ net1107 cell3.LE_0A.config_data\[9\] net928 vssd1 vssd1 vccd1 vccd1 _01395_
+ sky130_fd_sc_hd__mux2_1
XTAP_TAPCELL_ROW_121_2119 vssd1 vccd1 sky130_fd_sc_hd__tapvpwrvgnd_1
XANTENNA__11396__A_N _02037_ vssd1 vssd1 vccd1 vccd1 sky130_fd_sc_hd__diode_2
X_12898_ cell3.CB_1.config_dataB\[12\] net366 net941 vssd1 vssd1 vccd1 vccd1 _01327_
+ sky130_fd_sc_hd__mux2_1
XANTENNA__11293__A1 _05513_ vssd1 vssd1 vccd1 vccd1 sky130_fd_sc_hd__diode_2
X_11918_ cell0.SB0.route_sel\[24\] cell0.SB0.route_sel\[23\] net762 vssd1 vssd1 vccd1
+ vccd1 _00355_ sky130_fd_sc_hd__mux2_1
XTAP_TAPCELL_ROW_103_1852 vssd1 vccd1 sky130_fd_sc_hd__tapvpwrvgnd_1
X_11849_ net483 cell1.CB_0.config_dataB\[4\] net897 vssd1 vssd1 vccd1 vccd1 _00286_
+ sky130_fd_sc_hd__mux2_1
XFILLER_21_729 vssd1 vssd1 vccd1 vccd1 sky130_fd_sc_hd__fill_1
XANTENNA__09789__A2 bus3_2\[13\] vssd1 vssd1 vccd1 vccd1 sky130_fd_sc_hd__diode_2
XANTENNA__08997__A0 bus3_1\[6\] vssd1 vssd1 vccd1 vccd1 sky130_fd_sc_hd__diode_2
XFILLER_9_251 vssd1 vssd1 vccd1 vccd1 sky130_fd_sc_hd__fill_2
XTAP_TAPCELL_ROW_31_768 vssd1 vccd1 sky130_fd_sc_hd__tapvpwrvgnd_1
XTAP_TAPCELL_ROW_136_2351 vssd1 vccd1 sky130_fd_sc_hd__tapvpwrvgnd_1
X_13519_ clknet_leaf_100_clk _00491_ net680 vssd1 vssd1 vccd1 vccd1 cell1.LE_1A.config_data\[6\]
+ sky130_fd_sc_hd__dfrtp_1
XTAP_TAPCELL_ROW_31_779 vssd1 vccd1 sky130_fd_sc_hd__tapvpwrvgnd_1
Xclkload10 clknet_4_10_0_clk vssd1 vssd1 vccd1 vccd1 clkload10/Y sky130_fd_sc_hd__inv_6
X_07040_ _02080_ _02103_ _02104_ vssd1 vssd1 vccd1 vccd1 _02105_ sky130_fd_sc_hd__nand3_2
Xclkload43 clknet_leaf_19_clk vssd1 vssd1 vccd1 vccd1 clkload43/X sky130_fd_sc_hd__clkbuf_4
Xclkload32 clknet_leaf_126_clk vssd1 vssd1 vccd1 vccd1 clkload32/Y sky130_fd_sc_hd__bufinv_16
XTAP_TAPCELL_ROW_11_470 vssd1 vccd1 sky130_fd_sc_hd__tapvpwrvgnd_1
Xclkload21 clknet_leaf_134_clk vssd1 vssd1 vccd1 vccd1 clkload21/Y sky130_fd_sc_hd__inv_4
Xclkload65 clknet_leaf_36_clk vssd1 vssd1 vccd1 vccd1 clkload65/Y sky130_fd_sc_hd__inv_6
Xclkload54 clknet_leaf_32_clk vssd1 vssd1 vccd1 vccd1 clkload54/Y sky130_fd_sc_hd__clkinv_8
XANTENNA__12903__S net940 vssd1 vssd1 vccd1 vccd1 sky130_fd_sc_hd__diode_2
Xclkload87 clknet_leaf_98_clk vssd1 vssd1 vccd1 vccd1 clkload87/Y sky130_fd_sc_hd__inv_4
Xclkload76 clknet_leaf_111_clk vssd1 vssd1 vccd1 vccd1 clkload76/Y sky130_fd_sc_hd__bufinv_16
XFILLER_141_130 vssd1 vssd1 vccd1 vccd1 sky130_fd_sc_hd__fill_1
XANTENNA__09410__B2 _04432_ vssd1 vssd1 vccd1 vccd1 sky130_fd_sc_hd__diode_2
Xclkload98 clknet_leaf_92_clk vssd1 vssd1 vccd1 vccd1 clkload98/Y sky130_fd_sc_hd__clkinv_8
XFILLER_114_388 vssd1 vssd1 vccd1 vccd1 sky130_fd_sc_hd__fill_2
X_08991_ net481 net482 vssd1 vssd1 vccd1 vccd1 _04021_ sky130_fd_sc_hd__and2b_1
XANTENNA__08764__A3 net323 vssd1 vssd1 vccd1 vccd1 sky130_fd_sc_hd__diode_2
XFILLER_102_539 vssd1 vssd1 vccd1 vccd1 sky130_fd_sc_hd__fill_1
XFILLER_68_431 vssd1 vssd1 vccd1 vccd1 sky130_fd_sc_hd__fill_2
X_07942_ net511 _02985_ vssd1 vssd1 vccd1 vccd1 _02986_ sky130_fd_sc_hd__and2_1
XANTENNA__10859__B2 net14 vssd1 vssd1 vccd1 vccd1 sky130_fd_sc_hd__diode_2
XANTENNA__10859__A1 net13 vssd1 vssd1 vccd1 vccd1 sky130_fd_sc_hd__diode_2
X_07873_ cell0.LEI0.config_data\[14\] _02916_ _02915_ _02914_ vssd1 vssd1 vccd1 vccd1
+ _02917_ sky130_fd_sc_hd__o211a_1
XANTENNA__08516__A3 net26 vssd1 vssd1 vccd1 vccd1 sky130_fd_sc_hd__diode_2
X_09612_ _04628_ _04618_ vssd1 vssd1 vccd1 vccd1 _04629_ sky130_fd_sc_hd__nand2b_1
X_06824_ bus3_1\[6\] _01891_ _01892_ vssd1 vssd1 vccd1 vccd1 _01894_ sky130_fd_sc_hd__a21o_1
XANTENNA__06932__C1 _01989_ vssd1 vssd1 vccd1 vccd1 sky130_fd_sc_hd__diode_2
X_09543_ cell3.SB0.route_sel\[75\] cell3.SB0.route_sel\[74\] vssd1 vssd1 vccd1 vccd1
+ _04562_ sky130_fd_sc_hd__nand2_1
X_06755_ net277 vssd1 vssd1 vccd1 vccd1 _01825_ sky130_fd_sc_hd__inv_2
X_06686_ cell2.CB_0.config_dataB\[8\] vssd1 vssd1 vccd1 vccd1 _01756_ sky130_fd_sc_hd__inv_2
X_09474_ cell2.SB0.route_sel\[56\] cell2.SB0.route_sel\[57\] vssd1 vssd1 vccd1 vccd1
+ _04495_ sky130_fd_sc_hd__nand2b_1
XTAP_TAPCELL_ROW_19_592 vssd1 vccd1 sky130_fd_sc_hd__tapvpwrvgnd_1
XFILLER_24_545 vssd1 vssd1 vccd1 vccd1 sky130_fd_sc_hd__fill_1
X_08425_ _01494_ cell0.LE_1B.dff_out vssd1 vssd1 vccd1 vccd1 _03462_ sky130_fd_sc_hd__or2_1
X_08356_ net503 net502 _02040_ _03393_ vssd1 vssd1 vccd1 vccd1 _03394_ sky130_fd_sc_hd__o31a_1
Xclkload4 clknet_4_4_0_clk vssd1 vssd1 vccd1 vccd1 clkload4/Y sky130_fd_sc_hd__inv_6
XANTENNA__07320__X _02377_ vssd1 vssd1 vccd1 vccd1 sky130_fd_sc_hd__diode_2
X_07307_ cell1.CB_0.config_dataA\[22\] cell1.CB_0.config_dataA\[23\] vssd1 vssd1 vccd1
+ vccd1 _02365_ sky130_fd_sc_hd__nand2_1
XANTENNA_fanout314_X net314 vssd1 vssd1 vccd1 vccd1 sky130_fd_sc_hd__diode_2
X_08287_ net505 _01490_ _02425_ _03324_ vssd1 vssd1 vccd1 vccd1 _03325_ sky130_fd_sc_hd__o31a_1
XFILLER_137_458 vssd1 vssd1 vccd1 vccd1 sky130_fd_sc_hd__fill_1
X_07238_ _02295_ _02297_ vssd1 vssd1 vccd1 vccd1 bus1_0\[11\] sky130_fd_sc_hd__and2b_2
XTAP_TAPCELL_ROW_76_1442 vssd1 vccd1 sky130_fd_sc_hd__tapvpwrvgnd_1
XANTENNA_fanout895_A net898 vssd1 vssd1 vccd1 vccd1 sky130_fd_sc_hd__diode_2
XFILLER_3_405 vccd1 vssd1 vccd1 vssd1 sky130_ef_sc_hd__decap_40_12
X_07169_ cell1.SB0.route_sel\[84\] cell1.SB0.route_sel\[85\] vssd1 vssd1 vccd1 vccd1
+ _02231_ sky130_fd_sc_hd__nand2b_1
XANTENNA__07412__B1 _02466_ vssd1 vssd1 vccd1 vccd1 sky130_fd_sc_hd__diode_2
XFILLER_79_707 vssd1 vssd1 vccd1 vccd1 sky130_fd_sc_hd__fill_1
XTAP_TAPCELL_ROW_76_1453 vssd1 vccd1 sky130_fd_sc_hd__tapvpwrvgnd_1
XFILLER_3_449 vccd1 vssd1 vccd1 vssd1 sky130_ef_sc_hd__decap_40_12
X_10180_ _05170_ _05174_ _05180_ _01766_ _05179_ vssd1 vssd1 vccd1 vccd1 _05181_ sky130_fd_sc_hd__a221o_1
XFILLER_120_314 vssd1 vssd1 vccd1 vccd1 sky130_fd_sc_hd__fill_1
XANTENNA__09165__B1 _04192_ vssd1 vssd1 vccd1 vccd1 sky130_fd_sc_hd__diode_2
Xfanout285 net286 vssd1 vssd1 vccd1 vccd1 net285 sky130_fd_sc_hd__clkbuf_2
XFILLER_101_561 vssd1 vssd1 vccd1 vccd1 sky130_fd_sc_hd__fill_1
X_13870_ clknet_leaf_17_clk _00842_ net628 vssd1 vssd1 vccd1 vccd1 cell2.CB_1.config_dataB\[19\]
+ sky130_fd_sc_hd__dfstp_1
Xfanout296 cell3.CB_1.le_outA vssd1 vssd1 vccd1 vccd1 net296 sky130_fd_sc_hd__clkbuf_2
XFILLER_47_615 vssd1 vssd1 vccd1 vccd1 sky130_fd_sc_hd__fill_1
XANTENNA__08912__A0 bus3_1\[0\] vssd1 vssd1 vccd1 vccd1 sky130_fd_sc_hd__diode_2
XANTENNA__07715__A1 _01933_ vssd1 vssd1 vccd1 vccd1 sky130_fd_sc_hd__diode_2
X_12821_ cell2.SB0.route_sel\[63\] cell2.SB0.route_sel\[62\] net809 vssd1 vssd1 vccd1
+ vccd1 _01250_ sky130_fd_sc_hd__mux2_1
XFILLER_131_51 vssd1 vssd1 vccd1 vccd1 sky130_fd_sc_hd__fill_4
X_12752_ cell3.CB_0.config_dataA\[19\] cell3.CB_0.config_dataA\[18\] net929 vssd1
+ vssd1 vccd1 vccd1 _01181_ sky130_fd_sc_hd__mux2_1
X_12683_ cell3.CB_1.config_dataA\[0\] cell3.CB_0.config_dataB\[24\] net923 vssd1 vssd1
+ vccd1 vccd1 _01112_ sky130_fd_sc_hd__mux2_1
X_11703_ net960 net548 _06374_ vssd1 vssd1 vccd1 vccd1 _00142_ sky130_fd_sc_hd__a21bo_1
X_14422_ clknet_leaf_38_clk _01394_ net648 vssd1 vssd1 vccd1 vccd1 cell3.LE_0A.config_data\[9\]
+ sky130_fd_sc_hd__dfrtp_1
X_11634_ net518 cell0.CB_0.config_dataA\[4\] net771 vssd1 vssd1 vccd1 vccd1 _00075_
+ sky130_fd_sc_hd__mux2_1
XFILLER_15_589 vssd1 vssd1 vccd1 vccd1 sky130_fd_sc_hd__fill_2
X_14353_ clknet_leaf_69_clk _01325_ net732 vssd1 vssd1 vccd1 vccd1 cell3.CB_1.config_dataB\[10\]
+ sky130_fd_sc_hd__dfstp_1
XANTENNA__08045__Y _03087_ vssd1 vssd1 vccd1 vccd1 sky130_fd_sc_hd__diode_2
X_11565_ net1188 net1089 net802 vssd1 vssd1 vccd1 vccd1 _00006_ sky130_fd_sc_hd__mux2_1
XANTENNA_output180_A net180 vssd1 vssd1 vccd1 vccd1 sky130_fd_sc_hd__diode_2
XANTENNA__10250__A2 _05107_ vssd1 vssd1 vccd1 vccd1 sky130_fd_sc_hd__diode_2
XTAP_TAPCELL_ROW_118_2081 vssd1 vccd1 sky130_fd_sc_hd__tapvpwrvgnd_1
X_11496_ _01594_ cell2.SB0.route_sel\[26\] vssd1 vssd1 vccd1 vccd1 _06331_ sky130_fd_sc_hd__nand2_1
X_10516_ cell3.SB0.route_sel\[56\] _01713_ cell3.SB0.route_sel\[60\] cell3.SB0.route_sel\[61\]
+ _05473_ vssd1 vssd1 vccd1 vccd1 _05474_ sky130_fd_sc_hd__o221a_1
X_14284_ clknet_leaf_21_clk _01256_ net610 vssd1 vssd1 vccd1 vccd1 cell2.SB0.route_sel\[69\]
+ sky130_fd_sc_hd__dfstp_1
XANTENNA_input77_X net77 vssd1 vssd1 vccd1 vccd1 sky130_fd_sc_hd__diode_2
X_13304_ clknet_leaf_101_clk _00276_ net677 vssd1 vssd1 vccd1 vccd1 cell1.CB_1.config_dataA\[20\]
+ sky130_fd_sc_hd__dfstp_1
X_10447_ _05438_ _04492_ vssd1 vssd1 vccd1 vccd1 bus3_2\[6\] sky130_fd_sc_hd__and2b_2
X_13235_ clknet_leaf_123_clk _00207_ net587 vssd1 vssd1 vccd1 vccd1 cell0.LEI0.config_data\[20\]
+ sky130_fd_sc_hd__dfrtp_1
XANTENNA__12723__S net932 vssd1 vssd1 vccd1 vccd1 sky130_fd_sc_hd__diode_2
XANTENNA__10002__A2 _04583_ vssd1 vssd1 vccd1 vccd1 sky130_fd_sc_hd__diode_2
XTAP_TAPCELL_ROW_131_2270 vssd1 vccd1 sky130_fd_sc_hd__tapvpwrvgnd_1
X_10378_ _05371_ _05376_ cell2.CB_0.config_dataB\[14\] _05362_ vssd1 vssd1 vccd1 vccd1
+ _05377_ sky130_fd_sc_hd__a211o_1
XFILLER_112_826 vssd1 vssd1 vccd1 vccd1 sky130_fd_sc_hd__fill_1
X_13166_ clknet_leaf_119_clk _00138_ net598 vssd1 vssd1 vccd1 vccd1 cell0.LE_1A.edge_mode
+ sky130_fd_sc_hd__dfstp_1
XANTENNA__07954__A1 _02074_ vssd1 vssd1 vccd1 vccd1 sky130_fd_sc_hd__diode_2
XFILLER_97_559 vssd1 vssd1 vccd1 vccd1 sky130_fd_sc_hd__fill_1
X_12117_ net972 net548 _06380_ vssd1 vssd1 vccd1 vccd1 _00550_ sky130_fd_sc_hd__a21bo_1
X_13097_ clknet_leaf_9_clk _00069_ net588 vssd1 vssd1 vccd1 vccd1 cell0.CB_0.config_dataB\[24\]
+ sky130_fd_sc_hd__dfstp_2
XANTENNA__07954__B2 _02172_ vssd1 vssd1 vccd1 vccd1 sky130_fd_sc_hd__diode_2
X_12048_ net962 net550 _06377_ vssd1 vssd1 vccd1 vccd1 _00484_ sky130_fd_sc_hd__a21bo_1
XANTENNA__08903__B1 _03934_ vssd1 vssd1 vccd1 vccd1 sky130_fd_sc_hd__diode_2
XFILLER_65_445 vssd1 vssd1 vccd1 vccd1 sky130_fd_sc_hd__fill_2
XANTENNA__11074__S _05930_ vssd1 vssd1 vccd1 vccd1 sky130_fd_sc_hd__diode_2
XANTENNA__09459__A1 net15 vssd1 vssd1 vccd1 vccd1 sky130_fd_sc_hd__diode_2
X_13999_ clknet_leaf_79_clk _00971_ net708 vssd1 vssd1 vccd1 vccd1 cell3.SB0.route_sel\[7\]
+ sky130_fd_sc_hd__dfstp_1
XFILLER_53_607 vssd1 vssd1 vccd1 vccd1 sky130_fd_sc_hd__fill_1
XANTENNA__12463__A0 cell2.LE_0A.config_data\[0\] vssd1 vssd1 vccd1 vccd1 sky130_fd_sc_hd__diode_2
XTAP_TAPCELL_ROW_47_1010 vssd1 vccd1 sky130_fd_sc_hd__tapvpwrvgnd_1
X_06540_ cell0.SB0.route_sel\[44\] vssd1 vssd1 vccd1 vccd1 _01610_ sky130_fd_sc_hd__inv_2
XTAP_TAPCELL_ROW_36_849 vssd1 vccd1 sky130_fd_sc_hd__tapvpwrvgnd_1
XTAP_TAPCELL_ROW_16_551 vssd1 vccd1 sky130_fd_sc_hd__tapvpwrvgnd_1
X_06471_ cell1.SB0.route_sel\[99\] vssd1 vssd1 vccd1 vccd1 _01541_ sky130_fd_sc_hd__inv_2
XANTENNA__06963__Y _02029_ vssd1 vssd1 vccd1 vccd1 sky130_fd_sc_hd__diode_2
XTAP_TAPCELL_ROW_60_1210 vssd1 vccd1 sky130_fd_sc_hd__tapvpwrvgnd_1
XANTENNA__11802__S net902 vssd1 vssd1 vccd1 vccd1 sky130_fd_sc_hd__diode_2
X_08210_ net539 _01956_ vssd1 vssd1 vccd1 vccd1 _03250_ sky130_fd_sc_hd__nand2_1
X_09190_ cell3.CB_0.config_dataA\[24\] cell3.CB_0.config_dataA\[21\] cell3.CB_0.config_dataA\[20\]
+ vssd1 vssd1 vccd1 vccd1 _04218_ sky130_fd_sc_hd__or3_2
X_08141_ net547 _01877_ _03180_ net545 vssd1 vssd1 vccd1 vccd1 _03181_ sky130_fd_sc_hd__o211a_1
XANTENNA__08434__A2 _03465_ vssd1 vssd1 vccd1 vccd1 sky130_fd_sc_hd__diode_2
Xclkload110 clknet_leaf_52_clk vssd1 vssd1 vccd1 vccd1 clkload110/Y sky130_fd_sc_hd__clkinv_8
Xclkload121 clknet_leaf_75_clk vssd1 vssd1 vccd1 vccd1 clkload121/Y sky130_fd_sc_hd__inv_8
X_08072_ bus2_0\[0\] bus2_0\[1\] bus2_0\[2\] bus2_0\[3\] net527 net526 vssd1 vssd1
+ vccd1 vccd1 _03114_ sky130_fd_sc_hd__mux4_1
Xclkload132 clknet_leaf_68_clk vssd1 vssd1 vccd1 vccd1 clkload132/Y sky130_fd_sc_hd__inv_16
X_07023_ cell2.CB_1.config_dataA\[22\] cell2.CB_1.config_dataA\[23\] vssd1 vssd1 vccd1
+ vccd1 _02088_ sky130_fd_sc_hd__nand2b_1
XANTENNA__07794__Y _02839_ vssd1 vssd1 vccd1 vccd1 sky130_fd_sc_hd__diode_2
Xclkload143 clknet_1_1__leaf_cell1.LE_1A.sel_clk vssd1 vssd1 vccd1 vccd1 clkload143/X
+ sky130_fd_sc_hd__clkbuf_4
XFILLER_20_29 vccd1 vssd1 vccd1 vssd1 sky130_ef_sc_hd__decap_40_12
XFILLER_136_29 vccd1 vssd1 vccd1 vssd1 sky130_ef_sc_hd__decap_40_12
XTAP_TAPCELL_ROW_58_1183 vssd1 vccd1 sky130_fd_sc_hd__tapvpwrvgnd_1
XTAP_TAPCELL_ROW_58_1172 vssd1 vccd1 sky130_fd_sc_hd__tapvpwrvgnd_1
XFILLER_114_185 vssd1 vssd1 vccd1 vccd1 sky130_fd_sc_hd__fill_1
X_08974_ cell1.CB_0.config_dataA\[18\] cell1.CB_0.config_dataA\[17\] _04004_ _04005_
+ vssd1 vssd1 vccd1 vccd1 _04006_ sky130_fd_sc_hd__o31a_1
Xhold27 cell3.LE_0A.config_data\[5\] vssd1 vssd1 vccd1 vccd1 net986 sky130_fd_sc_hd__dlygate4sd3_1
XPHY_EDGE_ROW_89_Right_89 vssd1 vssd1 vccd1 vccd1 sky130_fd_sc_hd__decap_3
Xhold38 cell0.LE_0A.config_data\[1\] vssd1 vssd1 vccd1 vccd1 net997 sky130_fd_sc_hd__dlygate4sd3_1
XTAP_TAPCELL_ROW_71_1372 vssd1 vccd1 sky130_fd_sc_hd__tapvpwrvgnd_1
X_07925_ net515 _02235_ _02968_ net514 vssd1 vssd1 vccd1 vccd1 _02969_ sky130_fd_sc_hd__o211a_1
Xhold16 cell0.LE_1B.dff0_out vssd1 vssd1 vccd1 vccd1 net975 sky130_fd_sc_hd__dlygate4sd3_1
XFILLER_29_27 vccd1 vssd1 vccd1 vssd1 sky130_ef_sc_hd__decap_40_12
XANTENNA__13919__SET_B net752 vssd1 vssd1 vccd1 vccd1 sky130_fd_sc_hd__diode_2
XFILLER_84_721 vssd1 vssd1 vccd1 vccd1 sky130_fd_sc_hd__fill_1
Xhold49 cell1.LE_1A.config_data\[9\] vssd1 vssd1 vccd1 vccd1 net1008 sky130_fd_sc_hd__dlygate4sd3_1
XFILLER_29_615 vssd1 vssd1 vccd1 vccd1 sky130_fd_sc_hd__fill_1
XANTENNA__10701__A0 net15 vssd1 vssd1 vccd1 vccd1 sky130_fd_sc_hd__diode_2
X_07856_ cell0.SB0.route_sel\[6\] cell0.SB0.route_sel\[7\] vssd1 vssd1 vccd1 vccd1
+ _02900_ sky130_fd_sc_hd__nand2b_1
XANTENNA_fanout643_A net649 vssd1 vssd1 vccd1 vccd1 sky130_fd_sc_hd__diode_2
XFILLER_16_309 vssd1 vssd1 vccd1 vccd1 sky130_fd_sc_hd__fill_4
X_06807_ net299 _01876_ vssd1 vssd1 vccd1 vccd1 _01877_ sky130_fd_sc_hd__nand2_4
X_07787_ _02831_ _02827_ _02828_ vssd1 vssd1 vccd1 vccd1 _02832_ sky130_fd_sc_hd__mux2_1
X_06738_ cell3.LEI0.config_data\[14\] vssd1 vssd1 vccd1 vccd1 _01808_ sky130_fd_sc_hd__inv_2
X_09526_ _04218_ _04545_ vssd1 vssd1 vccd1 vccd1 _04546_ sky130_fd_sc_hd__nor2_1
XANTENNA__06920__A2 net267 vssd1 vssd1 vccd1 vccd1 sky130_fd_sc_hd__diode_2
X_09457_ _04307_ _04403_ vssd1 vssd1 vccd1 vccd1 _04479_ sky130_fd_sc_hd__nor2_1
XPHY_EDGE_ROW_98_Right_98 vssd1 vssd1 vccd1 vccd1 sky130_fd_sc_hd__decap_3
X_06669_ cell3.SB0.route_sel\[102\] vssd1 vssd1 vccd1 vccd1 _01739_ sky130_fd_sc_hd__inv_2
XANTENNA_fanout908_A net959 vssd1 vssd1 vccd1 vccd1 sky130_fd_sc_hd__diode_2
XANTENNA__08673__A2 _03486_ vssd1 vssd1 vccd1 vccd1 sky130_fd_sc_hd__diode_2
X_08408_ _03441_ _03445_ cell0.CB_1.config_dataB\[19\] vssd1 vssd1 vccd1 vccd1 _03446_
+ sky130_fd_sc_hd__a21oi_1
X_09388_ net380 net381 vssd1 vssd1 vccd1 vccd1 _04412_ sky130_fd_sc_hd__nand2b_1
XFILLER_12_559 vssd1 vssd1 vccd1 vccd1 sky130_fd_sc_hd__fill_2
X_08339_ _03369_ _03372_ _03376_ cell0.CB_1.config_dataB\[3\] vssd1 vssd1 vccd1 vccd1
+ _03377_ sky130_fd_sc_hd__and4bb_1
X_11350_ _04625_ _06240_ _04627_ vssd1 vssd1 vccd1 vccd1 net185 sky130_fd_sc_hd__o21ai_2
XANTENNA__07210__B _02032_ vssd1 vssd1 vccd1 vccd1 sky130_fd_sc_hd__diode_2
XFILLER_20_592 vssd1 vssd1 vccd1 vccd1 sky130_fd_sc_hd__fill_4
X_10301_ net431 _05088_ _05299_ net430 vssd1 vssd1 vccd1 vccd1 _05300_ sky130_fd_sc_hd__o211a_1
XFILLER_117_3 vccd1 vssd1 vccd1 vssd1 sky130_ef_sc_hd__decap_40_12
XPHY_EDGE_ROW_89_Left_232 vssd1 vssd1 vccd1 vccd1 sky130_fd_sc_hd__decap_3
XANTENNA_fanout898_X net898 vssd1 vssd1 vccd1 vccd1 sky130_fd_sc_hd__diode_2
XFILLER_4_725 vccd1 vssd1 vccd1 vssd1 sky130_ef_sc_hd__decap_40_12
X_13020_ cell3.LEI0.config_data\[41\] net1424 net949 vssd1 vssd1 vccd1 vccd1 _01448_
+ sky130_fd_sc_hd__mux2_1
X_11281_ _05107_ net307 _02532_ vssd1 vssd1 vccd1 vccd1 _06209_ sky130_fd_sc_hd__mux2_1
XANTENNA__11300__X net144 vssd1 vssd1 vccd1 vccd1 sky130_fd_sc_hd__diode_2
XANTENNA__08189__A1 net346 vssd1 vssd1 vccd1 vccd1 sky130_fd_sc_hd__diode_2
X_10232_ net412 _05144_ vssd1 vssd1 vccd1 vccd1 _05233_ sky130_fd_sc_hd__nand2_1
XANTENNA__10615__S0 net398 vssd1 vssd1 vccd1 vccd1 sky130_fd_sc_hd__diode_2
XFILLER_4_769 vccd1 vssd1 vccd1 vssd1 sky130_ef_sc_hd__decap_40_12
XFILLER_120_100 vssd1 vssd1 vccd1 vccd1 sky130_fd_sc_hd__fill_1
X_10163_ _05121_ _05161_ _05163_ vssd1 vssd1 vccd1 vccd1 _05164_ sky130_fd_sc_hd__a21oi_2
XFILLER_105_196 vssd1 vssd1 vccd1 vccd1 sky130_fd_sc_hd__fill_1
XFILLER_3_279 vssd1 vssd1 vccd1 vccd1 sky130_fd_sc_hd__fill_1
XANTENNA_input37_A CBnorth_in[13] vssd1 vssd1 vccd1 vccd1 sky130_fd_sc_hd__diode_2
XFILLER_121_689 vssd1 vssd1 vccd1 vccd1 sky130_fd_sc_hd__fill_1
X_10094_ cell2.SB0.route_sel\[67\] cell2.SB0.route_sel\[66\] vssd1 vssd1 vccd1 vccd1
+ _05095_ sky130_fd_sc_hd__nor2_1
X_13922_ clknet_leaf_25_clk _00894_ net608 vssd1 vssd1 vccd1 vccd1 cell2.LE_0A.config_data\[1\]
+ sky130_fd_sc_hd__dfrtp_1
XPHY_EDGE_ROW_98_Left_241 vssd1 vssd1 vccd1 vccd1 sky130_fd_sc_hd__decap_3
XTAP_TAPCELL_ROW_89_1644 vssd1 vccd1 sky130_fd_sc_hd__tapvpwrvgnd_1
XFILLER_75_754 vssd1 vssd1 vccd1 vccd1 sky130_fd_sc_hd__fill_1
XFILLER_47_434 vssd1 vssd1 vccd1 vccd1 sky130_fd_sc_hd__fill_1
XANTENNA_input131_X net131 vssd1 vssd1 vccd1 vccd1 sky130_fd_sc_hd__diode_2
XANTENNA__08361__A1 _02846_ vssd1 vssd1 vccd1 vccd1 sky130_fd_sc_hd__diode_2
X_13853_ clknet_leaf_45_clk _00825_ net630 vssd1 vssd1 vccd1 vccd1 cell2.CB_1.config_dataB\[2\]
+ sky130_fd_sc_hd__dfstp_2
XANTENNA__08361__B2 _02807_ vssd1 vssd1 vccd1 vccd1 sky130_fd_sc_hd__diode_2
XFILLER_19_169 vssd1 vssd1 vccd1 vccd1 sky130_fd_sc_hd__fill_1
X_12804_ cell2.SB0.route_sel\[46\] cell2.SB0.route_sel\[45\] net813 vssd1 vssd1 vccd1
+ vccd1 _01233_ sky130_fd_sc_hd__mux2_1
XFILLER_90_757 vssd1 vssd1 vccd1 vccd1 sky130_fd_sc_hd__fill_1
X_10996_ cell3.CB_0.config_dataA\[8\] cell3.CB_0.config_dataA\[7\] vssd1 vssd1 vccd1
+ vccd1 _05950_ sky130_fd_sc_hd__nor2_1
X_13784_ clknet_leaf_108_clk _00756_ net651 vssd1 vssd1 vccd1 vccd1 cell1.SB0.route_sel\[61\]
+ sky130_fd_sc_hd__dfstp_1
XTAP_TAPCELL_ROW_33_808 vssd1 vccd1 sky130_fd_sc_hd__tapvpwrvgnd_1
XANTENNA__12718__S net932 vssd1 vssd1 vccd1 vccd1 sky130_fd_sc_hd__diode_2
X_12735_ cell3.CB_0.config_dataA\[2\] net378 net924 vssd1 vssd1 vccd1 vccd1 _01164_
+ sky130_fd_sc_hd__mux2_1
XTAP_TAPCELL_ROW_100_1811 vssd1 vccd1 sky130_fd_sc_hd__tapvpwrvgnd_1
XFILLER_30_301 vssd1 vssd1 vccd1 vccd1 sky130_fd_sc_hd__fill_1
X_12666_ net1325 net1221 net958 vssd1 vssd1 vccd1 vccd1 _01095_ sky130_fd_sc_hd__mux2_1
XFILLER_89_7 vssd1 vssd1 vccd1 vccd1 sky130_fd_sc_hd__fill_1
XTAP_TAPCELL_ROW_13_510 vssd1 vccd1 sky130_fd_sc_hd__tapvpwrvgnd_1
XANTENNA__07872__A0 net342 vssd1 vssd1 vccd1 vccd1 sky130_fd_sc_hd__diode_2
X_14405_ clknet_leaf_61_clk net1133 net739 vssd1 vssd1 vccd1 vccd1 cell3.LE_0B.config_data\[14\]
+ sky130_fd_sc_hd__dfrtp_1
XFILLER_129_723 vssd1 vssd1 vccd1 vccd1 sky130_fd_sc_hd__fill_1
X_12597_ cell3.SB0.route_sel\[62\] cell3.SB0.route_sel\[61\] net834 vssd1 vssd1 vccd1
+ vccd1 _01026_ sky130_fd_sc_hd__mux2_1
X_11617_ cell0.CB_0.config_dataB\[13\] cell0.CB_0.config_dataB\[12\] net769 vssd1
+ vssd1 vccd1 vccd1 _00058_ sky130_fd_sc_hd__mux2_1
XANTENNA__07401__A _02422_ vssd1 vssd1 vccd1 vccd1 sky130_fd_sc_hd__diode_2
XTAP_TAPCELL_ROW_133_2310 vssd1 vccd1 sky130_fd_sc_hd__tapvpwrvgnd_1
X_14336_ clknet_leaf_18_clk _01308_ net614 vssd1 vssd1 vccd1 vccd1 cell2.SB0.route_sel\[121\]
+ sky130_fd_sc_hd__dfstp_1
X_11548_ _01590_ cell0.SB0.route_sel\[18\] cell0.SB0.route_sel\[17\] _01817_ _06365_
+ vssd1 vssd1 vccd1 vccd1 _06366_ sky130_fd_sc_hd__o221a_1
Xhold508 cell3.LE_1A.config_data\[6\] vssd1 vssd1 vccd1 vccd1 net1467 sky130_fd_sc_hd__dlygate4sd3_1
XANTENNA__10774__A3 net20 vssd1 vssd1 vccd1 vccd1 sky130_fd_sc_hd__diode_2
Xhold519 _01444_ vssd1 vssd1 vccd1 vccd1 net1478 sky130_fd_sc_hd__dlygate4sd3_1
X_14267_ clknet_leaf_24_clk _01239_ net603 vssd1 vssd1 vccd1 vccd1 cell2.SB0.route_sel\[52\]
+ sky130_fd_sc_hd__dfstp_1
X_11479_ cell1.SB0.route_sel\[106\] _01544_ cell1.SB0.route_sel\[111\] cell1.SB0.route_sel\[110\]
+ _06319_ vssd1 vssd1 vccd1 vccd1 _06320_ sky130_fd_sc_hd__o221a_1
X_14198_ clknet_leaf_54_clk _01170_ net716 vssd1 vssd1 vccd1 vccd1 cell3.CB_0.config_dataA\[8\]
+ sky130_fd_sc_hd__dfstp_1
X_13218_ clknet_leaf_11_clk net1100 net589 vssd1 vssd1 vccd1 vccd1 cell0.LEI0.config_data\[3\]
+ sky130_fd_sc_hd__dfrtp_1
XFILLER_112_623 vssd1 vssd1 vccd1 vccd1 sky130_fd_sc_hd__fill_2
X_13149_ clknet_leaf_118_clk _00121_ net598 vssd1 vssd1 vccd1 vccd1 cell0.LE_1A.config_data\[0\]
+ sky130_fd_sc_hd__dfrtp_1
XTAP_TAPCELL_ROW_111_1973 vssd1 vccd1 sky130_fd_sc_hd__tapvpwrvgnd_1
XFILLER_111_122 vssd1 vssd1 vccd1 vccd1 sky130_fd_sc_hd__fill_1
X_07710_ _02744_ _02756_ vssd1 vssd1 vccd1 vccd1 _02757_ sky130_fd_sc_hd__nor2_1
XFILLER_111_199 vssd1 vssd1 vccd1 vccd1 sky130_fd_sc_hd__fill_1
X_08690_ net28 _03703_ _03705_ net27 cell1.CB_1.config_dataB\[3\] vssd1 vssd1 vccd1
+ vccd1 _03724_ sky130_fd_sc_hd__a221o_1
XFILLER_53_404 vssd1 vssd1 vccd1 vccd1 sky130_fd_sc_hd__fill_1
X_07641_ _02683_ _02689_ vssd1 vssd1 vccd1 vccd1 _02690_ sky130_fd_sc_hd__nor2_1
X_07572_ net342 _02621_ vssd1 vssd1 vccd1 vccd1 _02622_ sky130_fd_sc_hd__nand2_1
X_09311_ cell2.SB0.route_sel\[24\] cell2.SB0.route_sel\[25\] vssd1 vssd1 vccd1 vccd1
+ _04336_ sky130_fd_sc_hd__nand2_1
X_06523_ cell0.SB0.route_sel\[22\] vssd1 vssd1 vccd1 vccd1 _01593_ sky130_fd_sc_hd__inv_2
XANTENNA__12628__S net883 vssd1 vssd1 vccd1 vccd1 sky130_fd_sc_hd__diode_2
XANTENNA__08655__A2 net2 vssd1 vssd1 vccd1 vccd1 sky130_fd_sc_hd__diode_2
XFILLER_21_301 vssd1 vssd1 vccd1 vccd1 sky130_fd_sc_hd__fill_1
XFILLER_22_813 vssd1 vssd1 vccd1 vccd1 sky130_fd_sc_hd__fill_1
X_09242_ net278 _04266_ vssd1 vssd1 vccd1 vccd1 _04269_ sky130_fd_sc_hd__nor2_1
X_06454_ cell1.SB0.route_sel\[62\] vssd1 vssd1 vccd1 vccd1 _01524_ sky130_fd_sc_hd__inv_2
XANTENNA__09604__A1 net20 vssd1 vssd1 vccd1 vccd1 sky130_fd_sc_hd__diode_2
X_09173_ _04174_ _04198_ _04200_ vssd1 vssd1 vccd1 vccd1 _04201_ sky130_fd_sc_hd__a21bo_1
XANTENNA__07311__A bus3_1\[12\] vssd1 vssd1 vccd1 vccd1 sky130_fd_sc_hd__diode_2
XANTENNA__10214__A2 _05131_ vssd1 vssd1 vccd1 vccd1 sky130_fd_sc_hd__diode_2
X_08124_ cell0.LE_0B.config_data\[16\] _03163_ _03164_ net351 vssd1 vssd1 vccd1 vccd1
+ cell0.CB_0.le_outB sky130_fd_sc_hd__o211a_1
XFILLER_31_39 vccd1 vssd1 vccd1 vssd1 sky130_ef_sc_hd__decap_40_12
XFILLER_107_428 vssd1 vssd1 vccd1 vccd1 sky130_fd_sc_hd__fill_2
XANTENNA__08958__A3 bus3_1\[15\] vssd1 vssd1 vccd1 vccd1 sky130_fd_sc_hd__diode_2
X_08055_ _03090_ _03093_ _03095_ _03096_ vssd1 vssd1 vccd1 vccd1 _03097_ sky130_fd_sc_hd__o22a_1
XTAP_TAPCELL_ROW_73_1401 vssd1 vccd1 sky130_fd_sc_hd__tapvpwrvgnd_1
X_07006_ _02069_ _02071_ vssd1 vssd1 vccd1 vccd1 bus1_0\[8\] sky130_fd_sc_hd__nor2_2
XANTENNA__08040__A0 bus2_0\[0\] vssd1 vssd1 vccd1 vccd1 sky130_fd_sc_hd__diode_2
XANTENNA_fanout593_A net601 vssd1 vssd1 vccd1 vccd1 sky130_fd_sc_hd__diode_2
Xinput117 SBwest_in[28] vssd1 vssd1 vccd1 vccd1 net117 sky130_fd_sc_hd__buf_1
Xinput106 SBwest_in[18] vssd1 vssd1 vccd1 vccd1 net106 sky130_fd_sc_hd__clkbuf_1
XFILLER_102_166 vssd1 vssd1 vccd1 vccd1 sky130_fd_sc_hd__fill_2
X_08957_ _03849_ _03972_ _03973_ _03853_ cell1.CB_0.config_dataA\[17\] vssd1 vssd1
+ vccd1 vccd1 _03989_ sky130_fd_sc_hd__a221o_1
XANTENNA_fanout858_A net863 vssd1 vssd1 vccd1 vccd1 sky130_fd_sc_hd__diode_2
XANTENNA_fanout760_A net768 vssd1 vssd1 vccd1 vccd1 sky130_fd_sc_hd__diode_2
Xinput128 SBwest_in[9] vssd1 vssd1 vccd1 vccd1 net128 sky130_fd_sc_hd__clkbuf_1
X_07908_ net514 net515 vssd1 vssd1 vccd1 vccd1 _02952_ sky130_fd_sc_hd__and2b_1
X_08888_ _03871_ _03905_ _03906_ _03868_ cell1.CB_0.config_dataA\[2\] vssd1 vssd1
+ vccd1 vccd1 _03920_ sky130_fd_sc_hd__a221o_1
X_07839_ net519 _01913_ _02882_ cell0.CB_0.config_dataA\[6\] vssd1 vssd1 vccd1 vccd1
+ _02883_ sky130_fd_sc_hd__o211a_1
X_10850_ net19 net20 net365 vssd1 vssd1 vccd1 vccd1 _05806_ sky130_fd_sc_hd__mux2_1
XFILLER_112_53 vssd1 vssd1 vccd1 vccd1 sky130_fd_sc_hd__fill_4
X_10781_ _05735_ _05736_ cell3.CB_1.config_dataB\[8\] _05733_ vssd1 vssd1 vccd1 vccd1
+ _05737_ sky130_fd_sc_hd__o211a_1
XTAP_TAPCELL_ROW_84_1574 vssd1 vccd1 sky130_fd_sc_hd__tapvpwrvgnd_1
XTAP_TAPCELL_ROW_84_1563 vssd1 vccd1 sky130_fd_sc_hd__tapvpwrvgnd_1
X_09509_ cell3.SB0.route_sel\[70\] cell3.SB0.route_sel\[71\] _01721_ _01722_ _02092_
+ vssd1 vssd1 vccd1 vccd1 _04529_ sky130_fd_sc_hd__a2111o_1
XFILLER_25_673 vssd1 vssd1 vccd1 vccd1 sky130_fd_sc_hd__fill_1
X_12520_ net1538 cell2.LEI0.config_data\[33\] net838 vssd1 vssd1 vccd1 vccd1 _00949_
+ sky130_fd_sc_hd__mux2_1
XFILLER_40_643 vssd1 vssd1 vccd1 vccd1 sky130_fd_sc_hd__fill_1
X_12451_ net1309 net1288 net842 vssd1 vssd1 vccd1 vccd1 _00882_ sky130_fd_sc_hd__mux2_1
XPHY_EDGE_ROW_117_Right_117 vssd1 vssd1 vccd1 vccd1 sky130_fd_sc_hd__decap_3
XFILLER_9_839 vssd1 vssd1 vccd1 vccd1 sky130_fd_sc_hd__fill_1
XFILLER_9_828 vssd1 vssd1 vccd1 vccd1 sky130_fd_sc_hd__fill_1
XANTENNA__10205__A2 _05096_ vssd1 vssd1 vccd1 vccd1 sky130_fd_sc_hd__diode_2
X_11402_ _02132_ _06268_ vssd1 vssd1 vccd1 vccd1 net261 sky130_fd_sc_hd__and2b_1
X_14121_ clknet_leaf_64_clk net1261 net747 vssd1 vssd1 vccd1 vccd1 cell3.LE_1B.config_data\[1\]
+ sky130_fd_sc_hd__dfrtp_1
X_12382_ cell1.SB0.route_sel\[120\] cell1.SB0.route_sel\[119\] net872 vssd1 vssd1
+ vccd1 vccd1 _00815_ sky130_fd_sc_hd__mux2_1
XFILLER_125_225 vssd1 vssd1 vccd1 vccd1 sky130_fd_sc_hd__fill_1
XTAP_TAPCELL_ROW_115_2040 vssd1 vccd1 sky130_fd_sc_hd__tapvpwrvgnd_1
X_11333_ _01825_ _05916_ _04364_ vssd1 vssd1 vccd1 vccd1 _06232_ sky130_fd_sc_hd__mux2_1
XANTENNA__09419__Y _04442_ vssd1 vssd1 vccd1 vccd1 sky130_fd_sc_hd__diode_2
XFILLER_4_533 vccd1 vssd1 vccd1 vssd1 sky130_ef_sc_hd__decap_40_12
X_11264_ _06199_ net309 _01924_ vssd1 vssd1 vccd1 vccd1 net194 sky130_fd_sc_hd__mux2_2
XANTENNA__09359__B1 _02799_ vssd1 vssd1 vccd1 vccd1 sky130_fd_sc_hd__diode_2
X_14052_ clknet_leaf_46_clk _01024_ net701 vssd1 vssd1 vccd1 vccd1 cell3.SB0.route_sel\[60\]
+ sky130_fd_sc_hd__dfstp_1
X_13003_ net1462 net1463 net951 vssd1 vssd1 vccd1 vccd1 _01431_ sky130_fd_sc_hd__mux2_1
X_10215_ net415 _05128_ _05215_ vssd1 vssd1 vccd1 vccd1 _05216_ sky130_fd_sc_hd__a21o_1
XANTENNA__07909__A1 _02902_ vssd1 vssd1 vccd1 vccd1 sky130_fd_sc_hd__diode_2
XANTENNA__07909__B2 _02905_ vssd1 vssd1 vccd1 vccd1 sky130_fd_sc_hd__diode_2
X_11195_ _01802_ cell3.CB_0.config_dataB\[16\] vssd1 vssd1 vccd1 vccd1 _06147_ sky130_fd_sc_hd__nor2_1
X_10146_ cell2.SB0.route_sel\[19\] cell2.SB0.route_sel\[18\] _01588_ cell2.SB0.route_sel\[22\]
+ _05146_ vssd1 vssd1 vccd1 vccd1 _05147_ sky130_fd_sc_hd__o221a_1
XANTENNA_output143_A net143 vssd1 vssd1 vccd1 vccd1 sky130_fd_sc_hd__diode_2
X_10077_ cell2.LE_1B.config_data\[16\] _05078_ _05079_ net351 vssd1 vssd1 vccd1 vccd1
+ cell2.CB_1.le_outB sky130_fd_sc_hd__o211a_1
X_13905_ clknet_leaf_31_clk _00877_ net622 vssd1 vssd1 vccd1 vccd1 cell2.LE_0B.config_data\[6\]
+ sky130_fd_sc_hd__dfrtp_1
XTAP_TAPCELL_ROW_126_2191 vssd1 vccd1 sky130_fd_sc_hd__tapvpwrvgnd_1
XANTENNA_clkload2_A clknet_4_2_0_clk vssd1 vssd1 vccd1 vccd1 sky130_fd_sc_hd__diode_2
X_13836_ clknet_leaf_113_clk _00808_ net674 vssd1 vssd1 vccd1 vccd1 cell1.SB0.route_sel\[113\]
+ sky130_fd_sc_hd__dfstp_1
XANTENNA__10429__C1 net351 vssd1 vssd1 vccd1 vccd1 sky130_fd_sc_hd__diode_2
X_10979_ net377 net376 vssd1 vssd1 vccd1 vccd1 _05933_ sky130_fd_sc_hd__nor2_1
XANTENNA__09834__A1 bus3_2\[9\] vssd1 vssd1 vccd1 vccd1 sky130_fd_sc_hd__diode_2
XTAP_TAPCELL_ROW_46_999 vssd1 vccd1 sky130_fd_sc_hd__tapvpwrvgnd_1
X_13767_ clknet_leaf_109_clk _00739_ net657 vssd1 vssd1 vccd1 vccd1 cell1.SB0.route_sel\[44\]
+ sky130_fd_sc_hd__dfstp_1
X_12718_ net385 cell3.CB_0.config_dataB\[9\] net932 vssd1 vssd1 vccd1 vccd1 _01147_
+ sky130_fd_sc_hd__mux2_1
XANTENNA__10995__A3 net43 vssd1 vssd1 vccd1 vccd1 sky130_fd_sc_hd__diode_2
X_13698_ clknet_leaf_27_clk _00670_ net614 vssd1 vssd1 vccd1 vccd1 cell2.CB_0.config_dataA\[0\]
+ sky130_fd_sc_hd__dfstp_1
X_12649_ cell3.SB0.route_sel\[114\] cell3.SB0.route_sel\[113\] net922 vssd1 vssd1
+ vccd1 vccd1 _01078_ sky130_fd_sc_hd__mux2_1
Xhold316 _00604_ vssd1 vssd1 vccd1 vccd1 net1275 sky130_fd_sc_hd__dlygate4sd3_1
X_14319_ clknet_leaf_26_clk _01291_ net616 vssd1 vssd1 vccd1 vccd1 cell2.SB0.route_sel\[104\]
+ sky130_fd_sc_hd__dfstp_1
Xhold305 cell0.LE_0B.config_data\[6\] vssd1 vssd1 vccd1 vccd1 net1264 sky130_fd_sc_hd__dlygate4sd3_1
Xhold349 cell1.LE_0A.config_data\[8\] vssd1 vssd1 vccd1 vccd1 net1308 sky130_fd_sc_hd__dlygate4sd3_1
Xhold327 cell0.LEI0.config_data\[19\] vssd1 vssd1 vccd1 vccd1 net1286 sky130_fd_sc_hd__dlygate4sd3_1
Xhold338 cell0.LEI0.config_data\[7\] vssd1 vssd1 vccd1 vccd1 net1297 sky130_fd_sc_hd__dlygate4sd3_1
X_09860_ cell2.LEI0.config_data\[30\] net303 vssd1 vssd1 vccd1 vccd1 _04866_ sky130_fd_sc_hd__nand2_1
Xfanout807 net855 vssd1 vssd1 vccd1 vccd1 net807 sky130_fd_sc_hd__clkbuf_4
XTAP_TAPCELL_ROW_55_1131 vssd1 vccd1 sky130_fd_sc_hd__tapvpwrvgnd_1
XANTENNA__12911__S net756 vssd1 vssd1 vccd1 vccd1 sky130_fd_sc_hd__diode_2
XANTENNA__09345__X _04370_ vssd1 vssd1 vccd1 vccd1 sky130_fd_sc_hd__diode_2
Xfanout818 net821 vssd1 vssd1 vccd1 vccd1 net818 sky130_fd_sc_hd__clkbuf_4
XFILLER_86_816 vssd1 vssd1 vccd1 vccd1 sky130_fd_sc_hd__fill_1
Xfanout829 net831 vssd1 vssd1 vccd1 vccd1 net829 sky130_fd_sc_hd__clkbuf_4
X_09791_ net448 _04724_ net446 vssd1 vssd1 vccd1 vccd1 _04797_ sky130_fd_sc_hd__a21bo_1
X_08811_ cell1.SB0.route_sel\[90\] cell1.SB0.route_sel\[91\] cell1.SB0.route_sel\[93\]
+ _01537_ _03842_ vssd1 vssd1 vccd1 vccd1 _03843_ sky130_fd_sc_hd__o221a_1
X_08742_ net31 net32 net2 net3 net453 net451 vssd1 vssd1 vccd1 vccd1 _03776_ sky130_fd_sc_hd__mux4_1
X_08673_ net461 _03486_ net460 vssd1 vssd1 vccd1 vccd1 _03707_ sky130_fd_sc_hd__o21ai_1
X_07624_ _02671_ _02672_ _02669_ vssd1 vssd1 vccd1 vccd1 _02673_ sky130_fd_sc_hd__a21oi_2
XFILLER_54_757 vssd1 vssd1 vccd1 vccd1 sky130_fd_sc_hd__fill_1
XANTENNA__07567__B1_N net65 vssd1 vssd1 vccd1 vccd1 sky130_fd_sc_hd__diode_2
X_07555_ _02605_ _02603_ vssd1 vssd1 vccd1 vccd1 bus2_0\[15\] sky130_fd_sc_hd__and2b_2
X_07486_ cell2.SB0.route_sel\[119\] cell2.SB0.route_sel\[118\] vssd1 vssd1 vccd1 vccd1
+ _02539_ sky130_fd_sc_hd__nor2_1
XTAP_TAPCELL_ROW_66_1293 vssd1 vccd1 sky130_fd_sc_hd__tapvpwrvgnd_1
X_06506_ cell0.LE_0A.config_data\[16\] vssd1 vssd1 vccd1 vccd1 _01576_ sky130_fd_sc_hd__inv_2
XFILLER_42_16 vccd1 vssd1 vccd1 vssd1 sky130_ef_sc_hd__decap_40_12
X_09225_ cell2.CB_0.config_dataB\[22\] cell2.CB_0.config_dataB\[23\] _02178_ vssd1
+ vssd1 vccd1 vccd1 _04252_ sky130_fd_sc_hd__or3_1
X_06437_ cell1.SB0.route_sel\[20\] vssd1 vssd1 vccd1 vccd1 _01507_ sky130_fd_sc_hd__inv_2
XANTENNA_fanout606_A net623 vssd1 vssd1 vccd1 vccd1 sky130_fd_sc_hd__diode_2
XANTENNA__09589__B1 cell2.SB0.route_sel\[92\] vssd1 vssd1 vccd1 vccd1 sky130_fd_sc_hd__diode_2
XANTENNA__09053__A2 _01821_ vssd1 vssd1 vccd1 vccd1 sky130_fd_sc_hd__diode_2
X_09156_ net342 _02621_ _02627_ _04182_ _04183_ vssd1 vssd1 vccd1 vccd1 _04184_ sky130_fd_sc_hd__a221o_1
X_09087_ net332 net327 net337 net324 cell1.LEI0.config_data\[27\] cell1.LEI0.config_data\[28\]
+ vssd1 vssd1 vccd1 vccd1 _04117_ sky130_fd_sc_hd__mux4_1
X_08107_ net342 net345 net350 net338 cell0.LEI0.config_data\[39\] cell0.LEI0.config_data\[40\]
+ vssd1 vssd1 vccd1 vccd1 _03149_ sky130_fd_sc_hd__mux4_1
XANTENNA__07695__B _01933_ vssd1 vssd1 vccd1 vccd1 sky130_fd_sc_hd__diode_2
Xclkbuf_leaf_110_clk clknet_4_8_0_clk vssd1 vssd1 vccd1 vccd1 clknet_leaf_110_clk
+ sky130_fd_sc_hd__clkbuf_8
X_08038_ bus2_0\[4\] _03060_ _03061_ bus2_0\[5\] cell0.CB_0.config_dataB\[3\] vssd1
+ vssd1 vccd1 vccd1 _03080_ sky130_fd_sc_hd__a221o_1
XANTENNA__13486__Q cell0.SB0.config_data_out vssd1 vssd1 vccd1 vccd1 sky130_fd_sc_hd__diode_2
XANTENNA__08013__A0 net342 vssd1 vssd1 vccd1 vccd1 sky130_fd_sc_hd__diode_2
X_10000_ _05003_ vssd1 vssd1 vccd1 vccd1 _05004_ sky130_fd_sc_hd__inv_2
XFILLER_89_665 vssd1 vssd1 vccd1 vccd1 sky130_fd_sc_hd__fill_1
X_09989_ cell2.LE_1B.config_data\[6\] cell2.LE_1B.config_data\[7\] _04956_ vssd1 vssd1
+ vccd1 vccd1 _04993_ sky130_fd_sc_hd__mux2_1
XANTENNA__10371__A1 _05093_ vssd1 vssd1 vccd1 vccd1 sky130_fd_sc_hd__diode_2
XFILLER_103_453 vssd1 vssd1 vccd1 vccd1 sky130_fd_sc_hd__fill_1
XFILLER_67_24 vssd1 vssd1 vccd1 vccd1 sky130_fd_sc_hd__fill_1
XANTENNA__10910__A3 net57 vssd1 vssd1 vccd1 vccd1 sky130_fd_sc_hd__diode_2
XFILLER_88_197 vssd1 vssd1 vccd1 vccd1 sky130_fd_sc_hd__fill_2
XTAP_TAPCELL_ROW_86_1603 vssd1 vccd1 sky130_fd_sc_hd__tapvpwrvgnd_1
XTAP_TAPCELL_ROW_4_374 vssd1 vccd1 sky130_fd_sc_hd__tapvpwrvgnd_1
XTAP_TAPCELL_ROW_4_363 vssd1 vccd1 sky130_fd_sc_hd__tapvpwrvgnd_1
XANTENNA__10123__B2 net59 vssd1 vssd1 vccd1 vccd1 sky130_fd_sc_hd__diode_2
XANTENNA__10123__A1 net60 vssd1 vssd1 vccd1 vccd1 sky130_fd_sc_hd__diode_2
XFILLER_84_381 vssd1 vssd1 vccd1 vccd1 sky130_fd_sc_hd__fill_2
X_11951_ cell0.SB0.route_sel\[57\] cell0.SB0.route_sel\[56\] net761 vssd1 vssd1 vccd1
+ vccd1 _00388_ sky130_fd_sc_hd__mux2_1
X_10902_ _04662_ _05855_ vssd1 vssd1 vccd1 vccd1 _05856_ sky130_fd_sc_hd__nand2_4
X_11882_ cell1.CB_0.config_dataA\[13\] cell1.CB_0.config_dataA\[12\] net882 vssd1
+ vssd1 vccd1 vccd1 _00319_ sky130_fd_sc_hd__mux2_1
X_10833_ net297 net290 cell3.LEI0.config_data\[33\] vssd1 vssd1 vccd1 vccd1 _05789_
+ sky130_fd_sc_hd__mux2_1
X_13621_ clknet_leaf_86_clk net1272 net686 vssd1 vssd1 vccd1 vccd1 cell1.LEI0.config_data\[42\]
+ sky130_fd_sc_hd__dfrtp_1
X_10764_ cell3.CB_1.config_dataB\[4\] _05693_ _05707_ _05719_ _01776_ vssd1 vssd1
+ vccd1 vccd1 _05720_ sky130_fd_sc_hd__a32o_1
X_13552_ clknet_leaf_90_clk _00524_ net699 vssd1 vssd1 vccd1 vccd1 cell1.LE_0B.edge_mode
+ sky130_fd_sc_hd__dfstp_1
XANTENNA__07827__A0 bus2_0\[12\] vssd1 vssd1 vccd1 vccd1 sky130_fd_sc_hd__diode_2
XTAP_TAPCELL_ROW_43_958 vssd1 vccd1 sky130_fd_sc_hd__tapvpwrvgnd_1
XTAP_TAPCELL_ROW_43_947 vssd1 vccd1 sky130_fd_sc_hd__tapvpwrvgnd_1
XFILLER_16_94 vssd1 vssd1 vccd1 vccd1 sky130_fd_sc_hd__fill_1
X_12503_ cell2.LEI0.config_data\[17\] net1439 net843 vssd1 vssd1 vccd1 vccd1 _00932_
+ sky130_fd_sc_hd__mux2_1
X_10695_ _05549_ _05642_ _05644_ _05554_ cell3.CB_1.config_dataA\[17\] vssd1 vssd1
+ vccd1 vccd1 _05653_ sky130_fd_sc_hd__a221o_1
X_13483_ clknet_leaf_10_clk _00455_ net585 vssd1 vssd1 vccd1 vccd1 cell0.SB0.route_sel\[124\]
+ sky130_fd_sc_hd__dfstp_1
XTAP_TAPCELL_ROW_23_660 vssd1 vccd1 sky130_fd_sc_hd__tapvpwrvgnd_1
X_12434_ cell2.LE_1A.edge_mode cell2.LE_1A.config_data\[16\] net849 vssd1 vssd1 vccd1
+ vccd1 _00866_ sky130_fd_sc_hd__mux2_1
XFILLER_12_197 vssd1 vssd1 vccd1 vccd1 sky130_fd_sc_hd__fill_8
XTAP_TAPCELL_ROW_97_1765 vssd1 vccd1 sky130_fd_sc_hd__tapvpwrvgnd_1
X_12365_ cell1.SB0.route_sel\[103\] cell1.SB0.route_sel\[102\] net870 vssd1 vssd1
+ vccd1 vccd1 _00798_ sky130_fd_sc_hd__mux2_1
Xclkbuf_leaf_101_clk clknet_4_10_0_clk vssd1 vssd1 vccd1 vccd1 clknet_leaf_101_clk
+ sky130_fd_sc_hd__clkbuf_8
X_14104_ clknet_leaf_51_clk _01076_ net713 vssd1 vssd1 vccd1 vccd1 cell3.SB0.route_sel\[112\]
+ sky130_fd_sc_hd__dfstp_1
X_11316_ net293 _06223_ _04591_ vssd1 vssd1 vccd1 vccd1 net152 sky130_fd_sc_hd__mux2_1
XANTENNA__11139__A0 _05893_ vssd1 vssd1 vccd1 vccd1 sky130_fd_sc_hd__diode_2
X_14035_ clknet_leaf_49_clk _01007_ net705 vssd1 vssd1 vccd1 vccd1 cell3.SB0.route_sel\[43\]
+ sky130_fd_sc_hd__dfstp_1
XANTENNA_output260_A net260 vssd1 vssd1 vccd1 vccd1 sky130_fd_sc_hd__diode_2
XFILLER_4_374 vccd1 vssd1 vccd1 vssd1 sky130_ef_sc_hd__decap_40_12
X_12296_ cell1.SB0.route_sel\[34\] cell1.SB0.route_sel\[33\] net861 vssd1 vssd1 vccd1
+ vccd1 _00729_ sky130_fd_sc_hd__mux2_1
XANTENNA__12731__S net933 vssd1 vssd1 vccd1 vccd1 sky130_fd_sc_hd__diode_2
XFILLER_79_142 vssd1 vssd1 vccd1 vccd1 sky130_fd_sc_hd__fill_1
X_11247_ clknet_leaf_90_clk cell1.LE_0B.edge_mode vssd1 vssd1 vccd1 vccd1 cell1.LE_0B.sel_clk
+ sky130_fd_sc_hd__xnor2_2
XANTENNA__08555__A1 net30 vssd1 vssd1 vccd1 vccd1 sky130_fd_sc_hd__diode_2
XPHY_EDGE_ROW_26_Left_169 vssd1 vssd1 vccd1 vccd1 sky130_fd_sc_hd__decap_3
X_11178_ _06129_ vssd1 vssd1 vccd1 vccd1 _06130_ sky130_fd_sc_hd__inv_2
XTAP_TAPCELL_ROW_128_2231 vssd1 vccd1 sky130_fd_sc_hd__tapvpwrvgnd_1
X_10129_ cell2.SB0.route_sel\[54\] _01613_ _01615_ cell2.SB0.route_sel\[53\] vssd1
+ vssd1 vccd1 vccd1 _05130_ sky130_fd_sc_hd__o22a_1
XFILLER_67_337 vssd1 vssd1 vccd1 vccd1 sky130_fd_sc_hd__fill_2
XFILLER_0_580 vssd1 vssd1 vccd1 vccd1 sky130_fd_sc_hd__fill_8
XTAP_TAPCELL_ROW_50_1061 vssd1 vccd1 sky130_fd_sc_hd__tapvpwrvgnd_1
XTAP_TAPCELL_ROW_141_2420 vssd1 vccd1 sky130_fd_sc_hd__tapvpwrvgnd_1
XANTENNA__10665__A2 net10 vssd1 vssd1 vccd1 vccd1 sky130_fd_sc_hd__diode_2
XFILLER_91_841 vssd1 vssd1 vccd1 vccd1 sky130_fd_sc_hd__fill_1
XFILLER_63_554 vssd1 vssd1 vccd1 vccd1 sky130_fd_sc_hd__fill_1
XANTENNA__06965__A cell0.CB_0.config_dataB\[24\] vssd1 vssd1 vccd1 vccd1 sky130_fd_sc_hd__diode_2
XFILLER_36_757 vssd1 vssd1 vccd1 vccd1 sky130_fd_sc_hd__fill_1
X_13819_ clknet_leaf_113_clk _00791_ net663 vssd1 vssd1 vccd1 vccd1 cell1.SB0.route_sel\[96\]
+ sky130_fd_sc_hd__dfstp_2
X_07340_ cell2.CB_0.config_dataA\[22\] cell2.CB_0.config_dataA\[23\] vssd1 vssd1 vccd1
+ vccd1 _02397_ sky130_fd_sc_hd__nand2_1
XTAP_TAPCELL_ROW_106_1894 vssd1 vccd1 sky130_fd_sc_hd__tapvpwrvgnd_1
XFILLER_90_395 vssd1 vssd1 vccd1 vccd1 sky130_fd_sc_hd__fill_1
XPHY_EDGE_ROW_35_Left_178 vssd1 vssd1 vccd1 vccd1 sky130_fd_sc_hd__decap_3
XTAP_TAPCELL_ROW_21_619 vssd1 vccd1 sky130_fd_sc_hd__tapvpwrvgnd_1
X_09010_ bus3_1\[12\] bus3_1\[13\] bus3_1\[14\] bus3_1\[15\] net482 net481 vssd1 vssd1
+ vccd1 vccd1 _04040_ sky130_fd_sc_hd__mux4_1
XANTENNA__07833__A3 bus2_0\[11\] vssd1 vssd1 vccd1 vccd1 sky130_fd_sc_hd__diode_2
XANTENNA__11810__S net902 vssd1 vssd1 vccd1 vccd1 sky130_fd_sc_hd__diode_2
X_07271_ net358 _02326_ bus1_0\[12\] vssd1 vssd1 vccd1 vccd1 _02329_ sky130_fd_sc_hd__o21a_1
XTAP_TAPCELL_ROW_139_2393 vssd1 vccd1 sky130_fd_sc_hd__tapvpwrvgnd_1
Xhold102 cell3.LE_0B.config_data\[8\] vssd1 vssd1 vccd1 vccd1 net1061 sky130_fd_sc_hd__dlygate4sd3_1
Xhold113 cell0.LE_1A.config_data\[14\] vssd1 vssd1 vccd1 vccd1 net1072 sky130_fd_sc_hd__dlygate4sd3_1
Xhold124 cell0.LE_1A.config_data\[7\] vssd1 vssd1 vccd1 vccd1 net1083 sky130_fd_sc_hd__dlygate4sd3_1
Xhold135 _00487_ vssd1 vssd1 vccd1 vccd1 net1094 sky130_fd_sc_hd__dlygate4sd3_1
Xhold146 cell2.LE_0B.config_data\[1\] vssd1 vssd1 vccd1 vccd1 net1105 sky130_fd_sc_hd__dlygate4sd3_1
Xhold168 cell2.LE_0A.config_data\[16\] vssd1 vssd1 vccd1 vccd1 net1127 sky130_fd_sc_hd__dlygate4sd3_1
XPHY_EDGE_ROW_44_Left_187 vssd1 vssd1 vccd1 vccd1 sky130_fd_sc_hd__decap_3
Xhold157 _00493_ vssd1 vssd1 vccd1 vccd1 net1116 sky130_fd_sc_hd__dlygate4sd3_1
Xhold179 cell2.LE_0B.config_data\[15\] vssd1 vssd1 vccd1 vccd1 net1138 sky130_fd_sc_hd__dlygate4sd3_1
X_09912_ _04916_ _04917_ _04791_ vssd1 vssd1 vccd1 vccd1 _04918_ sky130_fd_sc_hd__mux2_1
Xfanout615 net616 vssd1 vssd1 vccd1 vccd1 net615 sky130_fd_sc_hd__clkbuf_2
Xfanout604 net605 vssd1 vssd1 vccd1 vccd1 net604 sky130_fd_sc_hd__clkbuf_4
Xfanout637 net640 vssd1 vssd1 vccd1 vccd1 net637 sky130_fd_sc_hd__buf_2
Xfanout648 net649 vssd1 vssd1 vccd1 vccd1 net648 sky130_fd_sc_hd__clkbuf_2
X_09843_ net441 _04298_ _04848_ net440 vssd1 vssd1 vccd1 vccd1 _04849_ sky130_fd_sc_hd__o211a_1
Xfanout626 net632 vssd1 vssd1 vccd1 vccd1 net626 sky130_fd_sc_hd__buf_2
XANTENNA__09516__A net17 vssd1 vssd1 vccd1 vccd1 sky130_fd_sc_hd__diode_2
XANTENNA_fanout291_A cell3.CB_1.le_outB vssd1 vssd1 vccd1 vccd1 sky130_fd_sc_hd__diode_2
XFILLER_85_134 vssd1 vssd1 vccd1 vccd1 sky130_fd_sc_hd__fill_1
Xfanout659 net664 vssd1 vssd1 vccd1 vccd1 net659 sky130_fd_sc_hd__clkbuf_2
X_09774_ net444 _04472_ net443 vssd1 vssd1 vccd1 vccd1 _04780_ sky130_fd_sc_hd__o21ai_1
XFILLER_85_167 vssd1 vssd1 vccd1 vccd1 sky130_fd_sc_hd__fill_1
X_06986_ _02050_ _02051_ vssd1 vssd1 vccd1 vccd1 _02052_ sky130_fd_sc_hd__nor2_1
XFILLER_37_27 vccd1 vssd1 vccd1 vssd1 sky130_ef_sc_hd__decap_40_12
XTAP_TAPCELL_ROW_68_1322 vssd1 vccd1 sky130_fd_sc_hd__tapvpwrvgnd_1
XTAP_TAPCELL_ROW_1_322 vssd1 vccd1 sky130_fd_sc_hd__tapvpwrvgnd_1
X_08725_ net455 _03489_ _03758_ vssd1 vssd1 vccd1 vccd1 _03759_ sky130_fd_sc_hd__a21o_1
XTAP_TAPCELL_ROW_68_1333 vssd1 vccd1 sky130_fd_sc_hd__tapvpwrvgnd_1
XPHY_EDGE_ROW_53_Left_196 vssd1 vssd1 vccd1 vccd1 sky130_fd_sc_hd__decap_3
X_08656_ _03688_ _03689_ _01656_ vssd1 vssd1 vccd1 vccd1 _03690_ sky130_fd_sc_hd__mux2_1
XFILLER_27_779 vssd1 vssd1 vccd1 vccd1 sky130_fd_sc_hd__fill_1
XANTENNA_clkbuf_leaf_54_clk_A clknet_4_13_0_clk vssd1 vssd1 vccd1 vccd1 sky130_fd_sc_hd__diode_2
XANTENNA__09251__A cell3.SB0.route_sel\[21\] vssd1 vssd1 vccd1 vccd1 sky130_fd_sc_hd__diode_2
XFILLER_54_587 vssd1 vssd1 vccd1 vccd1 sky130_fd_sc_hd__fill_1
XFILLER_54_576 vssd1 vssd1 vccd1 vccd1 sky130_fd_sc_hd__fill_1
X_08587_ net488 net487 vssd1 vssd1 vccd1 vccd1 _03623_ sky130_fd_sc_hd__nor2_1
X_07607_ cell1.SB0.route_sel\[2\] _01496_ cell1.SB0.route_sel\[5\] _01497_ _02656_
+ vssd1 vssd1 vccd1 vccd1 _02657_ sky130_fd_sc_hd__a221o_1
XANTENNA_fanout723_A net724 vssd1 vssd1 vccd1 vccd1 sky130_fd_sc_hd__diode_2
X_07538_ _02582_ _02588_ cell2.SB0.route_sel\[123\] cell2.SB0.route_sel\[122\] vssd1
+ vssd1 vccd1 vccd1 _02589_ sky130_fd_sc_hd__o211a_1
XTAP_TAPCELL_ROW_81_1522 vssd1 vccd1 sky130_fd_sc_hd__tapvpwrvgnd_1
XFILLER_81_384 vssd1 vssd1 vccd1 vccd1 sky130_fd_sc_hd__fill_2
XANTENNA_fanout344_X net344 vssd1 vssd1 vccd1 vccd1 sky130_fd_sc_hd__diode_2
XFILLER_50_760 vssd1 vssd1 vccd1 vccd1 sky130_fd_sc_hd__fill_1
XTAP_TAPCELL_ROW_40_906 vssd1 vccd1 sky130_fd_sc_hd__tapvpwrvgnd_1
XANTENNA_clkbuf_leaf_69_clk_A clknet_4_14_0_clk vssd1 vssd1 vccd1 vccd1 sky130_fd_sc_hd__diode_2
X_07469_ _02521_ net317 _02518_ vssd1 vssd1 vccd1 vccd1 _02522_ sky130_fd_sc_hd__mux2_1
XFILLER_10_624 vccd1 vssd1 vccd1 vssd1 sky130_ef_sc_hd__decap_40_12
X_09208_ _04232_ net295 _04231_ vssd1 vssd1 vccd1 vccd1 _04235_ sky130_fd_sc_hd__mux2_1
X_10480_ net598 cell0.LE_0B.reset_mode vssd1 vssd1 vccd1 vccd1 _10480_/X sky130_fd_sc_hd__xor2_2
XFILLER_10_657 vccd1 vssd1 vccd1 vssd1 sky130_ef_sc_hd__decap_40_12
XANTENNA__08154__X _03194_ vssd1 vssd1 vccd1 vccd1 sky130_fd_sc_hd__diode_2
X_09139_ _04168_ _04167_ _04051_ vssd1 vssd1 vccd1 vccd1 _04169_ sky130_fd_sc_hd__mux2_1
XFILLER_5_105 vssd1 vssd1 vccd1 vccd1 sky130_fd_sc_hd__fill_4
XANTENNA_clkbuf_leaf_112_clk_A clknet_4_8_0_clk vssd1 vssd1 vccd1 vccd1 sky130_fd_sc_hd__diode_2
XFILLER_118_41 vccd1 vssd1 vccd1 vssd1 sky130_ef_sc_hd__decap_40_12
XTAP_TAPCELL_ROW_79_1495 vssd1 vccd1 sky130_fd_sc_hd__tapvpwrvgnd_1
X_12150_ net1074 cell1.LEI0.config_data\[31\] net900 vssd1 vssd1 vccd1 vccd1 _00583_
+ sky130_fd_sc_hd__mux2_1
XFILLER_135_386 vssd1 vssd1 vccd1 vccd1 sky130_fd_sc_hd__fill_4
X_11101_ _01795_ _06050_ _06052_ vssd1 vssd1 vccd1 vccd1 _06053_ sky130_fd_sc_hd__a21oi_1
X_12081_ net1020 cell1.LE_0B.config_data\[8\] net938 vssd1 vssd1 vccd1 vccd1 _00516_
+ sky130_fd_sc_hd__mux2_1
XTAP_TAPCELL_ROW_9_444 vssd1 vccd1 sky130_fd_sc_hd__tapvpwrvgnd_1
XANTENNA_clkbuf_leaf_127_clk_A clknet_4_2_0_clk vssd1 vssd1 vccd1 vccd1 sky130_fd_sc_hd__diode_2
XFILLER_1_333 vssd1 vssd1 vccd1 vccd1 sky130_fd_sc_hd__fill_2
X_11032_ _05912_ _05916_ cell3.CB_0.config_dataA\[10\] vssd1 vssd1 vccd1 vccd1 _05986_
+ sky130_fd_sc_hd__mux2_1
XTAP_TAPCELL_ROW_92_1695 vssd1 vccd1 sky130_fd_sc_hd__tapvpwrvgnd_1
XTAP_TAPCELL_ROW_92_1684 vssd1 vccd1 sky130_fd_sc_hd__tapvpwrvgnd_1
XANTENNA__08537__B2 _03473_ vssd1 vssd1 vccd1 vccd1 sky130_fd_sc_hd__diode_2
XANTENNA__08537__A1 _03477_ vssd1 vssd1 vccd1 vccd1 sky130_fd_sc_hd__diode_2
XFILLER_77_635 vssd1 vssd1 vccd1 vccd1 sky130_fd_sc_hd__fill_1
XFILLER_49_337 vssd1 vssd1 vccd1 vccd1 sky130_fd_sc_hd__fill_4
XANTENNA__07217__Y _02277_ vssd1 vssd1 vccd1 vccd1 sky130_fd_sc_hd__diode_2
X_12983_ net1458 cell3.LEI0.config_data\[3\] net945 vssd1 vssd1 vccd1 vccd1 _01411_
+ sky130_fd_sc_hd__mux2_1
XFILLER_94_77 vssd1 vssd1 vccd1 vccd1 sky130_fd_sc_hd__fill_4
XFILLER_92_638 vssd1 vssd1 vccd1 vccd1 sky130_fd_sc_hd__fill_4
XTAP_TAPCELL_ROW_123_2150 vssd1 vccd1 sky130_fd_sc_hd__tapvpwrvgnd_1
XFILLER_17_223 vssd1 vssd1 vccd1 vccd1 sky130_fd_sc_hd__fill_1
XTAP_TAPCELL_ROW_28_730 vssd1 vccd1 sky130_fd_sc_hd__tapvpwrvgnd_1
X_11934_ cell0.SB0.route_sel\[40\] cell0.SB0.route_sel\[39\] net757 vssd1 vssd1 vccd1
+ vccd1 _00371_ sky130_fd_sc_hd__mux2_1
X_13604_ clknet_leaf_86_clk _00576_ net686 vssd1 vssd1 vccd1 vccd1 cell1.LEI0.config_data\[25\]
+ sky130_fd_sc_hd__dfrtp_1
X_11865_ cell1.CB_0.config_dataB\[21\] cell1.CB_0.config_dataB\[20\] net881 vssd1
+ vssd1 vccd1 vccd1 _00302_ sky130_fd_sc_hd__mux2_1
X_10816_ _05766_ _05769_ _05771_ cell3.CB_1.config_dataB\[12\] vssd1 vssd1 vccd1 vccd1
+ _05772_ sky130_fd_sc_hd__o22a_1
X_11796_ net1385 cell0.LEI0.config_data\[45\] net792 vssd1 vssd1 vccd1 vccd1 _00233_
+ sky130_fd_sc_hd__mux2_1
X_10747_ _05690_ _05694_ _05698_ _05702_ vssd1 vssd1 vccd1 vccd1 _05703_ sky130_fd_sc_hd__o211a_1
X_13535_ clknet_leaf_90_clk _00507_ net699 vssd1 vssd1 vccd1 vccd1 cell1.LE_0B.config_data\[0\]
+ sky130_fd_sc_hd__dfrtp_1
X_10678_ _01791_ _05619_ cell3.CB_1.config_dataA\[11\] cell3.CB_1.config_dataA\[14\]
+ vssd1 vssd1 vccd1 vccd1 _05636_ sky130_fd_sc_hd__or4b_1
X_13466_ clknet_leaf_3_clk _00438_ net565 vssd1 vssd1 vccd1 vccd1 cell0.SB0.route_sel\[107\]
+ sky130_fd_sc_hd__dfstp_1
X_12417_ net1197 cell2.LE_0B.reset_mode net852 vssd1 vssd1 vccd1 vccd1 _00849_ sky130_fd_sc_hd__mux2_1
XANTENNA__09973__A0 bus3_2\[12\] vssd1 vssd1 vccd1 vccd1 sky130_fd_sc_hd__diode_2
XANTENNA__10032__A0 bus3_2\[8\] vssd1 vssd1 vccd1 vccd1 sky130_fd_sc_hd__diode_2
Xoutput207 net207 vssd1 vssd1 vccd1 vccd1 SBsouth_out[18] sky130_fd_sc_hd__buf_2
X_13397_ clknet_leaf_0_clk _00369_ net554 vssd1 vssd1 vccd1 vccd1 cell0.SB0.route_sel\[38\]
+ sky130_fd_sc_hd__dfstp_1
XFILLER_142_813 vssd1 vssd1 vccd1 vccd1 sky130_fd_sc_hd__fill_1
Xoutput229 net229 vssd1 vssd1 vccd1 vccd1 SBsouth_out[9] sky130_fd_sc_hd__buf_2
Xoutput218 net218 vssd1 vssd1 vccd1 vccd1 SBsouth_out[28] sky130_fd_sc_hd__buf_2
X_12348_ cell1.SB0.route_sel\[86\] cell1.SB0.route_sel\[85\] net868 vssd1 vssd1 vccd1
+ vccd1 _00781_ sky130_fd_sc_hd__mux2_1
XFILLER_4_193 vssd1 vssd1 vccd1 vccd1 sky130_fd_sc_hd__fill_2
X_12279_ cell1.SB0.route_sel\[17\] cell1.SB0.route_sel\[16\] net865 vssd1 vssd1 vccd1
+ vccd1 _00712_ sky130_fd_sc_hd__mux2_1
X_14018_ clknet_leaf_81_clk _00990_ net707 vssd1 vssd1 vccd1 vccd1 cell3.SB0.route_sel\[26\]
+ sky130_fd_sc_hd__dfstp_1
XFILLER_4_53 vccd1 vssd1 vccd1 vssd1 sky130_ef_sc_hd__decap_40_12
XANTENNA__11077__S _05930_ vssd1 vssd1 vccd1 vccd1 sky130_fd_sc_hd__diode_2
XANTENNA__10335__A1 _05093_ vssd1 vssd1 vccd1 vccd1 sky130_fd_sc_hd__diode_2
X_06840_ net314 _01902_ _01907_ _01908_ vssd1 vssd1 vccd1 vccd1 _01909_ sky130_fd_sc_hd__o2bb2a_1
XFILLER_4_97 vccd1 vssd1 vccd1 vssd1 sky130_ef_sc_hd__decap_40_12
XFILLER_67_167 vssd1 vssd1 vccd1 vccd1 sky130_fd_sc_hd__fill_1
XFILLER_56_819 vssd1 vssd1 vccd1 vccd1 sky130_fd_sc_hd__fill_1
XTAP_TAPCELL_ROW_108_1923 vssd1 vccd1 sky130_fd_sc_hd__tapvpwrvgnd_1
XANTENNA__06966__Y _02032_ vssd1 vssd1 vccd1 vccd1 sky130_fd_sc_hd__diode_2
X_06771_ cell1.CB_1.config_dataA\[24\] cell1.CB_1.config_dataA\[20\] cell1.CB_1.config_dataA\[21\]
+ vssd1 vssd1 vccd1 vccd1 _01841_ sky130_fd_sc_hd__or3b_4
XANTENNA__10099__B1 _05093_ vssd1 vssd1 vccd1 vccd1 sky130_fd_sc_hd__diode_2
XTAP_TAPCELL_ROW_108_1934 vssd1 vccd1 sky130_fd_sc_hd__tapvpwrvgnd_1
X_09490_ net287 net16 _04509_ vssd1 vssd1 vccd1 vccd1 _04511_ sky130_fd_sc_hd__mux2_1
X_08510_ _03501_ _03543_ _03545_ vssd1 vssd1 vccd1 vccd1 _03546_ sky130_fd_sc_hd__a21oi_4
X_08441_ _02069_ _03476_ vssd1 vssd1 vccd1 vccd1 _03477_ sky130_fd_sc_hd__or2_4
XTAP_TAPCELL_ROW_63_1252 vssd1 vccd1 sky130_fd_sc_hd__tapvpwrvgnd_1
XFILLER_51_557 vssd1 vssd1 vccd1 vccd1 sky130_fd_sc_hd__fill_1
X_08372_ _02678_ _03384_ _03386_ _02633_ cell0.CB_1.config_dataB\[12\] vssd1 vssd1
+ vccd1 vccd1 _03410_ sky130_fd_sc_hd__a221o_1
X_07323_ _02081_ _02379_ vssd1 vssd1 vccd1 vccd1 _02380_ sky130_fd_sc_hd__nand2_1
X_07254_ net317 _02311_ _02312_ _02310_ _02307_ vssd1 vssd1 vccd1 vccd1 _02313_ sky130_fd_sc_hd__o221a_1
XFILLER_118_843 vssd1 vssd1 vccd1 vccd1 sky130_fd_sc_hd__fill_1
XANTENNA__08216__A0 bus1_0\[2\] vssd1 vssd1 vccd1 vccd1 sky130_fd_sc_hd__diode_2
XFILLER_117_331 vssd1 vssd1 vccd1 vccd1 sky130_fd_sc_hd__fill_1
X_07185_ cell2.SB0.route_sel\[83\] cell2.SB0.route_sel\[82\] _02241_ _02244_ _02245_
+ vssd1 vssd1 vccd1 vccd1 _02246_ sky130_fd_sc_hd__a221o_1
XFILLER_3_609 vssd1 vssd1 vccd1 vccd1 sky130_fd_sc_hd__fill_4
Xfanout423 cell2.CB_0.config_dataB\[16\] vssd1 vssd1 vccd1 vccd1 net423 sky130_fd_sc_hd__buf_2
Xfanout412 net413 vssd1 vssd1 vccd1 vccd1 net412 sky130_fd_sc_hd__clkbuf_2
Xfanout401 cell2.CB_1.config_dataB\[15\] vssd1 vssd1 vccd1 vccd1 net401 sky130_fd_sc_hd__clkbuf_2
XANTENNA__08519__A1 net30 vssd1 vssd1 vccd1 vccd1 sky130_fd_sc_hd__diode_2
XTAP_TAPCELL_ROW_6_403 vssd1 vccd1 sky130_fd_sc_hd__tapvpwrvgnd_1
XANTENNA__07318__X bus1_0\[12\] vssd1 vssd1 vccd1 vccd1 sky130_fd_sc_hd__diode_2
Xfanout434 cell2.CB_0.config_dataB\[1\] vssd1 vssd1 vccd1 vccd1 net434 sky130_fd_sc_hd__buf_1
Xfanout445 cell2.CB_1.config_dataA\[5\] vssd1 vssd1 vccd1 vccd1 net445 sky130_fd_sc_hd__dlymetal6s2s_1
XANTENNA_fanout673_A net674 vssd1 vssd1 vccd1 vccd1 sky130_fd_sc_hd__diode_2
Xfanout456 cell1.CB_1.config_dataB\[10\] vssd1 vssd1 vccd1 vccd1 net456 sky130_fd_sc_hd__clkbuf_2
X_09826_ cell2.LE_1A.config_data\[5\] cell2.LE_1A.config_data\[4\] _04831_ vssd1 vssd1
+ vccd1 vccd1 _04832_ sky130_fd_sc_hd__mux2_1
Xfanout478 cell1.CB_0.config_dataB\[11\] vssd1 vssd1 vccd1 vccd1 net478 sky130_fd_sc_hd__buf_2
Xfanout467 cell1.CB_0.config_dataA\[10\] vssd1 vssd1 vccd1 vccd1 net467 sky130_fd_sc_hd__clkbuf_2
Xfanout489 cell1.CB_1.config_dataA\[15\] vssd1 vssd1 vccd1 vccd1 net489 sky130_fd_sc_hd__clkbuf_2
XANTENNA_fanout840_A net845 vssd1 vssd1 vccd1 vccd1 sky130_fd_sc_hd__diode_2
X_09757_ bus3_2\[8\] bus3_2\[9\] bus3_2\[10\] bus3_2\[11\] net444 net443 vssd1 vssd1
+ vccd1 vccd1 _04763_ sky130_fd_sc_hd__mux4_1
XPHY_EDGE_ROW_61_Left_204 vssd1 vssd1 vccd1 vccd1 sky130_fd_sc_hd__decap_3
X_06969_ _01835_ _02033_ _02034_ _02028_ vssd1 vssd1 vccd1 vccd1 _02035_ sky130_fd_sc_hd__o211a_1
XANTENNA_fanout938_A net940 vssd1 vssd1 vccd1 vccd1 sky130_fd_sc_hd__diode_2
XFILLER_27_554 vssd1 vssd1 vccd1 vccd1 sky130_fd_sc_hd__fill_4
X_08708_ net29 net30 net455 vssd1 vssd1 vccd1 vccd1 _03742_ sky130_fd_sc_hd__mux2_1
X_09688_ _04304_ _04649_ vssd1 vssd1 vccd1 vccd1 _04702_ sky130_fd_sc_hd__nor2_1
X_08639_ net1 net12 net23 net26 net459 cell1.CB_1.config_dataB\[6\] vssd1 vssd1 vccd1
+ vccd1 _03673_ sky130_fd_sc_hd__mux4_1
XFILLER_120_53 vssd1 vssd1 vccd1 vccd1 sky130_fd_sc_hd__fill_8
X_11650_ cell0.CB_0.config_dataA\[21\] cell0.CB_0.config_dataA\[20\] net779 vssd1
+ vssd1 vccd1 vccd1 _00091_ sky130_fd_sc_hd__mux2_1
XANTENNA__07258__A1 net308 vssd1 vssd1 vccd1 vccd1 sky130_fd_sc_hd__diode_2
X_10601_ _05558_ vssd1 vssd1 vccd1 vccd1 _05559_ sky130_fd_sc_hd__inv_2
XANTENNA__09798__A3 bus3_2\[11\] vssd1 vssd1 vccd1 vccd1 sky130_fd_sc_hd__diode_2
X_11581_ cell0.CB_1.config_dataA\[2\] net544 net788 vssd1 vssd1 vccd1 vccd1 _00022_
+ sky130_fd_sc_hd__mux2_1
X_10532_ net395 cell3.CB_1.config_dataA\[6\] vssd1 vssd1 vccd1 vccd1 _05490_ sky130_fd_sc_hd__nor2_1
X_13320_ clknet_leaf_87_clk _00292_ net689 vssd1 vssd1 vccd1 vccd1 cell1.CB_0.config_dataB\[11\]
+ sky130_fd_sc_hd__dfstp_1
XFILLER_10_421 vssd1 vssd1 vccd1 vccd1 sky130_fd_sc_hd__fill_4
XFILLER_13_51 vssd1 vssd1 vccd1 vccd1 sky130_fd_sc_hd__fill_4
XFILLER_22_292 vssd1 vssd1 vccd1 vccd1 sky130_fd_sc_hd__fill_1
XFILLER_129_51 vssd1 vssd1 vccd1 vccd1 sky130_fd_sc_hd__fill_4
XPHY_EDGE_ROW_70_Left_213 vssd1 vssd1 vccd1 vccd1 sky130_fd_sc_hd__decap_3
XANTENNA__10066__S _05030_ vssd1 vssd1 vccd1 vccd1 sky130_fd_sc_hd__diode_2
XANTENNA__09955__A0 bus3_2\[0\] vssd1 vssd1 vccd1 vccd1 sky130_fd_sc_hd__diode_2
XTAP_TAPCELL_ROW_94_1724 vssd1 vccd1 sky130_fd_sc_hd__tapvpwrvgnd_1
XTAP_TAPCELL_ROW_94_1713 vssd1 vccd1 sky130_fd_sc_hd__tapvpwrvgnd_1
X_10463_ cell3.SB0.route_sel\[96\] cell3.SB0.route_sel\[97\] vssd1 vssd1 vccd1 vccd1
+ _05449_ sky130_fd_sc_hd__nor2_1
XFILLER_89_11 vccd1 vssd1 vccd1 vssd1 sky130_ef_sc_hd__decap_40_12
X_13251_ clknet_leaf_119_clk _00223_ net587 vssd1 vssd1 vccd1 vccd1 cell0.LEI0.config_data\[36\]
+ sky130_fd_sc_hd__dfrtp_1
XFILLER_10_498 vssd1 vssd1 vccd1 vccd1 sky130_fd_sc_hd__fill_1
X_10394_ net36 net37 net38 net39 net425 net423 vssd1 vssd1 vccd1 vccd1 _05393_ sky130_fd_sc_hd__mux4_1
X_12202_ net438 cell2.CB_1.config_dataA\[14\] net913 vssd1 vssd1 vccd1 vccd1 _00635_
+ sky130_fd_sc_hd__mux2_1
X_13182_ clknet_leaf_14_clk net1186 net597 vssd1 vssd1 vccd1 vccd1 cell0.LE_0B.config_data\[11\]
+ sky130_fd_sc_hd__dfrtp_1
XANTENNA_input67_A SBsouth_in[11] vssd1 vssd1 vccd1 vccd1 sky130_fd_sc_hd__diode_2
X_12133_ net1183 net1035 net896 vssd1 vssd1 vccd1 vccd1 _00566_ sky130_fd_sc_hd__mux2_1
X_12064_ net1000 net1007 net890 vssd1 vssd1 vccd1 vccd1 _00500_ sky130_fd_sc_hd__mux2_1
X_11015_ net53 net54 net56 net57 net375 net374 vssd1 vssd1 vccd1 vccd1 _05969_ sky130_fd_sc_hd__mux4_1
XFILLER_2_697 vssd1 vssd1 vccd1 vccd1 sky130_fd_sc_hd__fill_2
XANTENNA_input22_X net22 vssd1 vssd1 vccd1 vccd1 sky130_fd_sc_hd__diode_2
XANTENNA__09443__X bus3_1\[5\] vssd1 vssd1 vccd1 vccd1 sky130_fd_sc_hd__diode_2
XFILLER_92_424 vssd1 vssd1 vccd1 vccd1 sky130_fd_sc_hd__fill_4
XFILLER_64_159 vssd1 vssd1 vccd1 vccd1 sky130_fd_sc_hd__fill_1
X_12966_ net1244 net1212 net853 vssd1 vssd1 vccd1 vccd1 _01394_ sky130_fd_sc_hd__mux2_1
XFILLER_18_587 vssd1 vssd1 vccd1 vccd1 sky130_fd_sc_hd__fill_1
X_12897_ cell3.CB_1.config_dataB\[11\] net367 net941 vssd1 vssd1 vccd1 vccd1 _01326_
+ sky130_fd_sc_hd__mux2_1
XFILLER_72_170 vssd1 vssd1 vccd1 vccd1 sky130_fd_sc_hd__fill_2
X_11917_ cell0.SB0.route_sel\[23\] cell0.SB0.route_sel\[22\] net763 vssd1 vssd1 vccd1
+ vccd1 _00354_ sky130_fd_sc_hd__mux2_1
XTAP_TAPCELL_ROW_103_1853 vssd1 vccd1 sky130_fd_sc_hd__tapvpwrvgnd_1
X_11848_ cell1.CB_0.config_dataB\[4\] cell1.CB_0.config_dataB\[3\] net897 vssd1 vssd1
+ vccd1 vccd1 _00285_ sky130_fd_sc_hd__mux2_1
XPHY_EDGE_ROW_109_Left_252 vssd1 vssd1 vccd1 vccd1 sky130_fd_sc_hd__decap_3
XANTENNA__09789__A3 bus3_2\[15\] vssd1 vssd1 vccd1 vccd1 sky130_fd_sc_hd__diode_2
XANTENNA__08446__A0 net31 vssd1 vssd1 vccd1 vccd1 sky130_fd_sc_hd__diode_2
XANTENNA__08997__A1 bus3_1\[7\] vssd1 vssd1 vccd1 vccd1 sky130_fd_sc_hd__diode_2
X_11779_ net1328 cell0.LEI0.config_data\[28\] net793 vssd1 vssd1 vccd1 vccd1 _00216_
+ sky130_fd_sc_hd__mux2_1
X_13518_ clknet_leaf_100_clk net996 net680 vssd1 vssd1 vccd1 vccd1 cell1.LE_1A.config_data\[5\]
+ sky130_fd_sc_hd__dfrtp_1
XTAP_TAPCELL_ROW_31_769 vssd1 vccd1 sky130_fd_sc_hd__tapvpwrvgnd_1
XTAP_TAPCELL_ROW_136_2352 vssd1 vccd1 sky130_fd_sc_hd__tapvpwrvgnd_1
XTAP_TAPCELL_ROW_136_2341 vssd1 vccd1 sky130_fd_sc_hd__tapvpwrvgnd_1
XFILLER_9_274 vssd1 vssd1 vccd1 vccd1 sky130_fd_sc_hd__fill_2
Xclkload11 clknet_4_12_0_clk vssd1 vssd1 vccd1 vccd1 clkload11/Y sky130_fd_sc_hd__clkinvlp_4
Xclkload44 clknet_leaf_20_clk vssd1 vssd1 vccd1 vccd1 clkload44/Y sky130_fd_sc_hd__clkinv_4
Xclkload22 clknet_leaf_3_clk vssd1 vssd1 vccd1 vccd1 clkload22/Y sky130_fd_sc_hd__clkinv_2
X_13449_ clknet_leaf_123_clk _00421_ net585 vssd1 vssd1 vccd1 vccd1 cell0.SB0.route_sel\[90\]
+ sky130_fd_sc_hd__dfstp_1
XTAP_TAPCELL_ROW_11_471 vssd1 vccd1 sky130_fd_sc_hd__tapvpwrvgnd_1
Xclkload33 clknet_leaf_128_clk vssd1 vssd1 vccd1 vccd1 clkload33/Y sky130_fd_sc_hd__inv_8
Xclkload66 clknet_leaf_37_clk vssd1 vssd1 vccd1 vccd1 clkload66/Y sky130_fd_sc_hd__clkinv_8
Xclkload55 clknet_leaf_15_clk vssd1 vssd1 vccd1 vccd1 clkload55/Y sky130_fd_sc_hd__clkinv_8
Xclkload77 clknet_leaf_112_clk vssd1 vssd1 vccd1 vccd1 clkload77/Y sky130_fd_sc_hd__clkinv_2
XANTENNA__09337__Y _04362_ vssd1 vssd1 vccd1 vccd1 sky130_fd_sc_hd__diode_2
Xclkload99 clknet_leaf_93_clk vssd1 vssd1 vccd1 vccd1 clkload99/Y sky130_fd_sc_hd__clkinv_4
Xclkload88 clknet_leaf_99_clk vssd1 vssd1 vccd1 vccd1 clkload88/X sky130_fd_sc_hd__clkbuf_4
XFILLER_114_378 vssd1 vssd1 vccd1 vccd1 sky130_fd_sc_hd__fill_1
X_08990_ net482 cell1.CB_0.config_dataB\[6\] vssd1 vssd1 vccd1 vccd1 _04020_ sky130_fd_sc_hd__nor2_1
XANTENNA__10308__A1 net305 vssd1 vssd1 vccd1 vccd1 sky130_fd_sc_hd__diode_2
XPHY_EDGE_ROW_118_Left_261 vssd1 vssd1 vccd1 vccd1 sky130_fd_sc_hd__decap_3
X_07941_ bus2_0\[6\] bus2_0\[7\] net512 vssd1 vssd1 vccd1 vccd1 _02985_ sky130_fd_sc_hd__mux2_1
X_07872_ net342 net346 net350 net338 cell0.LEI0.config_data\[12\] cell0.LEI0.config_data\[13\]
+ vssd1 vssd1 vccd1 vccd1 _02916_ sky130_fd_sc_hd__mux4_2
X_09611_ _04626_ net282 _04625_ vssd1 vssd1 vccd1 vccd1 _04628_ sky130_fd_sc_hd__mux2_1
X_06823_ _01886_ _01892_ vssd1 vssd1 vccd1 vccd1 _01893_ sky130_fd_sc_hd__nor2_1
XFILLER_18_29 vccd1 vssd1 vccd1 vssd1 sky130_ef_sc_hd__decap_40_12
X_06754_ net283 vssd1 vssd1 vccd1 vccd1 _01824_ sky130_fd_sc_hd__inv_2
XFILLER_83_446 vssd1 vssd1 vccd1 vccd1 sky130_fd_sc_hd__fill_2
X_09542_ net329 _02152_ _02156_ _04560_ _04557_ vssd1 vssd1 vccd1 vccd1 _04561_ sky130_fd_sc_hd__o221ai_4
XFILLER_36_351 vssd1 vssd1 vccd1 vccd1 sky130_fd_sc_hd__fill_1
X_06685_ cell2.LEI0.config_data\[5\] vssd1 vssd1 vccd1 vccd1 _01755_ sky130_fd_sc_hd__inv_2
X_09473_ _04494_ _04492_ vssd1 vssd1 vccd1 vccd1 bus3_1\[6\] sky130_fd_sc_hd__and2b_2
Xclkbuf_leaf_90_clk clknet_4_11_0_clk vssd1 vssd1 vccd1 vccd1 clknet_leaf_90_clk sky130_fd_sc_hd__clkbuf_8
XTAP_TAPCELL_ROW_19_593 vssd1 vccd1 sky130_fd_sc_hd__tapvpwrvgnd_1
XPHY_EDGE_ROW_127_Left_270 vssd1 vssd1 vccd1 vccd1 sky130_fd_sc_hd__decap_3
X_08424_ cell0.LE_1B.dff0_out cell0.LE_1B.dff1_out cell0.LE_1B.reset_val vssd1 vssd1
+ vccd1 vccd1 cell0.LE_1B.dff_out sky130_fd_sc_hd__mux2_1
XFILLER_51_343 vssd1 vssd1 vccd1 vccd1 sky130_fd_sc_hd__fill_1
X_08355_ _02136_ _03384_ _03392_ cell0.CB_1.config_dataB\[12\] vssd1 vssd1 vccd1 vccd1
+ _03393_ sky130_fd_sc_hd__a211oi_1
Xclkload5 clknet_4_5_0_clk vssd1 vssd1 vccd1 vccd1 clkload5/Y sky130_fd_sc_hd__clkinv_8
X_07306_ _02354_ _02355_ _02363_ vssd1 vssd1 vccd1 vccd1 _02364_ sky130_fd_sc_hd__o21ai_1
X_08286_ _02350_ _03317_ _03322_ _03323_ cell0.CB_1.config_dataB\[7\] vssd1 vssd1
+ vccd1 vccd1 _03324_ sky130_fd_sc_hd__o221a_1
XANTENNA__07660__A1 net87 vssd1 vssd1 vccd1 vccd1 sky130_fd_sc_hd__diode_2
X_07237_ cell1.SB0.route_sel\[90\] _01536_ cell1.SB0.route_sel\[93\] _01537_ _02296_
+ vssd1 vssd1 vccd1 vccd1 _02297_ sky130_fd_sc_hd__a221o_1
XANTENNA__09528__X _04548_ vssd1 vssd1 vccd1 vccd1 sky130_fd_sc_hd__diode_2
XTAP_TAPCELL_ROW_76_1443 vssd1 vccd1 sky130_fd_sc_hd__tapvpwrvgnd_1
XFILLER_3_417 vccd1 vssd1 vccd1 vssd1 sky130_ef_sc_hd__decap_40_12
XANTENNA_fanout790_A net807 vssd1 vssd1 vccd1 vccd1 sky130_fd_sc_hd__diode_2
X_07168_ cell1.SB0.route_sel\[80\] cell1.SB0.route_sel\[81\] _02222_ _02229_ vssd1
+ vssd1 vccd1 vccd1 _02230_ sky130_fd_sc_hd__a31o_1
XFILLER_117_194 vssd1 vssd1 vccd1 vccd1 sky130_fd_sc_hd__fill_1
XTAP_TAPCELL_ROW_76_1454 vssd1 vccd1 sky130_fd_sc_hd__tapvpwrvgnd_1
X_07099_ cell2.CB_1.config_dataA\[24\] cell2.CB_1.config_dataA\[21\] cell2.CB_1.config_dataA\[20\]
+ vssd1 vssd1 vccd1 vccd1 _02162_ sky130_fd_sc_hd__or3b_2
XANTENNA__13213__SET_B net751 vssd1 vssd1 vccd1 vccd1 sky130_fd_sc_hd__diode_2
XANTENNA__07176__B1 _02203_ vssd1 vssd1 vccd1 vccd1 sky130_fd_sc_hd__diode_2
XFILLER_59_443 vssd1 vssd1 vccd1 vccd1 sky130_fd_sc_hd__fill_4
Xfanout286 cell3.CB_0.le_outA vssd1 vssd1 vccd1 vccd1 net286 sky130_fd_sc_hd__buf_2
Xfanout297 net298 vssd1 vssd1 vccd1 vccd1 net297 sky130_fd_sc_hd__clkbuf_2
X_09809_ bus3_2\[6\] bus3_2\[7\] net447 vssd1 vssd1 vccd1 vccd1 _04815_ sky130_fd_sc_hd__mux2_1
XFILLER_75_24 vssd1 vssd1 vccd1 vccd1 sky130_fd_sc_hd__fill_1
XANTENNA__08912__A1 bus3_1\[1\] vssd1 vssd1 vccd1 vccd1 sky130_fd_sc_hd__diode_2
XANTENNA__07715__A2 net353 vssd1 vssd1 vccd1 vccd1 sky130_fd_sc_hd__diode_2
X_12820_ cell2.SB0.route_sel\[62\] cell2.SB0.route_sel\[61\] net809 vssd1 vssd1 vccd1
+ vccd1 _01249_ sky130_fd_sc_hd__mux2_1
XANTENNA__09423__B _04442_ vssd1 vssd1 vccd1 vccd1 sky130_fd_sc_hd__diode_2
XANTENNA_input121_A SBwest_in[31] vssd1 vssd1 vccd1 vccd1 sky130_fd_sc_hd__diode_2
XFILLER_62_619 vssd1 vssd1 vccd1 vccd1 sky130_fd_sc_hd__fill_1
XFILLER_15_502 vssd1 vssd1 vccd1 vccd1 sky130_fd_sc_hd__fill_2
X_12751_ cell3.CB_0.config_dataA\[18\] cell3.CB_0.config_dataA\[17\] net929 vssd1
+ vssd1 vccd1 vccd1 _01180_ sky130_fd_sc_hd__mux2_1
XTAP_TAPCELL_ROW_38_880 vssd1 vccd1 sky130_fd_sc_hd__tapvpwrvgnd_1
X_12682_ cell3.LE_1B.reset_mode net1511 net957 vssd1 vssd1 vccd1 vccd1 _01111_ sky130_fd_sc_hd__mux2_1
Xclkbuf_leaf_81_clk clknet_4_12_0_clk vssd1 vssd1 vccd1 vccd1 clknet_leaf_81_clk sky130_fd_sc_hd__clkbuf_8
X_11702_ net755 _03311_ vssd1 vssd1 vccd1 vccd1 _06374_ sky130_fd_sc_hd__nand2_1
X_14421_ clknet_leaf_38_clk net1213 net648 vssd1 vssd1 vccd1 vccd1 cell3.LE_0A.config_data\[8\]
+ sky130_fd_sc_hd__dfrtp_1
X_11633_ cell0.CB_0.config_dataA\[4\] cell0.CB_0.config_dataA\[3\] net769 vssd1 vssd1
+ vccd1 vccd1 _00074_ sky130_fd_sc_hd__mux2_1
X_14352_ clknet_leaf_69_clk _01324_ net732 vssd1 vssd1 vccd1 vccd1 cell3.CB_1.config_dataB\[9\]
+ sky130_fd_sc_hd__dfstp_1
X_11564_ net1089 cell0.LE_1B.config_data\[4\] net801 vssd1 vssd1 vccd1 vccd1 _00005_
+ sky130_fd_sc_hd__mux2_1
XFILLER_10_251 vssd1 vssd1 vccd1 vccd1 sky130_fd_sc_hd__fill_1
XTAP_TAPCELL_ROW_118_2082 vssd1 vccd1 sky130_fd_sc_hd__tapvpwrvgnd_1
XTAP_TAPCELL_ROW_118_2071 vssd1 vccd1 sky130_fd_sc_hd__tapvpwrvgnd_1
X_11495_ _06330_ _04295_ vssd1 vssd1 vccd1 vccd1 net239 sky130_fd_sc_hd__and2b_1
X_10515_ cell3.SB0.route_sel\[62\] _01715_ vssd1 vssd1 vccd1 vccd1 _05473_ sky130_fd_sc_hd__nand2_1
X_14283_ clknet_leaf_21_clk _01255_ net610 vssd1 vssd1 vccd1 vccd1 cell2.SB0.route_sel\[68\]
+ sky130_fd_sc_hd__dfstp_1
XFILLER_7_745 vssd1 vssd1 vccd1 vccd1 sky130_fd_sc_hd__fill_1
X_13303_ clknet_leaf_99_clk _00275_ net680 vssd1 vssd1 vccd1 vccd1 cell1.CB_1.config_dataA\[19\]
+ sky130_fd_sc_hd__dfstp_1
X_10446_ cell3.SB0.route_sel\[48\] cell3.SB0.route_sel\[49\] cell3.SB0.route_sel\[52\]
+ _01712_ _05437_ vssd1 vssd1 vccd1 vccd1 _05438_ sky130_fd_sc_hd__o221a_1
X_13234_ clknet_leaf_10_clk net1287 net585 vssd1 vssd1 vccd1 vccd1 cell0.LEI0.config_data\[19\]
+ sky130_fd_sc_hd__dfrtp_1
XFILLER_40_60 vssd1 vssd1 vccd1 vccd1 sky130_fd_sc_hd__fill_2
XTAP_TAPCELL_ROW_131_2271 vssd1 vccd1 sky130_fd_sc_hd__tapvpwrvgnd_1
X_10377_ cell2.CB_0.config_dataB\[12\] _05375_ _05373_ cell2.CB_0.config_dataB\[13\]
+ vssd1 vssd1 vccd1 vccd1 _05376_ sky130_fd_sc_hd__o211a_1
X_13165_ clknet_leaf_117_clk _00137_ net669 vssd1 vssd1 vccd1 vccd1 cell0.LE_1A.config_data\[16\]
+ sky130_fd_sc_hd__dfrtp_1
XFILLER_111_337 vssd1 vssd1 vccd1 vccd1 sky130_fd_sc_hd__fill_1
X_12116_ net755 _04018_ vssd1 vssd1 vccd1 vccd1 _06380_ sky130_fd_sc_hd__nand2_1
X_13096_ clknet_leaf_9_clk _00068_ net573 vssd1 vssd1 vccd1 vccd1 cell0.CB_0.config_dataB\[23\]
+ sky130_fd_sc_hd__dfstp_1
X_12047_ net756 _03812_ vssd1 vssd1 vccd1 vccd1 _06377_ sky130_fd_sc_hd__nand2_1
XANTENNA__09156__A1 net342 vssd1 vssd1 vccd1 vccd1 sky130_fd_sc_hd__diode_2
XFILLER_38_649 vssd1 vssd1 vccd1 vccd1 sky130_fd_sc_hd__fill_1
XANTENNA__07275__B1_N net68 vssd1 vssd1 vccd1 vccd1 sky130_fd_sc_hd__diode_2
XANTENNA__10112__X _05113_ vssd1 vssd1 vccd1 vccd1 sky130_fd_sc_hd__diode_2
XANTENNA__14147__SET_B net727 vssd1 vssd1 vccd1 vccd1 sky130_fd_sc_hd__diode_2
X_13998_ clknet_leaf_79_clk _00970_ net708 vssd1 vssd1 vccd1 vccd1 cell3.SB0.route_sel\[6\]
+ sky130_fd_sc_hd__dfstp_1
X_12949_ net1132 cell3.LE_0B.config_data\[13\] net950 vssd1 vssd1 vccd1 vccd1 _01377_
+ sky130_fd_sc_hd__mux2_1
XANTENNA__12463__A1 cell1.SB0.config_data_out vssd1 vssd1 vccd1 vccd1 sky130_fd_sc_hd__diode_2
XFILLER_52_118 vssd1 vssd1 vccd1 vccd1 sky130_fd_sc_hd__fill_1
XTAP_TAPCELL_ROW_47_1011 vssd1 vccd1 sky130_fd_sc_hd__tapvpwrvgnd_1
Xclkbuf_leaf_72_clk clknet_4_14_0_clk vssd1 vssd1 vccd1 vccd1 clknet_leaf_72_clk sky130_fd_sc_hd__clkbuf_8
XTAP_TAPCELL_ROW_16_541 vssd1 vccd1 sky130_fd_sc_hd__tapvpwrvgnd_1
X_06470_ cell1.SB0.route_sel\[98\] vssd1 vssd1 vccd1 vccd1 _01540_ sky130_fd_sc_hd__inv_2
XTAP_TAPCELL_ROW_16_552 vssd1 vccd1 sky130_fd_sc_hd__tapvpwrvgnd_1
XTAP_TAPCELL_ROW_60_1211 vssd1 vccd1 sky130_fd_sc_hd__tapvpwrvgnd_1
X_08140_ net547 _01956_ vssd1 vssd1 vccd1 vccd1 _03180_ sky130_fd_sc_hd__nand2_1
Xclkload111 clknet_leaf_53_clk vssd1 vssd1 vccd1 vccd1 clkload111/Y sky130_fd_sc_hd__bufinv_16
Xclkload122 clknet_leaf_76_clk vssd1 vssd1 vccd1 vccd1 clkload122/Y sky130_fd_sc_hd__clkinvlp_4
X_08071_ cell0.CB_0.config_dataB\[13\] cell0.CB_0.config_dataB\[12\] _03111_ _03112_
+ vssd1 vssd1 vccd1 vccd1 _03113_ sky130_fd_sc_hd__o22a_1
Xclkload100 clknet_leaf_94_clk vssd1 vssd1 vccd1 vccd1 clkload100/Y sky130_fd_sc_hd__inv_8
Xclkload133 clknet_1_1__leaf_cell3.LE_0A.sel_clk vssd1 vssd1 vccd1 vccd1 clkload133/X
+ sky130_fd_sc_hd__clkbuf_4
X_07022_ cell2.CB_1.config_dataA\[24\] cell2.CB_1.config_dataA\[20\] cell2.CB_1.config_dataA\[21\]
+ vssd1 vssd1 vccd1 vccd1 _02087_ sky130_fd_sc_hd__or3_1
Xclkload144 clknet_1_1__leaf_cell1.LE_1B.sel_clk vssd1 vssd1 vccd1 vccd1 clkload144/X
+ sky130_fd_sc_hd__clkbuf_4
XANTENNA__10942__B cell3.SB0.route_sel\[44\] vssd1 vssd1 vccd1 vccd1 sky130_fd_sc_hd__diode_2
XANTENNA__10529__B2 cell3.SB0.route_sel\[37\] vssd1 vssd1 vccd1 vccd1 sky130_fd_sc_hd__diode_2
XTAP_TAPCELL_ROW_58_1184 vssd1 vccd1 sky130_fd_sc_hd__tapvpwrvgnd_1
XTAP_TAPCELL_ROW_58_1173 vssd1 vccd1 sky130_fd_sc_hd__tapvpwrvgnd_1
X_08973_ cell1.LEI0.config_data\[38\] _04001_ _04003_ _03999_ vssd1 vssd1 vccd1 vccd1
+ _04005_ sky130_fd_sc_hd__o31a_1
Xhold17 cell3.LE_0B.config_data\[9\] vssd1 vssd1 vccd1 vccd1 net976 sky130_fd_sc_hd__dlygate4sd3_1
Xhold28 _01391_ vssd1 vssd1 vccd1 vccd1 net987 sky130_fd_sc_hd__dlygate4sd3_1
XTAP_TAPCELL_ROW_71_1373 vssd1 vccd1 sky130_fd_sc_hd__tapvpwrvgnd_1
X_07924_ net515 _02301_ vssd1 vssd1 vccd1 vccd1 _02968_ sky130_fd_sc_hd__nand2_1
XFILLER_29_39 vccd1 vssd1 vccd1 vssd1 sky130_ef_sc_hd__decap_40_12
XFILLER_84_711 vssd1 vssd1 vccd1 vccd1 sky130_fd_sc_hd__fill_8
Xhold39 _00166_ vssd1 vssd1 vccd1 vccd1 net998 sky130_fd_sc_hd__dlygate4sd3_1
XANTENNA__13349__SET_B net674 vssd1 vssd1 vccd1 vccd1 sky130_fd_sc_hd__diode_2
XANTENNA__10701__A1 net16 vssd1 vssd1 vccd1 vccd1 sky130_fd_sc_hd__diode_2
XFILLER_83_221 vssd1 vssd1 vccd1 vccd1 sky130_fd_sc_hd__fill_2
XFILLER_83_210 vssd1 vssd1 vccd1 vccd1 sky130_fd_sc_hd__fill_8
X_07855_ net518 _02894_ _02898_ net517 vssd1 vssd1 vccd1 vccd1 _02899_ sky130_fd_sc_hd__o211a_1
XFILLER_28_115 vssd1 vssd1 vccd1 vccd1 sky130_fd_sc_hd__fill_2
XFILLER_84_788 vssd1 vssd1 vccd1 vccd1 sky130_fd_sc_hd__fill_1
XFILLER_83_276 vssd1 vssd1 vccd1 vccd1 sky130_fd_sc_hd__fill_4
X_06806_ _01456_ cell0.SB0.route_sel\[49\] cell0.SB0.route_sel\[54\] _01459_ _01875_
+ vssd1 vssd1 vccd1 vccd1 _01876_ sky130_fd_sc_hd__a221o_2
X_07786_ net92 _02829_ _02830_ vssd1 vssd1 vccd1 vccd1 _02831_ sky130_fd_sc_hd__a21oi_1
X_09525_ cell3.CB_0.config_dataA\[22\] cell3.CB_0.config_dataA\[23\] vssd1 vssd1 vccd1
+ vccd1 _04545_ sky130_fd_sc_hd__nand2b_1
X_06737_ cell3.CB_0.config_dataA\[4\] vssd1 vssd1 vccd1 vccd1 _01807_ sky130_fd_sc_hd__inv_2
XFILLER_83_287 vssd1 vssd1 vccd1 vccd1 sky130_fd_sc_hd__fill_1
XANTENNA__06920__A3 _01985_ vssd1 vssd1 vccd1 vccd1 sky130_fd_sc_hd__diode_2
XFILLER_37_671 vssd1 vssd1 vccd1 vccd1 sky130_fd_sc_hd__fill_1
XANTENNA_fanout636_A net640 vssd1 vssd1 vccd1 vccd1 sky130_fd_sc_hd__diode_2
Xclkbuf_leaf_63_clk clknet_4_15_0_clk vssd1 vssd1 vccd1 vccd1 clknet_leaf_63_clk sky130_fd_sc_hd__clkbuf_8
X_06668_ cell3.SB0.route_sel\[98\] vssd1 vssd1 vccd1 vccd1 _01738_ sky130_fd_sc_hd__inv_2
X_09456_ _04304_ _04406_ vssd1 vssd1 vccd1 vccd1 _04478_ sky130_fd_sc_hd__nor2_1
XFILLER_101_66 vssd1 vssd1 vccd1 vccd1 sky130_fd_sc_hd__fill_2
XANTENNA__07331__X _02388_ vssd1 vssd1 vccd1 vccd1 sky130_fd_sc_hd__diode_2
X_08407_ _03434_ _03435_ _03443_ _03444_ vssd1 vssd1 vccd1 vccd1 _03445_ sky130_fd_sc_hd__o22a_1
XFILLER_101_77 vssd1 vssd1 vccd1 vccd1 sky130_fd_sc_hd__fill_1
X_09387_ _04376_ _04377_ _04402_ _04410_ vssd1 vssd1 vccd1 vccd1 _04411_ sky130_fd_sc_hd__a31o_1
X_06599_ cell1.CB_0.config_dataB\[2\] vssd1 vssd1 vccd1 vccd1 _01669_ sky130_fd_sc_hd__inv_2
XANTENNA__07881__A1 _02905_ vssd1 vssd1 vccd1 vccd1 sky130_fd_sc_hd__diode_2
XANTENNA__07881__B2 _02902_ vssd1 vssd1 vccd1 vccd1 sky130_fd_sc_hd__diode_2
XANTENNA__07698__B _01931_ vssd1 vssd1 vccd1 vccd1 sky130_fd_sc_hd__diode_2
XFILLER_138_713 vssd1 vssd1 vccd1 vccd1 sky130_fd_sc_hd__fill_1
X_08338_ _02136_ _03350_ _03374_ _03375_ cell0.CB_1.config_dataB\[2\] vssd1 vssd1
+ vccd1 vccd1 _03376_ sky130_fd_sc_hd__a2111o_1
XFILLER_138_757 vccd1 vssd1 vccd1 vssd1 sky130_ef_sc_hd__decap_40_12
XFILLER_137_223 vssd1 vssd1 vccd1 vccd1 sky130_fd_sc_hd__fill_1
X_08269_ _03308_ _03307_ _03231_ vssd1 vssd1 vccd1 vccd1 _03309_ sky130_fd_sc_hd__mux2_1
XANTENNA__07633__A1 _02658_ vssd1 vssd1 vccd1 vccd1 sky130_fd_sc_hd__diode_2
X_11280_ _06208_ net310 _02464_ vssd1 vssd1 vccd1 vccd1 net170 sky130_fd_sc_hd__mux2_2
X_10300_ net431 _05084_ vssd1 vssd1 vccd1 vccd1 _05299_ sky130_fd_sc_hd__nand2_1
XFILLER_106_643 vssd1 vssd1 vccd1 vccd1 sky130_fd_sc_hd__fill_1
X_10231_ _05231_ _05197_ _05164_ vssd1 vssd1 vccd1 vccd1 _05232_ sky130_fd_sc_hd__mux2_1
XANTENNA__08189__A2 net350 vssd1 vssd1 vccd1 vccd1 sky130_fd_sc_hd__diode_2
XFILLER_4_737 vccd1 vssd1 vccd1 vssd1 sky130_ef_sc_hd__decap_40_12
XFILLER_3_225 vccd1 vssd1 vccd1 vssd1 sky130_ef_sc_hd__decap_40_12
XFILLER_10_41 vccd1 vssd1 vccd1 vssd1 sky130_ef_sc_hd__decap_40_12
XFILLER_126_41 vccd1 vssd1 vccd1 vssd1 sky130_ef_sc_hd__decap_40_12
X_10162_ cell2.CB_0.config_dataA\[9\] _05094_ _05122_ _05162_ _01768_ vssd1 vssd1
+ vccd1 vccd1 _05163_ sky130_fd_sc_hd__a32o_1
XFILLER_10_85 vccd1 vssd1 vccd1 vssd1 sky130_ef_sc_hd__decap_40_12
X_10093_ net417 net418 vssd1 vssd1 vccd1 vccd1 _05094_ sky130_fd_sc_hd__and2b_1
XANTENNA__09705__Y _04718_ vssd1 vssd1 vccd1 vccd1 sky130_fd_sc_hd__diode_2
XFILLER_87_582 vssd1 vssd1 vccd1 vccd1 sky130_fd_sc_hd__fill_1
X_13921_ clknet_leaf_14_clk _00893_ net629 vssd1 vssd1 vccd1 vccd1 cell2.LE_0A.config_data\[0\]
+ sky130_fd_sc_hd__dfrtp_4
XFILLER_142_40 vssd1 vssd1 vccd1 vccd1 sky130_fd_sc_hd__fill_4
XTAP_TAPCELL_ROW_89_1645 vssd1 vccd1 sky130_fd_sc_hd__tapvpwrvgnd_1
X_13852_ clknet_leaf_45_clk _00824_ net631 vssd1 vssd1 vccd1 vccd1 cell2.CB_1.config_dataB\[1\]
+ sky130_fd_sc_hd__dfstp_1
X_12803_ cell2.SB0.route_sel\[45\] cell2.SB0.route_sel\[44\] net812 vssd1 vssd1 vccd1
+ vccd1 _01232_ sky130_fd_sc_hd__mux2_1
X_13783_ clknet_leaf_108_clk _00755_ net651 vssd1 vssd1 vccd1 vccd1 cell1.SB0.route_sel\[60\]
+ sky130_fd_sc_hd__dfstp_1
Xclkbuf_leaf_54_clk clknet_4_13_0_clk vssd1 vssd1 vccd1 vccd1 clknet_leaf_54_clk sky130_fd_sc_hd__clkbuf_8
X_10995_ net40 net41 net42 net43 net377 net376 vssd1 vssd1 vccd1 vccd1 _05949_ sky130_fd_sc_hd__mux4_1
X_12734_ net378 net379 net924 vssd1 vssd1 vccd1 vccd1 _01163_ sky130_fd_sc_hd__mux2_1
XFILLER_15_332 vssd1 vssd1 vccd1 vccd1 sky130_fd_sc_hd__fill_2
XTAP_TAPCELL_ROW_33_809 vssd1 vccd1 sky130_fd_sc_hd__tapvpwrvgnd_1
XANTENNA__09861__A2 net316 vssd1 vssd1 vccd1 vccd1 sky130_fd_sc_hd__diode_2
XTAP_TAPCELL_ROW_100_1801 vssd1 vccd1 sky130_fd_sc_hd__tapvpwrvgnd_1
XFILLER_96_9 vccd1 vssd1 vccd1 vssd1 sky130_ef_sc_hd__decap_40_12
XTAP_TAPCELL_ROW_13_500 vssd1 vccd1 sky130_fd_sc_hd__tapvpwrvgnd_1
X_12665_ net1221 cell3.LE_1B.config_data\[1\] net957 vssd1 vssd1 vccd1 vccd1 _01094_
+ sky130_fd_sc_hd__mux2_1
XANTENNA__10208__A0 net36 vssd1 vssd1 vccd1 vccd1 sky130_fd_sc_hd__diode_2
XTAP_TAPCELL_ROW_100_1812 vssd1 vccd1 sky130_fd_sc_hd__tapvpwrvgnd_1
XANTENNA__07872__A1 net346 vssd1 vssd1 vccd1 vccd1 sky130_fd_sc_hd__diode_2
X_14404_ clknet_leaf_61_clk net1225 net739 vssd1 vssd1 vccd1 vccd1 cell3.LE_0B.config_data\[13\]
+ sky130_fd_sc_hd__dfrtp_1
X_12596_ cell3.SB0.route_sel\[61\] cell3.SB0.route_sel\[60\] net834 vssd1 vssd1 vccd1
+ vccd1 _01025_ sky130_fd_sc_hd__mux2_1
X_11616_ cell0.CB_0.config_dataB\[12\] net526 net769 vssd1 vssd1 vccd1 vccd1 _00057_
+ sky130_fd_sc_hd__mux2_1
XTAP_TAPCELL_ROW_133_2300 vssd1 vccd1 sky130_fd_sc_hd__tapvpwrvgnd_1
X_14335_ clknet_leaf_19_clk _01307_ net614 vssd1 vssd1 vccd1 vccd1 cell2.SB0.route_sel\[120\]
+ sky130_fd_sc_hd__dfstp_1
X_11547_ cell0.SB0.route_sel\[23\] cell0.SB0.route_sel\[22\] vssd1 vssd1 vccd1 vccd1
+ _06365_ sky130_fd_sc_hd__or2_1
Xhold509 cell1.LE_0A.dff1_out vssd1 vssd1 vccd1 vccd1 net1468 sky130_fd_sc_hd__dlygate4sd3_1
X_14266_ clknet_leaf_24_clk _01238_ net605 vssd1 vssd1 vccd1 vccd1 cell2.SB0.route_sel\[51\]
+ sky130_fd_sc_hd__dfstp_1
X_11478_ cell1.SB0.route_sel\[105\] cell1.SB0.route_sel\[104\] vssd1 vssd1 vccd1 vccd1
+ _06319_ sky130_fd_sc_hd__nand2b_1
X_10429_ cell2.LE_0B.config_data\[16\] _05425_ _05426_ net351 vssd1 vssd1 vccd1 vccd1
+ cell2.CB_0.le_outB sky130_fd_sc_hd__o211a_1
XFILLER_124_451 vssd1 vssd1 vccd1 vccd1 sky130_fd_sc_hd__fill_1
X_14197_ clknet_leaf_53_clk _01169_ net715 vssd1 vssd1 vccd1 vccd1 cell3.CB_0.config_dataA\[7\]
+ sky130_fd_sc_hd__dfstp_2
XFILLER_112_602 vssd1 vssd1 vccd1 vccd1 sky130_fd_sc_hd__fill_1
X_13217_ clknet_leaf_11_clk _00189_ net589 vssd1 vssd1 vccd1 vccd1 cell0.LEI0.config_data\[2\]
+ sky130_fd_sc_hd__dfrtp_1
XFILLER_98_847 vssd1 vssd1 vccd1 vccd1 sky130_fd_sc_hd__fill_1
XFILLER_97_324 vssd1 vssd1 vccd1 vccd1 sky130_fd_sc_hd__fill_1
X_13148_ clknet_1_0__leaf_cell0.LE_1B.sel_clk _00120_ net751 vssd1 vssd1 vccd1 vccd1
+ cell0.LE_1B.dff0_out sky130_fd_sc_hd__dfrtp_1
XFILLER_3_781 vssd1 vssd1 vccd1 vccd1 sky130_fd_sc_hd__fill_2
XANTENNA__07129__A net339 vssd1 vssd1 vccd1 vccd1 sky130_fd_sc_hd__diode_2
XTAP_TAPCELL_ROW_111_1974 vssd1 vccd1 sky130_fd_sc_hd__tapvpwrvgnd_1
X_13079_ clknet_leaf_6_clk _00051_ net568 vssd1 vssd1 vccd1 vccd1 cell0.CB_0.config_dataB\[6\]
+ sky130_fd_sc_hd__dfstp_1
XFILLER_25_3 vccd1 vssd1 vccd1 vssd1 sky130_ef_sc_hd__decap_40_12
XANTENNA__12684__A1 net398 vssd1 vssd1 vccd1 vccd1 sky130_fd_sc_hd__diode_2
XFILLER_66_733 vssd1 vssd1 vccd1 vccd1 sky130_fd_sc_hd__fill_1
X_07640_ _02688_ net334 _02686_ vssd1 vssd1 vccd1 vccd1 _02689_ sky130_fd_sc_hd__mux2_1
XFILLER_26_619 vssd1 vssd1 vccd1 vccd1 sky130_fd_sc_hd__fill_1
X_07571_ _02026_ _02620_ vssd1 vssd1 vccd1 vccd1 _02621_ sky130_fd_sc_hd__nor2_1
XFILLER_19_671 vssd1 vssd1 vccd1 vccd1 sky130_fd_sc_hd__fill_1
X_09310_ _04331_ _04333_ _04334_ vssd1 vssd1 vccd1 vccd1 _04335_ sky130_fd_sc_hd__a21oi_1
Xclkbuf_leaf_45_clk clknet_4_6_0_clk vssd1 vssd1 vccd1 vccd1 clknet_leaf_45_clk sky130_fd_sc_hd__clkbuf_8
XANTENNA__12909__S net940 vssd1 vssd1 vccd1 vccd1 sky130_fd_sc_hd__diode_2
XANTENNA__11813__S net905 vssd1 vssd1 vccd1 vccd1 sky130_fd_sc_hd__diode_2
X_06522_ cell0.SB0.route_sel\[23\] vssd1 vssd1 vccd1 vccd1 _01592_ sky130_fd_sc_hd__inv_2
XANTENNA__06974__Y _02040_ vssd1 vssd1 vccd1 vccd1 sky130_fd_sc_hd__diode_2
XANTENNA__10998__A1 net45 vssd1 vssd1 vccd1 vccd1 sky130_fd_sc_hd__diode_2
XANTENNA__10998__B2 net46 vssd1 vssd1 vccd1 vccd1 sky130_fd_sc_hd__diode_2
XFILLER_80_268 vssd1 vssd1 vccd1 vccd1 sky130_fd_sc_hd__fill_1
XANTENNA__08655__A3 net3 vssd1 vssd1 vccd1 vccd1 sky130_fd_sc_hd__diode_2
X_09241_ _04219_ _04267_ vssd1 vssd1 vccd1 vccd1 _04268_ sky130_fd_sc_hd__nor2_1
X_06453_ cell1.SB0.route_sel\[61\] vssd1 vssd1 vccd1 vccd1 _01523_ sky130_fd_sc_hd__inv_2
XFILLER_21_313 vssd1 vssd1 vccd1 vccd1 sky130_fd_sc_hd__fill_1
X_09172_ net318 _04174_ _04199_ cell3.SB0.route_sel\[5\] cell3.SB0.route_sel\[4\]
+ vssd1 vssd1 vccd1 vccd1 _04200_ sky130_fd_sc_hd__o2111a_1
X_08123_ _01563_ cell0.LE_0B.dff_out vssd1 vssd1 vccd1 vccd1 _03164_ sky130_fd_sc_hd__or2_1
XFILLER_135_727 vssd1 vssd1 vccd1 vccd1 sky130_fd_sc_hd__fill_1
X_08054_ _02388_ _03091_ _03092_ _02456_ _01559_ vssd1 vssd1 vccd1 vccd1 _03096_ sky130_fd_sc_hd__a221o_1
XANTENNA__11401__X _06268_ vssd1 vssd1 vccd1 vccd1 sky130_fd_sc_hd__diode_2
X_07005_ cell1.SB0.route_sel\[64\] cell1.SB0.route_sel\[65\] _01525_ cell1.SB0.route_sel\[67\]
+ _02070_ vssd1 vssd1 vccd1 vccd1 _02071_ sky130_fd_sc_hd__o221a_1
XANTENNA__11175__A1 net45 vssd1 vssd1 vccd1 vccd1 sky130_fd_sc_hd__diode_2
XTAP_TAPCELL_ROW_73_1402 vssd1 vccd1 sky130_fd_sc_hd__tapvpwrvgnd_1
XANTENNA__11175__B2 net46 vssd1 vssd1 vccd1 vccd1 sky130_fd_sc_hd__diode_2
XANTENNA__08040__A1 bus2_0\[1\] vssd1 vssd1 vccd1 vccd1 sky130_fd_sc_hd__diode_2
XFILLER_130_421 vssd1 vssd1 vccd1 vccd1 sky130_fd_sc_hd__fill_4
XANTENNA__07981__B net551 vssd1 vssd1 vccd1 vccd1 sky130_fd_sc_hd__diode_2
Xinput118 SBwest_in[29] vssd1 vssd1 vccd1 vccd1 net118 sky130_fd_sc_hd__clkbuf_1
Xinput107 SBwest_in[19] vssd1 vssd1 vccd1 vccd1 net107 sky130_fd_sc_hd__dlymetal6s2s_1
Xinput129 config_data_in vssd1 vssd1 vccd1 vccd1 net129 sky130_fd_sc_hd__buf_1
X_08956_ net465 _03841_ _03987_ net463 vssd1 vssd1 vccd1 vccd1 _03988_ sky130_fd_sc_hd__o211a_1
XFILLER_130_498 vssd1 vssd1 vccd1 vccd1 sky130_fd_sc_hd__fill_2
XANTENNA_fanout753_A net754 vssd1 vssd1 vccd1 vccd1 sky130_fd_sc_hd__diode_2
X_07907_ net516 cell0.CB_0.config_dataA\[11\] vssd1 vssd1 vccd1 vccd1 _02951_ sky130_fd_sc_hd__nor2_1
X_08887_ net474 _03858_ _03918_ vssd1 vssd1 vccd1 vccd1 _03919_ sky130_fd_sc_hd__o21a_1
X_07838_ net519 _01986_ vssd1 vssd1 vccd1 vccd1 _02882_ sky130_fd_sc_hd__nand2_1
XFILLER_112_21 vssd1 vssd1 vccd1 vccd1 sky130_fd_sc_hd__fill_4
XANTENNA_fanout920_A net934 vssd1 vssd1 vccd1 vccd1 sky130_fd_sc_hd__diode_2
Xclkbuf_leaf_36_clk clknet_4_7_0_clk vssd1 vssd1 vccd1 vccd1 clknet_leaf_36_clk sky130_fd_sc_hd__clkbuf_8
X_09508_ _02085_ _02106_ _04526_ _02090_ vssd1 vssd1 vccd1 vccd1 _04528_ sky130_fd_sc_hd__a31oi_2
XFILLER_71_257 vssd1 vssd1 vccd1 vccd1 sky130_fd_sc_hd__fill_1
X_07769_ net328 _02814_ vssd1 vssd1 vccd1 vccd1 _02815_ sky130_fd_sc_hd__nor2_1
X_10780_ _05549_ _05724_ _05734_ net368 cell3.CB_1.config_dataB\[7\] vssd1 vssd1 vccd1
+ vccd1 _05736_ sky130_fd_sc_hd__a221o_1
XANTENNA__09843__A2 _04298_ vssd1 vssd1 vccd1 vccd1 sky130_fd_sc_hd__diode_2
XTAP_TAPCELL_ROW_84_1575 vssd1 vccd1 sky130_fd_sc_hd__tapvpwrvgnd_1
XTAP_TAPCELL_ROW_84_1564 vssd1 vccd1 sky130_fd_sc_hd__tapvpwrvgnd_1
X_09439_ _04458_ _04460_ _04461_ vssd1 vssd1 vccd1 vccd1 _04462_ sky130_fd_sc_hd__a21oi_1
XANTENNA_fanout806_X net806 vssd1 vssd1 vccd1 vccd1 sky130_fd_sc_hd__diode_2
XFILLER_12_313 vssd1 vssd1 vccd1 vccd1 sky130_fd_sc_hd__fill_1
X_12450_ net1288 net1279 net842 vssd1 vssd1 vccd1 vccd1 _00881_ sky130_fd_sc_hd__mux2_1
XFILLER_40_677 vssd1 vssd1 vccd1 vccd1 sky130_fd_sc_hd__fill_1
XANTENNA__14368__RESET_B net753 vssd1 vssd1 vccd1 vccd1 sky130_fd_sc_hd__diode_2
X_11401_ cell0.SB0.route_sel\[77\] _01469_ cell0.SB0.route_sel\[74\] _01470_ _06267_
+ vssd1 vssd1 vccd1 vccd1 _06268_ sky130_fd_sc_hd__a221o_1
X_14120_ clknet_leaf_63_clk _01092_ net747 vssd1 vssd1 vccd1 vccd1 cell3.LE_1B.config_data\[0\]
+ sky130_fd_sc_hd__dfrtp_1
XTAP_TAPCELL_ROW_115_2030 vssd1 vccd1 sky130_fd_sc_hd__tapvpwrvgnd_1
XANTENNA__11311__X net150 vssd1 vssd1 vccd1 vccd1 sky130_fd_sc_hd__diode_2
X_12381_ cell1.SB0.route_sel\[119\] cell1.SB0.route_sel\[118\] net872 vssd1 vssd1
+ vccd1 vccd1 _00814_ sky130_fd_sc_hd__mux2_1
X_11332_ _06231_ net284 _04316_ vssd1 vssd1 vccd1 vccd1 net175 sky130_fd_sc_hd__mux2_1
XFILLER_21_51 vssd1 vssd1 vccd1 vccd1 sky130_fd_sc_hd__fill_4
XFILLER_137_51 vssd1 vssd1 vccd1 vccd1 sky130_fd_sc_hd__fill_4
X_11263_ _05131_ net307 _01921_ vssd1 vssd1 vccd1 vccd1 _06199_ sky130_fd_sc_hd__mux2_1
X_14051_ clknet_leaf_46_clk _01023_ net701 vssd1 vssd1 vccd1 vccd1 cell3.SB0.route_sel\[59\]
+ sky130_fd_sc_hd__dfstp_1
XFILLER_4_545 vccd1 vssd1 vccd1 vssd1 sky130_ef_sc_hd__decap_40_12
XFILLER_134_782 vccd1 vssd1 vccd1 vssd1 sky130_ef_sc_hd__decap_40_12
X_11194_ net383 cell3.CB_0.config_dataB\[16\] vssd1 vssd1 vccd1 vccd1 _06146_ sky130_fd_sc_hd__or2_1
X_13002_ net1463 net1473 net948 vssd1 vssd1 vccd1 vccd1 _01430_ sky130_fd_sc_hd__mux2_1
XFILLER_106_473 vssd1 vssd1 vccd1 vccd1 sky130_fd_sc_hd__fill_2
X_10214_ net415 _05131_ net414 vssd1 vssd1 vccd1 vccd1 _05215_ sky130_fd_sc_hd__o21ai_1
XANTENNA__08031__B2 _02890_ vssd1 vssd1 vccd1 vccd1 sky130_fd_sc_hd__diode_2
XANTENNA__08052__B _02585_ vssd1 vssd1 vccd1 vccd1 sky130_fd_sc_hd__diode_2
XFILLER_4_589 vccd1 vssd1 vccd1 vssd1 sky130_ef_sc_hd__decap_40_12
XFILLER_133_281 vssd1 vssd1 vccd1 vccd1 sky130_fd_sc_hd__fill_1
XFILLER_79_335 vssd1 vssd1 vccd1 vccd1 sky130_fd_sc_hd__fill_1
X_10145_ cell2.SB0.route_sel\[21\] cell2.SB0.route_sel\[20\] vssd1 vssd1 vccd1 vccd1
+ _05146_ sky130_fd_sc_hd__nand2b_1
XFILLER_95_839 vssd1 vssd1 vccd1 vccd1 sky130_fd_sc_hd__fill_1
X_10076_ _01752_ cell2.LE_1B.dff_out vssd1 vssd1 vccd1 vccd1 _05079_ sky130_fd_sc_hd__or2_1
X_13904_ clknet_leaf_31_clk _00876_ net622 vssd1 vssd1 vccd1 vccd1 cell2.LE_0B.config_data\[5\]
+ sky130_fd_sc_hd__dfrtp_1
XANTENNA__07137__A3 net98 vssd1 vssd1 vccd1 vccd1 sky130_fd_sc_hd__diode_2
XTAP_TAPCELL_ROW_126_2192 vssd1 vccd1 sky130_fd_sc_hd__tapvpwrvgnd_1
X_13835_ clknet_leaf_114_clk _00807_ net666 vssd1 vssd1 vccd1 vccd1 cell1.SB0.route_sel\[112\]
+ sky130_fd_sc_hd__dfstp_1
Xclkbuf_leaf_27_clk clknet_4_5_0_clk vssd1 vssd1 vccd1 vccd1 clknet_leaf_27_clk sky130_fd_sc_hd__clkbuf_8
XFILLER_90_566 vssd1 vssd1 vccd1 vccd1 sky130_fd_sc_hd__fill_1
XANTENNA__09170__Y _04198_ vssd1 vssd1 vccd1 vccd1 sky130_fd_sc_hd__diode_2
X_10978_ net377 _05847_ _05931_ cell3.CB_0.config_dataA\[6\] vssd1 vssd1 vccd1 vccd1
+ _05932_ sky130_fd_sc_hd__o211a_1
XANTENNA__09834__A2 bus3_2\[10\] vssd1 vssd1 vccd1 vccd1 sky130_fd_sc_hd__diode_2
X_13766_ clknet_leaf_110_clk _00738_ net651 vssd1 vssd1 vccd1 vccd1 cell1.SB0.route_sel\[43\]
+ sky130_fd_sc_hd__dfstp_1
X_12717_ cell3.CB_0.config_dataB\[9\] cell3.CB_0.config_dataB\[8\] net931 vssd1 vssd1
+ vccd1 vccd1 _01146_ sky130_fd_sc_hd__mux2_1
X_13697_ clknet_leaf_33_clk _00669_ net621 vssd1 vssd1 vccd1 vccd1 cell2.CB_0.config_dataB\[24\]
+ sky130_fd_sc_hd__dfstp_1
XTAP_TAPCELL_ROW_26_691 vssd1 vccd1 sky130_fd_sc_hd__tapvpwrvgnd_1
X_12648_ cell3.SB0.route_sel\[113\] cell3.SB0.route_sel\[112\] net922 vssd1 vssd1
+ vccd1 vccd1 _01077_ sky130_fd_sc_hd__mux2_1
XANTENNA__09598__A1 _02289_ vssd1 vssd1 vccd1 vccd1 sky130_fd_sc_hd__diode_2
X_12579_ cell3.SB0.route_sel\[44\] cell3.SB0.route_sel\[43\] net915 vssd1 vssd1 vccd1
+ vccd1 _01008_ sky130_fd_sc_hd__mux2_1
X_14318_ clknet_leaf_18_clk _01290_ net615 vssd1 vssd1 vccd1 vccd1 cell2.SB0.route_sel\[103\]
+ sky130_fd_sc_hd__dfstp_1
Xhold317 cell1.LEI0.config_data\[44\] vssd1 vssd1 vccd1 vccd1 net1276 sky130_fd_sc_hd__dlygate4sd3_1
Xhold306 cell0.LE_1B.config_data\[9\] vssd1 vssd1 vccd1 vccd1 net1265 sky130_fd_sc_hd__dlygate4sd3_1
Xhold339 cell2.LE_1B.config_data\[1\] vssd1 vssd1 vccd1 vccd1 net1298 sky130_fd_sc_hd__dlygate4sd3_1
X_14249_ clknet_leaf_18_clk _01221_ net614 vssd1 vssd1 vccd1 vccd1 cell2.SB0.route_sel\[34\]
+ sky130_fd_sc_hd__dfstp_1
Xhold328 _00206_ vssd1 vssd1 vccd1 vccd1 net1287 sky130_fd_sc_hd__dlygate4sd3_1
XFILLER_98_600 vssd1 vssd1 vccd1 vccd1 sky130_fd_sc_hd__fill_4
XANTENNA__09626__X _04642_ vssd1 vssd1 vccd1 vccd1 sky130_fd_sc_hd__diode_2
XTAP_TAPCELL_ROW_55_1132 vssd1 vccd1 sky130_fd_sc_hd__tapvpwrvgnd_1
Xfanout819 net821 vssd1 vssd1 vccd1 vccd1 net819 sky130_fd_sc_hd__clkbuf_2
Xfanout808 net811 vssd1 vssd1 vccd1 vccd1 net808 sky130_fd_sc_hd__clkbuf_4
XANTENNA__08897__B _03885_ vssd1 vssd1 vccd1 vccd1 sky130_fd_sc_hd__diode_2
XANTENNA__11808__S net902 vssd1 vssd1 vccd1 vccd1 sky130_fd_sc_hd__diode_2
XANTENNA__08573__A2 _03465_ vssd1 vssd1 vccd1 vccd1 sky130_fd_sc_hd__diode_2
X_08810_ cell1.SB0.route_sel\[95\] _01538_ vssd1 vssd1 vccd1 vccd1 _03842_ sky130_fd_sc_hd__nand2_1
XANTENNA__10380__A2 net315 vssd1 vssd1 vccd1 vccd1 sky130_fd_sc_hd__diode_2
X_09790_ net447 _04696_ vssd1 vssd1 vccd1 vccd1 _04796_ sky130_fd_sc_hd__nor2_1
XANTENNA__07781__B1 bus1_0\[5\] vssd1 vssd1 vccd1 vccd1 sky130_fd_sc_hd__diode_2
X_08741_ net4 net5 net6 net7 net453 cell1.CB_1.config_dataB\[16\] vssd1 vssd1 vccd1
+ vccd1 _03775_ sky130_fd_sc_hd__mux4_1
X_08672_ net31 net32 net2 net3 net462 cell1.CB_1.config_dataB\[1\] vssd1 vssd1 vccd1
+ vccd1 _03706_ sky130_fd_sc_hd__mux4_1
XANTENNA__10132__A2 _05128_ vssd1 vssd1 vccd1 vccd1 sky130_fd_sc_hd__diode_2
X_07623_ net345 _02125_ _02624_ _02620_ _02121_ vssd1 vssd1 vccd1 vccd1 _02672_ sky130_fd_sc_hd__o32a_1
XFILLER_26_29 vccd1 vssd1 vccd1 vssd1 sky130_ef_sc_hd__decap_40_12
XANTENNA__10948__A _05901_ vssd1 vssd1 vccd1 vccd1 sky130_fd_sc_hd__diode_2
Xclkbuf_leaf_18_clk clknet_4_4_0_clk vssd1 vssd1 vccd1 vccd1 clknet_leaf_18_clk sky130_fd_sc_hd__clkbuf_8
XFILLER_93_393 vssd1 vssd1 vccd1 vccd1 sky130_fd_sc_hd__fill_1
XPHY_EDGE_ROW_5_Right_5 vssd1 vssd1 vccd1 vccd1 sky130_fd_sc_hd__decap_3
X_07554_ _01650_ cell2.SB0.route_sel\[122\] cell2.SB0.route_sel\[126\] cell2.SB0.config_data_out
+ _02604_ vssd1 vssd1 vccd1 vccd1 _02605_ sky130_fd_sc_hd__o221a_1
X_07485_ cell2.SB0.route_sel\[112\] cell2.SB0.route_sel\[113\] _02531_ _02537_ vssd1
+ vssd1 vccd1 vccd1 _02538_ sky130_fd_sc_hd__a31oi_4
XTAP_TAPCELL_ROW_66_1294 vssd1 vccd1 sky130_fd_sc_hd__tapvpwrvgnd_1
XFILLER_62_791 vssd1 vssd1 vccd1 vccd1 sky130_fd_sc_hd__fill_1
X_06505_ cell0.CB_0.config_dataA\[17\] vssd1 vssd1 vccd1 vccd1 _01575_ sky130_fd_sc_hd__inv_2
X_09224_ cell2.SB0.route_sel\[8\] cell2.SB0.route_sel\[9\] _04250_ vssd1 vssd1 vccd1
+ vccd1 _04251_ sky130_fd_sc_hd__and3_1
X_06436_ cell1.SB0.route_sel\[19\] vssd1 vssd1 vccd1 vccd1 _01506_ sky130_fd_sc_hd__inv_2
XANTENNA_fanout334_A net335 vssd1 vssd1 vccd1 vccd1 sky130_fd_sc_hd__diode_2
XANTENNA__09589__B2 cell2.SB0.route_sel\[93\] vssd1 vssd1 vccd1 vccd1 sky130_fd_sc_hd__diode_2
X_09155_ cell2.SB0.route_sel\[5\] cell2.SB0.route_sel\[4\] vssd1 vssd1 vccd1 vccd1
+ _04183_ sky130_fd_sc_hd__and2_1
X_09086_ _04103_ _04104_ _04111_ _04115_ vssd1 vssd1 vccd1 vccd1 _04116_ sky130_fd_sc_hd__o211a_1
X_08106_ _01560_ _03146_ _03147_ _03131_ _03137_ vssd1 vssd1 vccd1 vccd1 _03148_ sky130_fd_sc_hd__o32a_1
XANTENNA__07695__C _02609_ vssd1 vssd1 vccd1 vccd1 sky130_fd_sc_hd__diode_2
XANTENNA__10970__X _05924_ vssd1 vssd1 vccd1 vccd1 sky130_fd_sc_hd__diode_2
X_08037_ bus2_0\[6\] bus2_0\[7\] net534 vssd1 vssd1 vccd1 vccd1 _03079_ sky130_fd_sc_hd__mux2_1
XANTENNA__08013__A1 net346 vssd1 vssd1 vccd1 vccd1 sky130_fd_sc_hd__diode_2
XFILLER_115_281 vssd1 vssd1 vccd1 vccd1 sky130_fd_sc_hd__fill_1
XFILLER_1_559 vssd1 vssd1 vccd1 vccd1 sky130_fd_sc_hd__fill_1
X_09988_ cell2.CB_1.config_dataB\[9\] _04958_ _04962_ _04986_ _04991_ vssd1 vssd1
+ vccd1 vccd1 _04992_ sky130_fd_sc_hd__a311oi_4
XFILLER_88_176 vssd1 vssd1 vccd1 vccd1 sky130_fd_sc_hd__fill_1
X_08939_ bus3_1\[6\] bus3_1\[7\] net464 vssd1 vssd1 vccd1 vccd1 _03971_ sky130_fd_sc_hd__mux2_1
XFILLER_29_221 vssd1 vssd1 vccd1 vccd1 sky130_fd_sc_hd__fill_1
XANTENNA__11019__A _05879_ vssd1 vssd1 vccd1 vccd1 sky130_fd_sc_hd__diode_2
XTAP_TAPCELL_ROW_86_1604 vssd1 vccd1 sky130_fd_sc_hd__tapvpwrvgnd_1
XANTENNA_fanout756_X net756 vssd1 vssd1 vccd1 vccd1 sky130_fd_sc_hd__diode_2
XANTENNA__09513__B2 _04532_ vssd1 vssd1 vccd1 vccd1 sky130_fd_sc_hd__diode_2
XANTENNA__09513__A1 cell3.SB0.route_sel\[69\] vssd1 vssd1 vccd1 vccd1 sky130_fd_sc_hd__diode_2
XTAP_TAPCELL_ROW_4_375 vssd1 vccd1 sky130_fd_sc_hd__tapvpwrvgnd_1
XTAP_TAPCELL_ROW_4_364 vssd1 vccd1 sky130_fd_sc_hd__tapvpwrvgnd_1
X_11950_ cell0.SB0.route_sel\[56\] cell0.SB0.route_sel\[55\] net760 vssd1 vssd1 vccd1
+ vccd1 _00387_ sky130_fd_sc_hd__mux2_1
X_10901_ _01737_ _01738_ _01739_ cell3.SB0.route_sel\[103\] _05854_ vssd1 vssd1 vccd1
+ vccd1 _05855_ sky130_fd_sc_hd__a221o_1
XFILLER_83_35 vssd1 vssd1 vccd1 vccd1 sky130_fd_sc_hd__fill_2
X_11881_ cell1.CB_0.config_dataA\[12\] net466 net882 vssd1 vssd1 vccd1 vccd1 _00318_
+ sky130_fd_sc_hd__mux2_1
XFILLER_17_449 vssd1 vssd1 vccd1 vccd1 sky130_fd_sc_hd__fill_4
X_10832_ net285 net280 cell3.LEI0.config_data\[33\] vssd1 vssd1 vccd1 vccd1 _05788_
+ sky130_fd_sc_hd__mux2_1
X_13620_ clknet_leaf_86_clk _00592_ net686 vssd1 vssd1 vccd1 vccd1 cell1.LEI0.config_data\[41\]
+ sky130_fd_sc_hd__dfrtp_1
XFILLER_32_419 vssd1 vssd1 vccd1 vccd1 sky130_fd_sc_hd__fill_1
X_10763_ net286 net279 net298 net291 cell3.LEI0.config_data\[9\] cell3.LEI0.config_data\[10\]
+ vssd1 vssd1 vccd1 vccd1 _05719_ sky130_fd_sc_hd__mux4_1
X_13551_ clknet_leaf_90_clk _00523_ net699 vssd1 vssd1 vccd1 vccd1 cell1.LE_0B.config_data\[16\]
+ sky130_fd_sc_hd__dfrtp_1
XANTENNA__07827__A1 bus2_0\[13\] vssd1 vssd1 vccd1 vccd1 sky130_fd_sc_hd__diode_2
XTAP_TAPCELL_ROW_43_959 vssd1 vccd1 sky130_fd_sc_hd__tapvpwrvgnd_1
XTAP_TAPCELL_ROW_43_948 vssd1 vccd1 sky130_fd_sc_hd__tapvpwrvgnd_1
XFILLER_16_73 vssd1 vssd1 vccd1 vccd1 sky130_fd_sc_hd__fill_2
X_12502_ net1439 cell2.LEI0.config_data\[15\] net843 vssd1 vssd1 vccd1 vccd1 _00931_
+ sky130_fd_sc_hd__mux2_1
XANTENNA__09029__A0 bus3_1\[6\] vssd1 vssd1 vccd1 vccd1 sky130_fd_sc_hd__diode_2
XANTENNA__08047__B _02301_ vssd1 vssd1 vccd1 vccd1 sky130_fd_sc_hd__diode_2
XFILLER_9_615 vssd1 vssd1 vccd1 vccd1 sky130_fd_sc_hd__fill_1
XFILLER_12_132 vssd1 vssd1 vccd1 vccd1 sky130_fd_sc_hd__fill_4
XFILLER_13_677 vssd1 vssd1 vccd1 vccd1 sky130_fd_sc_hd__fill_2
XTAP_TAPCELL_ROW_23_650 vssd1 vccd1 sky130_fd_sc_hd__tapvpwrvgnd_1
XFILLER_139_841 vssd1 vssd1 vccd1 vccd1 sky130_fd_sc_hd__fill_4
X_10694_ _05540_ _05543_ net391 vssd1 vssd1 vccd1 vccd1 _05652_ sky130_fd_sc_hd__mux2_1
X_13482_ clknet_leaf_2_clk _00454_ net570 vssd1 vssd1 vccd1 vccd1 cell0.SB0.route_sel\[123\]
+ sky130_fd_sc_hd__dfstp_1
XANTENNA_input97_A SBwest_in[0] vssd1 vssd1 vccd1 vccd1 sky130_fd_sc_hd__diode_2
X_12433_ cell2.LE_1A.config_data\[16\] net1391 net849 vssd1 vssd1 vccd1 vccd1 _00865_
+ sky130_fd_sc_hd__mux2_1
XFILLER_32_61 vssd1 vssd1 vccd1 vccd1 sky130_fd_sc_hd__fill_2
XFILLER_32_83 vssd1 vssd1 vccd1 vccd1 sky130_fd_sc_hd__fill_1
XTAP_TAPCELL_ROW_97_1766 vssd1 vccd1 sky130_fd_sc_hd__tapvpwrvgnd_1
X_12364_ cell1.SB0.route_sel\[102\] cell1.SB0.route_sel\[101\] net869 vssd1 vssd1
+ vccd1 vccd1 _00797_ sky130_fd_sc_hd__mux2_1
X_14103_ clknet_leaf_50_clk _01075_ net711 vssd1 vssd1 vccd1 vccd1 cell3.SB0.route_sel\[111\]
+ sky130_fd_sc_hd__dfstp_1
X_11315_ _01826_ _04592_ _06222_ vssd1 vssd1 vccd1 vccd1 _06223_ sky130_fd_sc_hd__a21oi_1
XFILLER_5_843 vssd1 vssd1 vccd1 vccd1 sky130_fd_sc_hd__fill_1
XANTENNA_input52_X net52 vssd1 vssd1 vccd1 vccd1 sky130_fd_sc_hd__diode_2
XANTENNA__11139__A1 _05890_ vssd1 vssd1 vccd1 vccd1 sky130_fd_sc_hd__diode_2
X_14034_ clknet_leaf_49_clk _01006_ net705 vssd1 vssd1 vccd1 vccd1 cell3.SB0.route_sel\[42\]
+ sky130_fd_sc_hd__dfstp_1
X_12295_ cell1.SB0.route_sel\[33\] cell1.SB0.route_sel\[32\] net859 vssd1 vssd1 vccd1
+ vccd1 _00728_ sky130_fd_sc_hd__mux2_1
XANTENNA_output253_A net253 vssd1 vssd1 vccd1 vccd1 sky130_fd_sc_hd__diode_2
X_11246_ net696 cell1.LE_1A.reset_mode vssd1 vssd1 vccd1 vccd1 _11246_/X sky130_fd_sc_hd__xor2_2
XFILLER_4_386 vssd1 vssd1 vccd1 vccd1 sky130_fd_sc_hd__fill_8
X_11177_ net40 net41 net42 net43 cell3.CB_0.config_dataB\[10\] cell3.CB_0.config_dataB\[11\]
+ vssd1 vssd1 vccd1 vccd1 _06129_ sky130_fd_sc_hd__mux4_1
XFILLER_79_154 vssd1 vssd1 vccd1 vccd1 sky130_fd_sc_hd__fill_1
XTAP_TAPCELL_ROW_128_2232 vssd1 vccd1 sky130_fd_sc_hd__tapvpwrvgnd_1
XTAP_TAPCELL_ROW_128_2221 vssd1 vccd1 sky130_fd_sc_hd__tapvpwrvgnd_1
X_10128_ cell2.SB0.route_sel\[51\] cell2.SB0.route_sel\[50\] vssd1 vssd1 vccd1 vccd1
+ _05129_ sky130_fd_sc_hd__or2_1
XFILLER_0_570 vssd1 vssd1 vccd1 vccd1 sky130_fd_sc_hd__fill_2
X_10059_ cell2.CB_1.config_dataB\[18\] _01751_ cell2.CB_1.config_dataB\[19\] _05035_
+ vssd1 vssd1 vccd1 vccd1 _05063_ sky130_fd_sc_hd__and4b_1
XTAP_TAPCELL_ROW_50_1062 vssd1 vccd1 sky130_fd_sc_hd__tapvpwrvgnd_1
XTAP_TAPCELL_ROW_50_1051 vssd1 vccd1 sky130_fd_sc_hd__tapvpwrvgnd_1
XTAP_TAPCELL_ROW_141_2421 vssd1 vccd1 sky130_fd_sc_hd__tapvpwrvgnd_1
XFILLER_94_179 vssd1 vssd1 vccd1 vccd1 sky130_fd_sc_hd__fill_1
XFILLER_63_511 vssd1 vssd1 vccd1 vccd1 sky130_fd_sc_hd__fill_1
XANTENNA__10665__A3 net11 vssd1 vssd1 vccd1 vccd1 sky130_fd_sc_hd__diode_2
XFILLER_75_393 vssd1 vssd1 vccd1 vccd1 sky130_fd_sc_hd__fill_1
XANTENNA__09268__B1 _04293_ vssd1 vssd1 vccd1 vccd1 sky130_fd_sc_hd__diode_2
X_13818_ clknet_leaf_104_clk _00790_ net663 vssd1 vssd1 vccd1 vccd1 cell1.SB0.route_sel\[95\]
+ sky130_fd_sc_hd__dfstp_1
XTAP_TAPCELL_ROW_106_1895 vssd1 vccd1 sky130_fd_sc_hd__tapvpwrvgnd_1
XFILLER_73_90 vssd1 vssd1 vccd1 vccd1 sky130_fd_sc_hd__fill_1
X_13749_ clknet_leaf_107_clk _00721_ net652 vssd1 vssd1 vccd1 vccd1 cell1.SB0.route_sel\[26\]
+ sky130_fd_sc_hd__dfstp_1
X_07270_ _02011_ _02323_ net349 vssd1 vssd1 vccd1 vccd1 _02328_ sky130_fd_sc_hd__and3b_1
XTAP_TAPCELL_ROW_139_2394 vssd1 vccd1 sky130_fd_sc_hd__tapvpwrvgnd_1
XFILLER_8_681 vccd1 vssd1 vccd1 vssd1 sky130_ef_sc_hd__decap_40_12
XANTENNA__08243__A1 _02846_ vssd1 vssd1 vccd1 vccd1 sky130_fd_sc_hd__diode_2
XANTENNA__08243__B2 _02807_ vssd1 vssd1 vccd1 vccd1 sky130_fd_sc_hd__diode_2
Xhold103 _01371_ vssd1 vssd1 vccd1 vccd1 net1062 sky130_fd_sc_hd__dlygate4sd3_1
Xhold125 cell0.LE_0A.config_data\[3\] vssd1 vssd1 vccd1 vccd1 net1084 sky130_fd_sc_hd__dlygate4sd3_1
Xhold114 _00135_ vssd1 vssd1 vccd1 vccd1 net1073 sky130_fd_sc_hd__dlygate4sd3_1
Xhold147 _00872_ vssd1 vssd1 vccd1 vccd1 net1106 sky130_fd_sc_hd__dlygate4sd3_1
Xhold136 cell2.LEI0.config_data\[32\] vssd1 vssd1 vccd1 vccd1 net1095 sky130_fd_sc_hd__dlygate4sd3_1
X_09911_ cell2.LE_1A.config_data\[11\] cell2.LE_1A.config_data\[10\] _04831_ vssd1
+ vssd1 vccd1 vccd1 _04917_ sky130_fd_sc_hd__mux2_1
Xhold158 cell0.LE_0A.config_data\[0\] vssd1 vssd1 vccd1 vccd1 net1117 sky130_fd_sc_hd__dlygate4sd3_1
Xclkbuf_leaf_7_clk clknet_4_1_0_clk vssd1 vssd1 vccd1 vccd1 clknet_leaf_7_clk sky130_fd_sc_hd__clkbuf_8
Xfanout605 net606 vssd1 vssd1 vccd1 vccd1 net605 sky130_fd_sc_hd__buf_2
Xhold169 cell0.LE_0A.config_data\[8\] vssd1 vssd1 vccd1 vccd1 net1128 sky130_fd_sc_hd__dlygate4sd3_1
Xfanout649 net650 vssd1 vssd1 vccd1 vccd1 net649 sky130_fd_sc_hd__buf_2
Xfanout638 net640 vssd1 vssd1 vccd1 vccd1 net638 sky130_fd_sc_hd__clkbuf_4
XFILLER_113_763 vssd1 vssd1 vccd1 vccd1 sky130_fd_sc_hd__fill_1
Xfanout627 net628 vssd1 vssd1 vccd1 vccd1 net627 sky130_fd_sc_hd__clkbuf_4
Xfanout616 net623 vssd1 vssd1 vccd1 vccd1 net616 sky130_fd_sc_hd__clkbuf_2
X_09842_ net441 _04348_ vssd1 vssd1 vccd1 vccd1 _04848_ sky130_fd_sc_hd__nand2_1
X_09773_ _04773_ _04776_ _04778_ cell2.CB_1.config_dataA\[7\] vssd1 vssd1 vccd1 vccd1
+ _04779_ sky130_fd_sc_hd__o22a_1
XANTENNA__07754__B1 bus2_0\[4\] vssd1 vssd1 vccd1 vccd1 sky130_fd_sc_hd__diode_2
XANTENNA_fanout284_A cell3.CB_0.le_outA vssd1 vssd1 vccd1 vccd1 sky130_fd_sc_hd__diode_2
X_06985_ cell1.CB_1.config_dataA\[22\] cell1.CB_1.config_dataA\[23\] vssd1 vssd1 vccd1
+ vccd1 _02051_ sky130_fd_sc_hd__nand2b_2
X_08724_ net455 _03486_ net454 vssd1 vssd1 vccd1 vccd1 _03758_ sky130_fd_sc_hd__o21ai_1
XFILLER_37_39 vccd1 vssd1 vccd1 vssd1 sky130_ef_sc_hd__decap_40_12
XANTENNA_clkbuf_4_7_0_clk_X clknet_4_7_0_clk vssd1 vssd1 vccd1 vccd1 sky130_fd_sc_hd__diode_2
XTAP_TAPCELL_ROW_68_1323 vssd1 vccd1 sky130_fd_sc_hd__tapvpwrvgnd_1
XTAP_TAPCELL_ROW_1_323 vssd1 vccd1 sky130_fd_sc_hd__tapvpwrvgnd_1
XTAP_TAPCELL_ROW_68_1334 vssd1 vccd1 sky130_fd_sc_hd__tapvpwrvgnd_1
X_08655_ net31 net32 net2 net3 net459 net457 vssd1 vssd1 vccd1 vccd1 _03689_ sky130_fd_sc_hd__mux4_1
XANTENNA_fanout549_A net550 vssd1 vssd1 vccd1 vccd1 sky130_fd_sc_hd__diode_2
X_08586_ _03618_ _03621_ vssd1 vssd1 vccd1 vccd1 _03622_ sky130_fd_sc_hd__nor2_1
X_07606_ cell1.SB0.route_sel\[0\] cell1.SB0.route_sel\[1\] vssd1 vssd1 vccd1 vccd1
+ _02656_ sky130_fd_sc_hd__nor2_1
XTAP_TAPCELL_ROW_81_1523 vssd1 vccd1 sky130_fd_sc_hd__tapvpwrvgnd_1
X_07537_ _02554_ _02586_ _02587_ vssd1 vssd1 vccd1 vccd1 _02588_ sky130_fd_sc_hd__a21oi_1
XANTENNA_fanout716_A net724 vssd1 vssd1 vccd1 vccd1 sky130_fd_sc_hd__diode_2
XTAP_TAPCELL_ROW_40_907 vssd1 vccd1 sky130_fd_sc_hd__tapvpwrvgnd_1
XANTENNA_fanout337_X net337 vssd1 vssd1 vccd1 vccd1 sky130_fd_sc_hd__diode_2
X_07468_ bus3_2\[14\] _02519_ _02520_ vssd1 vssd1 vccd1 vccd1 _02521_ sky130_fd_sc_hd__a21o_1
XFILLER_10_636 vssd1 vssd1 vccd1 vccd1 sky130_fd_sc_hd__fill_8
XFILLER_22_474 vssd1 vssd1 vccd1 vccd1 sky130_fd_sc_hd__fill_2
XFILLER_136_811 vssd1 vssd1 vccd1 vccd1 sky130_fd_sc_hd__fill_1
X_09207_ net295 _04231_ vssd1 vssd1 vccd1 vccd1 _04234_ sky130_fd_sc_hd__nand2_1
X_06419_ cell0.SB0.route_sel\[122\] vssd1 vssd1 vccd1 vccd1 _01489_ sky130_fd_sc_hd__inv_2
X_07399_ cell0.SB0.route_sel\[109\] _01480_ cell0.SB0.route_sel\[107\] cell0.SB0.route_sel\[106\]
+ _02453_ vssd1 vssd1 vccd1 vccd1 _02454_ sky130_fd_sc_hd__o221a_1
XFILLER_10_669 vccd1 vssd1 vccd1 vssd1 sky130_ef_sc_hd__decap_40_12
X_09138_ cell1.LE_0B.config_data\[11\] cell1.LE_0B.config_data\[10\] _04086_ vssd1
+ vssd1 vccd1 vccd1 _04168_ sky130_fd_sc_hd__mux2_1
XFILLER_135_376 vssd1 vssd1 vccd1 vccd1 sky130_fd_sc_hd__fill_1
XFILLER_118_53 vssd1 vssd1 vccd1 vccd1 sky130_fd_sc_hd__fill_8
X_11100_ cell3.CB_0.config_dataB\[2\] _06051_ cell3.CB_0.config_dataB\[3\] vssd1 vssd1
+ vccd1 vccd1 _06052_ sky130_fd_sc_hd__a21bo_1
XANTENNA__10592__A2 _05548_ vssd1 vssd1 vccd1 vccd1 sky130_fd_sc_hd__diode_2
XTAP_TAPCELL_ROW_79_1496 vssd1 vccd1 sky130_fd_sc_hd__tapvpwrvgnd_1
X_09069_ _03830_ _04090_ _04091_ _03826_ _01671_ vssd1 vssd1 vccd1 vccd1 _04099_ sky130_fd_sc_hd__a221o_1
XFILLER_2_813 vccd1 vssd1 vccd1 vssd1 sky130_ef_sc_hd__decap_40_12
X_12080_ net1025 cell1.LE_0B.config_data\[7\] net938 vssd1 vssd1 vccd1 vccd1 _00515_
+ sky130_fd_sc_hd__mux2_1
XTAP_TAPCELL_ROW_9_445 vssd1 vccd1 sky130_fd_sc_hd__tapvpwrvgnd_1
X_11031_ _01810_ _05980_ _05981_ _05984_ vssd1 vssd1 vccd1 vccd1 _05985_ sky130_fd_sc_hd__o2bb2a_1
XTAP_TAPCELL_ROW_92_1685 vssd1 vccd1 sky130_fd_sc_hd__tapvpwrvgnd_1
XFILLER_134_41 vccd1 vssd1 vccd1 vssd1 sky130_ef_sc_hd__decap_40_12
XFILLER_131_571 vssd1 vssd1 vccd1 vccd1 sky130_fd_sc_hd__fill_1
XFILLER_76_124 vccd1 vssd1 vccd1 vssd1 sky130_ef_sc_hd__decap_40_12
XFILLER_1_389 vssd1 vssd1 vccd1 vccd1 sky130_fd_sc_hd__fill_2
XFILLER_134_85 vssd1 vssd1 vccd1 vccd1 sky130_fd_sc_hd__fill_1
XFILLER_92_606 vssd1 vssd1 vccd1 vccd1 sky130_fd_sc_hd__fill_4
XFILLER_76_146 vssd1 vssd1 vccd1 vccd1 sky130_fd_sc_hd__fill_2
X_12982_ net1499 cell3.LEI0.config_data\[2\] net945 vssd1 vssd1 vccd1 vccd1 _01410_
+ sky130_fd_sc_hd__mux2_1
XANTENNA_input12_A CBeast_in[1] vssd1 vssd1 vccd1 vccd1 sky130_fd_sc_hd__diode_2
XFILLER_57_382 vssd1 vssd1 vccd1 vccd1 sky130_fd_sc_hd__fill_1
X_11933_ cell0.SB0.route_sel\[39\] cell0.SB0.route_sel\[38\] net757 vssd1 vssd1 vccd1
+ vccd1 _00370_ sky130_fd_sc_hd__mux2_1
XTAP_TAPCELL_ROW_28_731 vssd1 vccd1 sky130_fd_sc_hd__tapvpwrvgnd_1
XTAP_TAPCELL_ROW_123_2151 vssd1 vccd1 sky130_fd_sc_hd__tapvpwrvgnd_1
X_11864_ cell1.CB_0.config_dataB\[20\] cell1.CB_0.config_dataB\[19\] net892 vssd1
+ vssd1 vccd1 vccd1 _00301_ sky130_fd_sc_hd__mux2_1
XFILLER_17_279 vssd1 vssd1 vccd1 vccd1 sky130_fd_sc_hd__fill_1
X_10815_ _05770_ vssd1 vssd1 vccd1 vccd1 _05771_ sky130_fd_sc_hd__inv_2
X_13603_ clknet_leaf_95_clk _00575_ net686 vssd1 vssd1 vccd1 vccd1 cell1.LEI0.config_data\[24\]
+ sky130_fd_sc_hd__dfrtp_1
XANTENNA__10804__A0 _05478_ vssd1 vssd1 vccd1 vccd1 sky130_fd_sc_hd__diode_2
X_11795_ net1475 net1374 net786 vssd1 vssd1 vccd1 vccd1 _00232_ sky130_fd_sc_hd__mux2_1
XFILLER_9_401 vssd1 vssd1 vccd1 vccd1 sky130_fd_sc_hd__fill_2
X_10746_ net370 _05699_ _05700_ _05701_ vssd1 vssd1 vccd1 vccd1 _05702_ sky130_fd_sc_hd__a211o_1
X_13534_ clknet_1_0__leaf_cell1.LE_1A.sel_clk _00506_ net753 vssd1 vssd1 vccd1 vccd1
+ cell1.LE_1A.dff0_out sky130_fd_sc_hd__dfrtp_1
X_10677_ cell3.LEI0.config_data\[31\] _05632_ _05634_ cell3.LEI0.config_data\[32\]
+ vssd1 vssd1 vccd1 vccd1 _05635_ sky130_fd_sc_hd__a211o_1
X_13465_ clknet_leaf_3_clk _00437_ net565 vssd1 vssd1 vccd1 vccd1 cell0.SB0.route_sel\[106\]
+ sky130_fd_sc_hd__dfstp_1
X_12416_ net973 net549 _06381_ vssd1 vssd1 vccd1 vccd1 _00848_ sky130_fd_sc_hd__a21bo_1
XFILLER_9_489 vssd1 vssd1 vccd1 vccd1 sky130_fd_sc_hd__fill_2
XANTENNA__09973__A1 bus3_2\[14\] vssd1 vssd1 vccd1 vccd1 sky130_fd_sc_hd__diode_2
XANTENNA__10032__A1 bus3_2\[9\] vssd1 vssd1 vccd1 vccd1 sky130_fd_sc_hd__diode_2
Xoutput208 net208 vssd1 vssd1 vccd1 vccd1 SBsouth_out[19] sky130_fd_sc_hd__buf_2
X_13396_ clknet_leaf_0_clk _00368_ net554 vssd1 vssd1 vccd1 vccd1 cell0.SB0.route_sel\[37\]
+ sky130_fd_sc_hd__dfstp_1
XFILLER_126_365 vssd1 vssd1 vccd1 vccd1 sky130_fd_sc_hd__fill_1
XANTENNA__07984__B1 net351 vssd1 vssd1 vccd1 vccd1 sky130_fd_sc_hd__diode_2
XFILLER_5_673 vccd1 vssd1 vccd1 vssd1 sky130_ef_sc_hd__decap_40_12
Xoutput219 net219 vssd1 vssd1 vccd1 vccd1 SBsouth_out[29] sky130_fd_sc_hd__buf_2
X_12347_ cell1.SB0.route_sel\[85\] cell1.SB0.route_sel\[84\] net868 vssd1 vssd1 vccd1
+ vccd1 _00780_ sky130_fd_sc_hd__mux2_1
XFILLER_142_847 vssd1 vssd1 vccd1 vccd1 sky130_fd_sc_hd__fill_1
X_12278_ cell1.SB0.route_sel\[16\] cell1.SB0.route_sel\[15\] net864 vssd1 vssd1 vccd1
+ vccd1 _00711_ sky130_fd_sc_hd__mux2_1
X_11229_ _06179_ _06180_ _06107_ vssd1 vssd1 vccd1 vccd1 _06181_ sky130_fd_sc_hd__mux2_1
X_14017_ clknet_leaf_80_clk _00989_ net707 vssd1 vssd1 vccd1 vccd1 cell3.SB0.route_sel\[25\]
+ sky130_fd_sc_hd__dfstp_1
XFILLER_4_65 vccd1 vssd1 vccd1 vssd1 sky130_ef_sc_hd__decap_40_12
XFILLER_95_422 vssd1 vssd1 vccd1 vccd1 sky130_fd_sc_hd__fill_2
XFILLER_110_799 vssd1 vssd1 vccd1 vccd1 sky130_fd_sc_hd__fill_1
XTAP_TAPCELL_ROW_108_1924 vssd1 vccd1 sky130_fd_sc_hd__tapvpwrvgnd_1
X_06770_ net29 _01839_ vssd1 vssd1 vccd1 vccd1 _01840_ sky130_fd_sc_hd__or2_1
XANTENNA__10099__A1 _02106_ vssd1 vssd1 vccd1 vccd1 sky130_fd_sc_hd__diode_2
XTAP_TAPCELL_ROW_108_1935 vssd1 vccd1 sky130_fd_sc_hd__tapvpwrvgnd_1
XFILLER_82_138 vssd1 vssd1 vccd1 vccd1 sky130_fd_sc_hd__fill_2
XANTENNA__07424__X _02478_ vssd1 vssd1 vccd1 vccd1 sky130_fd_sc_hd__diode_2
XFILLER_51_503 vssd1 vssd1 vccd1 vccd1 sky130_fd_sc_hd__fill_1
XFILLER_23_205 vssd1 vssd1 vccd1 vccd1 sky130_fd_sc_hd__fill_1
X_08440_ cell1.SB0.route_sel\[69\] cell1.SB0.route_sel\[68\] _01527_ cell1.SB0.route_sel\[71\]
+ _03475_ vssd1 vssd1 vccd1 vccd1 _03476_ sky130_fd_sc_hd__o221a_1
XFILLER_63_374 vssd1 vssd1 vccd1 vccd1 sky130_fd_sc_hd__fill_1
XTAP_TAPCELL_ROW_63_1253 vssd1 vccd1 sky130_fd_sc_hd__tapvpwrvgnd_1
X_08371_ net504 _02719_ _03408_ net502 vssd1 vssd1 vccd1 vccd1 _03409_ sky130_fd_sc_hd__o211a_1
XFILLER_32_761 vssd1 vssd1 vccd1 vccd1 sky130_fd_sc_hd__fill_1
X_07322_ cell2.CB_1.config_dataB\[23\] cell2.CB_1.config_dataB\[22\] vssd1 vssd1 vccd1
+ vccd1 _02379_ sky130_fd_sc_hd__and2_1
X_07253_ net301 _01993_ _02084_ _02311_ vssd1 vssd1 vccd1 vccd1 _02312_ sky130_fd_sc_hd__o31ai_2
X_07184_ net314 _02242_ vssd1 vssd1 vccd1 vccd1 _02245_ sky130_fd_sc_hd__and2_1
XANTENNA__08216__A1 bus1_0\[3\] vssd1 vssd1 vccd1 vccd1 sky130_fd_sc_hd__diode_2
XFILLER_2_109 vccd1 vssd1 vccd1 vssd1 sky130_ef_sc_hd__decap_40_12
XFILLER_132_335 vssd1 vssd1 vccd1 vccd1 sky130_fd_sc_hd__fill_1
XANTENNA__10680__B _05635_ vssd1 vssd1 vccd1 vccd1 sky130_fd_sc_hd__diode_2
Xfanout413 cell2.CB_0.config_dataA\[15\] vssd1 vssd1 vccd1 vccd1 net413 sky130_fd_sc_hd__clkbuf_2
Xfanout402 cell2.CB_1.config_dataB\[11\] vssd1 vssd1 vccd1 vccd1 net402 sky130_fd_sc_hd__buf_2
XTAP_TAPCELL_ROW_6_404 vssd1 vccd1 sky130_fd_sc_hd__tapvpwrvgnd_1
Xfanout435 net436 vssd1 vssd1 vccd1 vccd1 net435 sky130_fd_sc_hd__clkbuf_2
Xfanout424 cell2.CB_0.config_dataB\[15\] vssd1 vssd1 vccd1 vccd1 net424 sky130_fd_sc_hd__buf_2
X_09825_ _04824_ _04829_ _04830_ vssd1 vssd1 vccd1 vccd1 _04831_ sky130_fd_sc_hd__and3_2
Xfanout446 cell2.CB_1.config_dataA\[1\] vssd1 vssd1 vccd1 vccd1 net446 sky130_fd_sc_hd__buf_2
XANTENNA_input4_A CBeast_in[12] vssd1 vssd1 vccd1 vccd1 sky130_fd_sc_hd__diode_2
XFILLER_98_282 vccd1 vssd1 vccd1 vssd1 sky130_ef_sc_hd__decap_40_12
Xfanout457 cell1.CB_1.config_dataB\[6\] vssd1 vssd1 vccd1 vccd1 net457 sky130_fd_sc_hd__clkbuf_2
XANTENNA__07047__A net357 vssd1 vssd1 vccd1 vccd1 sky130_fd_sc_hd__diode_2
Xfanout479 cell1.CB_0.config_dataB\[10\] vssd1 vssd1 vccd1 vccd1 net479 sky130_fd_sc_hd__buf_2
Xfanout468 cell1.CB_0.config_dataA\[10\] vssd1 vssd1 vccd1 vccd1 net468 sky130_fd_sc_hd__clkbuf_2
XFILLER_104_33 vssd1 vssd1 vccd1 vccd1 sky130_fd_sc_hd__fill_2
X_09756_ bus3_2\[12\] bus3_2\[14\] bus3_2\[13\] bus3_2\[15\] net443 net444 vssd1 vssd1
+ vccd1 vccd1 _04762_ sky130_fd_sc_hd__mux4_1
XFILLER_86_477 vssd1 vssd1 vccd1 vccd1 sky130_fd_sc_hd__fill_4
X_06968_ net345 _02031_ _02032_ vssd1 vssd1 vccd1 vccd1 _02034_ sky130_fd_sc_hd__or3_1
X_09687_ net24 _04700_ vssd1 vssd1 vccd1 vccd1 _04701_ sky130_fd_sc_hd__or2_1
XFILLER_39_393 vssd1 vssd1 vccd1 vccd1 sky130_fd_sc_hd__fill_1
X_08707_ _03739_ _03740_ vssd1 vssd1 vccd1 vccd1 _03741_ sky130_fd_sc_hd__and2b_1
XANTENNA_fanout833_A net837 vssd1 vssd1 vccd1 vccd1 sky130_fd_sc_hd__diode_2
X_06899_ _01966_ net333 _01965_ vssd1 vssd1 vccd1 vccd1 _01967_ sky130_fd_sc_hd__mux2_1
X_08638_ _03537_ _03670_ _03671_ _03540_ _01656_ vssd1 vssd1 vccd1 vccd1 _03672_ sky130_fd_sc_hd__a221o_1
XANTENNA__11039__B1 _05992_ vssd1 vssd1 vccd1 vccd1 sky130_fd_sc_hd__diode_2
XFILLER_120_21 vssd1 vssd1 vccd1 vccd1 sky130_fd_sc_hd__fill_4
XFILLER_82_694 vssd1 vssd1 vccd1 vccd1 sky130_fd_sc_hd__fill_2
XFILLER_82_683 vssd1 vssd1 vccd1 vccd1 sky130_fd_sc_hd__fill_1
XFILLER_27_599 vssd1 vssd1 vccd1 vccd1 sky130_fd_sc_hd__fill_1
XANTENNA_fanout621_X net621 vssd1 vssd1 vccd1 vccd1 sky130_fd_sc_hd__diode_2
X_08569_ net4 net5 net6 net7 net492 net490 vssd1 vssd1 vccd1 vccd1 _03605_ sky130_fd_sc_hd__mux4_1
X_10600_ net286 net279 net297 net290 cell3.LEI0.config_data\[18\] cell3.LEI0.config_data\[19\]
+ vssd1 vssd1 vccd1 vccd1 _05558_ sky130_fd_sc_hd__mux4_1
XANTENNA__09652__B1 _04666_ vssd1 vssd1 vccd1 vccd1 sky130_fd_sc_hd__diode_2
X_11580_ net544 net546 net788 vssd1 vssd1 vccd1 vccd1 _00021_ sky130_fd_sc_hd__mux2_1
X_10531_ _04419_ _05488_ vssd1 vssd1 vccd1 vccd1 _05489_ sky130_fd_sc_hd__and2_2
X_13250_ clknet_leaf_122_clk _00222_ net587 vssd1 vssd1 vccd1 vccd1 cell0.LEI0.config_data\[35\]
+ sky130_fd_sc_hd__dfrtp_1
XANTENNA__08207__A1 bus1_0\[5\] vssd1 vssd1 vccd1 vccd1 sky130_fd_sc_hd__diode_2
XFILLER_129_63 vssd1 vssd1 vccd1 vccd1 sky130_fd_sc_hd__fill_1
XANTENNA__11211__A0 net53 vssd1 vssd1 vccd1 vccd1 sky130_fd_sc_hd__diode_2
XANTENNA__09404__B1 _04425_ vssd1 vssd1 vccd1 vccd1 sky130_fd_sc_hd__diode_2
X_12201_ cell2.CB_1.config_dataA\[14\] cell2.CB_1.config_dataA\[13\] net913 vssd1
+ vssd1 vccd1 vccd1 _00634_ sky130_fd_sc_hd__mux2_1
XTAP_TAPCELL_ROW_94_1714 vssd1 vccd1 sky130_fd_sc_hd__tapvpwrvgnd_1
XFILLER_89_23 vccd1 vssd1 vccd1 vssd1 sky130_ef_sc_hd__decap_40_12
X_10462_ _05448_ _04631_ vssd1 vssd1 vccd1 vccd1 bus3_2\[11\] sky130_fd_sc_hd__and2b_2
XANTENNA__08207__B2 bus1_0\[4\] vssd1 vssd1 vccd1 vccd1 sky130_fd_sc_hd__diode_2
X_10393_ cell2.CB_0.config_dataB\[17\] _05390_ _05391_ _05388_ vssd1 vssd1 vccd1 vccd1
+ _05392_ sky130_fd_sc_hd__o31a_1
XANTENNA__09955__A1 bus3_2\[2\] vssd1 vssd1 vccd1 vccd1 sky130_fd_sc_hd__diode_2
XTAP_TAPCELL_ROW_94_1725 vssd1 vccd1 sky130_fd_sc_hd__tapvpwrvgnd_1
X_13181_ clknet_leaf_14_clk _00153_ net631 vssd1 vssd1 vccd1 vccd1 cell0.LE_0B.config_data\[10\]
+ sky130_fd_sc_hd__dfrtp_1
XANTENNA__07966__A0 net344 vssd1 vssd1 vccd1 vccd1 sky130_fd_sc_hd__diode_2
X_12132_ net1035 cell1.LEI0.config_data\[13\] net895 vssd1 vssd1 vccd1 vccd1 _00565_
+ sky130_fd_sc_hd__mux2_1
XFILLER_2_643 vssd1 vssd1 vccd1 vccd1 sky130_fd_sc_hd__fill_1
X_12063_ net1007 net991 net888 vssd1 vssd1 vccd1 vccd1 _00499_ sky130_fd_sc_hd__mux2_1
X_11014_ net49 net50 net51 net52 net375 net374 vssd1 vssd1 vccd1 vccd1 _05968_ sky130_fd_sc_hd__mux4_1
XANTENNA__08060__B _02897_ vssd1 vssd1 vccd1 vccd1 sky130_fd_sc_hd__diode_2
XANTENNA__06796__A cell0.CB_0.config_dataB\[24\] vssd1 vssd1 vccd1 vccd1 sky130_fd_sc_hd__diode_2
XANTENNA__08930__A2 _03841_ vssd1 vssd1 vccd1 vccd1 sky130_fd_sc_hd__diode_2
XANTENNA_input15_X net15 vssd1 vssd1 vccd1 vccd1 sky130_fd_sc_hd__diode_2
X_12965_ net1212 cell3.LE_0A.config_data\[7\] net853 vssd1 vssd1 vccd1 vccd1 _01393_
+ sky130_fd_sc_hd__mux2_1
XANTENNA_output216_A net216 vssd1 vssd1 vccd1 vccd1 sky130_fd_sc_hd__diode_2
X_11916_ cell0.SB0.route_sel\[22\] cell0.SB0.route_sel\[21\] net763 vssd1 vssd1 vccd1
+ vccd1 _00353_ sky130_fd_sc_hd__mux2_1
X_12896_ net367 cell3.CB_1.config_dataB\[9\] net943 vssd1 vssd1 vccd1 vccd1 _01325_
+ sky130_fd_sc_hd__mux2_1
XTAP_TAPCELL_ROW_103_1854 vssd1 vccd1 sky130_fd_sc_hd__tapvpwrvgnd_1
X_11847_ cell1.CB_0.config_dataB\[3\] cell1.CB_0.config_dataB\[2\] net897 vssd1 vssd1
+ vccd1 vccd1 _00284_ sky130_fd_sc_hd__mux2_1
X_11778_ net1417 cell0.LEI0.config_data\[27\] net793 vssd1 vssd1 vccd1 vccd1 _00215_
+ sky130_fd_sc_hd__mux2_1
XANTENNA__08446__A1 net32 vssd1 vssd1 vccd1 vccd1 sky130_fd_sc_hd__diode_2
X_10729_ _05673_ _05678_ _05686_ vssd1 vssd1 vccd1 vccd1 _05687_ sky130_fd_sc_hd__a21oi_1
X_13517_ clknet_leaf_100_clk _00489_ net680 vssd1 vssd1 vccd1 vccd1 cell1.LE_1A.config_data\[4\]
+ sky130_fd_sc_hd__dfrtp_1
XANTENNA__07420__A net361 vssd1 vssd1 vccd1 vccd1 sky130_fd_sc_hd__diode_2
XTAP_TAPCELL_ROW_136_2353 vssd1 vccd1 sky130_fd_sc_hd__tapvpwrvgnd_1
XTAP_TAPCELL_ROW_136_2342 vssd1 vccd1 sky130_fd_sc_hd__tapvpwrvgnd_1
XANTENNA__08235__B _02277_ vssd1 vssd1 vccd1 vccd1 sky130_fd_sc_hd__diode_2
Xclkload12 clknet_4_13_0_clk vssd1 vssd1 vccd1 vccd1 clkload12/Y sky130_fd_sc_hd__inv_6
Xclkload23 clknet_leaf_4_clk vssd1 vssd1 vccd1 vccd1 clkload23/Y sky130_fd_sc_hd__clkinv_4
X_13448_ clknet_leaf_123_clk _00420_ net585 vssd1 vssd1 vccd1 vccd1 cell0.SB0.route_sel\[89\]
+ sky130_fd_sc_hd__dfstp_1
XTAP_TAPCELL_ROW_11_472 vssd1 vccd1 sky130_fd_sc_hd__tapvpwrvgnd_1
Xclkload34 clknet_leaf_129_clk vssd1 vssd1 vccd1 vccd1 clkload34/Y sky130_fd_sc_hd__inv_4
Xclkload67 clknet_leaf_38_clk vssd1 vssd1 vccd1 vccd1 clkload67/Y sky130_fd_sc_hd__inv_8
XANTENNA__09946__B2 _04555_ vssd1 vssd1 vccd1 vccd1 sky130_fd_sc_hd__diode_2
Xclkload56 clknet_leaf_16_clk vssd1 vssd1 vccd1 vccd1 clkload56/Y sky130_fd_sc_hd__clkinv_8
Xclkload45 clknet_leaf_21_clk vssd1 vssd1 vccd1 vccd1 clkload45/Y sky130_fd_sc_hd__clkinv_2
XFILLER_55_3 vssd1 vssd1 vccd1 vccd1 sky130_fd_sc_hd__fill_1
X_13379_ clknet_leaf_131_clk _00351_ net559 vssd1 vssd1 vccd1 vccd1 cell0.SB0.route_sel\[20\]
+ sky130_fd_sc_hd__dfstp_1
Xclkload78 clknet_leaf_113_clk vssd1 vssd1 vccd1 vccd1 clkload78/Y sky130_fd_sc_hd__clkinv_4
XANTENNA_clkbuf_leaf_53_clk_A clknet_4_13_0_clk vssd1 vssd1 vccd1 vccd1 sky130_fd_sc_hd__diode_2
XANTENNA__10556__A2 _05513_ vssd1 vssd1 vccd1 vccd1 sky130_fd_sc_hd__diode_2
XANTENNA__07793__C net354 vssd1 vssd1 vccd1 vccd1 sky130_fd_sc_hd__diode_2
XFILLER_5_470 vccd1 vssd1 vccd1 vssd1 sky130_ef_sc_hd__decap_40_12
Xclkload89 clknet_leaf_101_clk vssd1 vssd1 vccd1 vccd1 clkload89/Y sky130_fd_sc_hd__bufinv_16
X_07940_ net511 net512 vssd1 vssd1 vccd1 vccd1 _02984_ sky130_fd_sc_hd__and2b_1
XFILLER_142_699 vssd1 vssd1 vccd1 vccd1 sky130_fd_sc_hd__fill_1
XANTENNA__10308__A2 net315 vssd1 vssd1 vccd1 vccd1 sky130_fd_sc_hd__diode_2
X_07871_ cell0.CB_0.config_dataA\[8\] cell0.CB_0.config_dataA\[7\] cell0.CB_0.config_dataA\[9\]
+ _02870_ vssd1 vssd1 vccd1 vccd1 _02915_ sky130_fd_sc_hd__or4bb_1
X_09610_ net282 _04625_ vssd1 vssd1 vccd1 vccd1 _04627_ sky130_fd_sc_hd__nand2_1
XANTENNA_clkbuf_leaf_68_clk_A clknet_4_15_0_clk vssd1 vssd1 vccd1 vccd1 sky130_fd_sc_hd__diode_2
XFILLER_83_414 vssd1 vssd1 vccd1 vccd1 sky130_fd_sc_hd__fill_8
XANTENNA__11816__S net905 vssd1 vssd1 vccd1 vccd1 sky130_fd_sc_hd__diode_2
XFILLER_68_477 vssd1 vssd1 vccd1 vccd1 sky130_fd_sc_hd__fill_2
X_06822_ net325 _01891_ vssd1 vssd1 vccd1 vccd1 _01892_ sky130_fd_sc_hd__nor2_1
X_06753_ net308 vssd1 vssd1 vccd1 vccd1 _01823_ sky130_fd_sc_hd__inv_2
XANTENNA__06932__A1 net317 vssd1 vssd1 vccd1 vccd1 sky130_fd_sc_hd__diode_2
X_09541_ _02154_ net270 _03848_ vssd1 vssd1 vccd1 vccd1 _04560_ sky130_fd_sc_hd__and3_1
XANTENNA_clkbuf_leaf_111_clk_A clknet_4_8_0_clk vssd1 vssd1 vccd1 vccd1 sky130_fd_sc_hd__diode_2
X_06684_ cell2.LE_1A.config_data\[16\] vssd1 vssd1 vccd1 vccd1 _01754_ sky130_fd_sc_hd__inv_2
X_09472_ _01710_ cell3.SB0.route_sel\[50\] cell3.SB0.route_sel\[55\] cell3.SB0.route_sel\[54\]
+ _04493_ vssd1 vssd1 vccd1 vccd1 _04494_ sky130_fd_sc_hd__o221a_1
XFILLER_24_514 vccd1 vssd1 vccd1 vssd1 sky130_ef_sc_hd__decap_40_12
X_08423_ _03453_ _03460_ _03449_ vssd1 vssd1 vccd1 vccd1 _03461_ sky130_fd_sc_hd__mux2_1
XFILLER_12_709 vssd1 vssd1 vccd1 vccd1 sky130_fd_sc_hd__fill_2
XTAP_TAPCELL_ROW_19_594 vssd1 vccd1 sky130_fd_sc_hd__tapvpwrvgnd_1
XFILLER_34_29 vccd1 vssd1 vccd1 vssd1 sky130_ef_sc_hd__decap_40_12
XANTENNA__06879__A_N cell0.CB_0.config_dataB\[24\] vssd1 vssd1 vccd1 vccd1 sky130_fd_sc_hd__diode_2
X_08354_ net503 _02211_ _03391_ net502 vssd1 vssd1 vccd1 vccd1 _03392_ sky130_fd_sc_hd__o211a_1
XANTENNA_clkbuf_leaf_126_clk_A clknet_4_2_0_clk vssd1 vssd1 vccd1 vccd1 sky130_fd_sc_hd__diode_2
XANTENNA__08392__A2_N _02136_ vssd1 vssd1 vccd1 vccd1 sky130_fd_sc_hd__diode_2
XFILLER_137_405 vssd1 vssd1 vccd1 vccd1 sky130_fd_sc_hd__fill_1
XANTENNA__10244__B2 net59 vssd1 vssd1 vccd1 vccd1 sky130_fd_sc_hd__diode_2
XANTENNA__10244__A1 net60 vssd1 vssd1 vccd1 vccd1 sky130_fd_sc_hd__diode_2
X_07305_ cell1.SB0.route_sel\[98\] cell1.SB0.route_sel\[99\] net335 _02359_ _02362_
+ vssd1 vssd1 vccd1 vccd1 _02363_ sky130_fd_sc_hd__a221o_1
XFILLER_126_9 vccd1 vssd1 vccd1 vssd1 sky130_ef_sc_hd__decap_40_12
Xclkload6 clknet_4_6_0_clk vssd1 vssd1 vccd1 vccd1 clkload6/Y sky130_fd_sc_hd__inv_8
X_08285_ net507 _02560_ cell0.CB_1.config_dataB\[6\] vssd1 vssd1 vccd1 vccd1 _03323_
+ sky130_fd_sc_hd__a21bo_1
XANTENNA__10962__Y _05916_ vssd1 vssd1 vccd1 vccd1 sky130_fd_sc_hd__diode_2
X_07236_ cell1.SB0.route_sel\[89\] cell1.SB0.route_sel\[88\] vssd1 vssd1 vccd1 vccd1
+ _02296_ sky130_fd_sc_hd__nor2_1
X_07167_ _02189_ _02228_ net861 vssd1 vssd1 vccd1 vccd1 _02229_ sky130_fd_sc_hd__a21o_1
XFILLER_132_121 vssd1 vssd1 vccd1 vccd1 sky130_fd_sc_hd__fill_1
XTAP_TAPCELL_ROW_76_1455 vssd1 vccd1 sky130_fd_sc_hd__tapvpwrvgnd_1
XTAP_TAPCELL_ROW_76_1444 vssd1 vccd1 sky130_fd_sc_hd__tapvpwrvgnd_1
XANTENNA__11744__A1 net1157 vssd1 vssd1 vccd1 vccd1 sky130_fd_sc_hd__diode_2
XFILLER_3_429 vccd1 vssd1 vccd1 vssd1 sky130_ef_sc_hd__decap_40_12
XANTENNA__08432__Y _03468_ vssd1 vssd1 vccd1 vccd1 sky130_fd_sc_hd__diode_2
XANTENNA_fanout783_A net787 vssd1 vssd1 vccd1 vccd1 sky130_fd_sc_hd__diode_2
X_07098_ net270 _02161_ vssd1 vssd1 vccd1 vccd1 bus1_0\[9\] sky130_fd_sc_hd__and2_2
Xclkbuf_1_1__f_cell3.LE_1A.sel_clk clknet_0_cell3.LE_1A.sel_clk vssd1 vssd1 vccd1
+ vccd1 clknet_1_1__leaf_cell3.LE_1A.sel_clk sky130_fd_sc_hd__clkbuf_16
XANTENNA_fanout950_A net952 vssd1 vssd1 vccd1 vccd1 sky130_fd_sc_hd__diode_2
XANTENNA_input7_X net7 vssd1 vssd1 vccd1 vccd1 sky130_fd_sc_hd__diode_2
XFILLER_101_541 vssd1 vssd1 vccd1 vccd1 sky130_fd_sc_hd__fill_8
Xfanout298 cell3.CB_1.le_outA vssd1 vssd1 vccd1 vccd1 net298 sky130_fd_sc_hd__clkbuf_2
X_09808_ _04809_ _04813_ vssd1 vssd1 vccd1 vccd1 _04814_ sky130_fd_sc_hd__and2b_1
Xfanout287 net289 vssd1 vssd1 vccd1 vccd1 net287 sky130_fd_sc_hd__clkbuf_2
Xclkbuf_1_0__f_cell1.LE_1B.sel_clk clknet_0_cell1.LE_1B.sel_clk vssd1 vssd1 vccd1
+ vccd1 clknet_1_0__leaf_cell1.LE_1B.sel_clk sky130_fd_sc_hd__clkbuf_16
XANTENNA__08912__A2 bus3_1\[2\] vssd1 vssd1 vccd1 vccd1 sky130_fd_sc_hd__diode_2
XFILLER_19_319 vccd1 vssd1 vccd1 vssd1 sky130_ef_sc_hd__decap_40_12
X_09739_ _04748_ _04295_ vssd1 vssd1 vccd1 vccd1 bus2_0\[2\] sky130_fd_sc_hd__and2b_2
XANTENNA__09423__C _04444_ vssd1 vssd1 vccd1 vccd1 sky130_fd_sc_hd__diode_2
XFILLER_55_650 vssd1 vssd1 vccd1 vccd1 sky130_fd_sc_hd__fill_1
X_12750_ cell3.CB_0.config_dataA\[17\] net372 net929 vssd1 vssd1 vccd1 vccd1 _01179_
+ sky130_fd_sc_hd__mux2_1
XTAP_TAPCELL_ROW_120_2110 vssd1 vccd1 sky130_fd_sc_hd__tapvpwrvgnd_1
XANTENNA__09873__A0 bus3_2\[12\] vssd1 vssd1 vccd1 vccd1 sky130_fd_sc_hd__diode_2
XANTENNA_input114_A SBwest_in[25] vssd1 vssd1 vccd1 vccd1 sky130_fd_sc_hd__diode_2
XTAP_TAPCELL_ROW_38_881 vssd1 vccd1 sky130_fd_sc_hd__tapvpwrvgnd_1
X_12681_ net1511 cell3.LE_1B.edge_mode net956 vssd1 vssd1 vccd1 vccd1 _01110_ sky130_fd_sc_hd__mux2_1
XFILLER_91_57 vssd1 vssd1 vccd1 vccd1 sky130_fd_sc_hd__fill_1
X_11701_ net1486 net548 _06373_ vssd1 vssd1 vccd1 vccd1 _00141_ sky130_fd_sc_hd__a21bo_1
X_14420_ clknet_leaf_38_clk net1191 net718 vssd1 vssd1 vccd1 vccd1 cell3.LE_0A.config_data\[7\]
+ sky130_fd_sc_hd__dfrtp_1
XANTENNA__13957__RESET_B net635 vssd1 vssd1 vccd1 vccd1 sky130_fd_sc_hd__diode_2
X_11632_ cell0.CB_0.config_dataA\[3\] cell0.CB_0.config_dataA\[2\] net769 vssd1 vssd1
+ vccd1 vccd1 _00073_ sky130_fd_sc_hd__mux2_1
X_14351_ clknet_leaf_69_clk _01323_ net727 vssd1 vssd1 vccd1 vccd1 cell3.CB_1.config_dataB\[8\]
+ sky130_fd_sc_hd__dfstp_1
X_11563_ net1253 net1136 net801 vssd1 vssd1 vccd1 vccd1 _00004_ sky130_fd_sc_hd__mux2_1
X_13302_ clknet_leaf_99_clk _00274_ net680 vssd1 vssd1 vccd1 vccd1 cell1.CB_1.config_dataA\[18\]
+ sky130_fd_sc_hd__dfstp_1
XTAP_TAPCELL_ROW_118_2083 vssd1 vccd1 sky130_fd_sc_hd__tapvpwrvgnd_1
XTAP_TAPCELL_ROW_118_2072 vssd1 vccd1 sky130_fd_sc_hd__tapvpwrvgnd_1
X_14282_ clknet_leaf_21_clk _01254_ net610 vssd1 vssd1 vccd1 vccd1 cell2.SB0.route_sel\[67\]
+ sky130_fd_sc_hd__dfstp_1
X_11494_ cell2.SB0.route_sel\[16\] cell2.SB0.route_sel\[17\] cell2.SB0.route_sel\[19\]
+ _01587_ _06329_ vssd1 vssd1 vccd1 vccd1 _06330_ sky130_fd_sc_hd__o221a_1
X_10514_ _05472_ net337 _02568_ vssd1 vssd1 vccd1 vccd1 net140 sky130_fd_sc_hd__mux2_1
XFILLER_10_274 vssd1 vssd1 vccd1 vccd1 sky130_fd_sc_hd__fill_1
X_10445_ _01710_ cell3.SB0.route_sel\[50\] vssd1 vssd1 vccd1 vccd1 _05437_ sky130_fd_sc_hd__nand2_1
XANTENNA__09928__A1 bus3_2\[4\] vssd1 vssd1 vccd1 vccd1 sky130_fd_sc_hd__diode_2
XANTENNA__09928__B2 bus3_2\[5\] vssd1 vssd1 vccd1 vccd1 sky130_fd_sc_hd__diode_2
X_13233_ clknet_leaf_10_clk net1067 net585 vssd1 vssd1 vccd1 vccd1 cell0.LEI0.config_data\[18\]
+ sky130_fd_sc_hd__dfrtp_1
XFILLER_6_278 vssd1 vssd1 vccd1 vccd1 sky130_fd_sc_hd__fill_1
X_13164_ clknet_leaf_116_clk net1069 net667 vssd1 vssd1 vccd1 vccd1 cell0.LE_1A.config_data\[15\]
+ sky130_fd_sc_hd__dfrtp_1
XANTENNA_output166_A net166 vssd1 vssd1 vccd1 vccd1 sky130_fd_sc_hd__diode_2
X_10376_ _05374_ vssd1 vssd1 vccd1 vccd1 _05375_ sky130_fd_sc_hd__inv_2
XTAP_TAPCELL_ROW_131_2272 vssd1 vccd1 sky130_fd_sc_hd__tapvpwrvgnd_1
X_12115_ net1517 net550 _06379_ vssd1 vssd1 vccd1 vccd1 _00549_ sky130_fd_sc_hd__a21bo_1
XFILLER_124_688 vssd1 vssd1 vccd1 vccd1 sky130_fd_sc_hd__fill_1
XANTENNA_clkbuf_4_15_0_clk_X clknet_4_15_0_clk vssd1 vssd1 vccd1 vccd1 sky130_fd_sc_hd__diode_2
X_13095_ clknet_leaf_11_clk _00067_ net573 vssd1 vssd1 vccd1 vccd1 cell0.CB_0.config_dataB\[22\]
+ sky130_fd_sc_hd__dfstp_1
XFILLER_2_473 vssd1 vssd1 vccd1 vccd1 sky130_fd_sc_hd__fill_2
XANTENNA__09555__A_N _04573_ vssd1 vssd1 vccd1 vccd1 sky130_fd_sc_hd__diode_2
X_12046_ cell1.CB_1.config_dataB\[24\] net449 net885 vssd1 vssd1 vccd1 vccd1 _00483_
+ sky130_fd_sc_hd__mux2_1
XFILLER_49_92 vssd1 vssd1 vccd1 vccd1 sky130_fd_sc_hd__fill_1
XFILLER_65_447 vssd1 vssd1 vccd1 vccd1 sky130_fd_sc_hd__fill_1
XFILLER_1_55 vssd1 vssd1 vccd1 vccd1 sky130_fd_sc_hd__fill_1
XFILLER_80_406 vssd1 vssd1 vccd1 vccd1 sky130_fd_sc_hd__fill_2
X_13997_ clknet_leaf_79_clk _00969_ net708 vssd1 vssd1 vccd1 vccd1 cell3.SB0.route_sel\[5\]
+ sky130_fd_sc_hd__dfstp_1
XFILLER_65_458 vssd1 vssd1 vccd1 vccd1 sky130_fd_sc_hd__fill_4
XFILLER_46_661 vssd1 vssd1 vccd1 vccd1 sky130_fd_sc_hd__fill_1
X_12948_ cell3.LE_0B.config_data\[13\] net1224 net950 vssd1 vssd1 vccd1 vccd1 _01376_
+ sky130_fd_sc_hd__mux2_1
XANTENNA__09901__Y _04907_ vssd1 vssd1 vccd1 vccd1 sky130_fd_sc_hd__diode_2
XFILLER_80_428 vssd1 vssd1 vccd1 vccd1 sky130_fd_sc_hd__fill_4
XFILLER_80_417 vssd1 vssd1 vccd1 vccd1 sky130_fd_sc_hd__fill_2
XTAP_TAPCELL_ROW_47_1012 vssd1 vccd1 sky130_fd_sc_hd__tapvpwrvgnd_1
X_12879_ cell2.SB0.route_sel\[121\] cell2.SB0.route_sel\[120\] net820 vssd1 vssd1
+ vccd1 vccd1 _01308_ sky130_fd_sc_hd__mux2_1
XFILLER_61_631 vssd1 vssd1 vccd1 vccd1 sky130_fd_sc_hd__fill_1
XANTENNA__08131__A3 _02040_ vssd1 vssd1 vccd1 vccd1 sky130_fd_sc_hd__diode_2
XTAP_TAPCELL_ROW_16_542 vssd1 vccd1 sky130_fd_sc_hd__tapvpwrvgnd_1
XTAP_TAPCELL_ROW_60_1201 vssd1 vccd1 sky130_fd_sc_hd__tapvpwrvgnd_1
XTAP_TAPCELL_ROW_16_553 vssd1 vccd1 sky130_fd_sc_hd__tapvpwrvgnd_1
XTAP_TAPCELL_ROW_60_1212 vssd1 vccd1 sky130_fd_sc_hd__tapvpwrvgnd_1
XANTENNA__10495__B _03533_ vssd1 vssd1 vccd1 vccd1 sky130_fd_sc_hd__diode_2
Xclkload112 clknet_leaf_54_clk vssd1 vssd1 vccd1 vccd1 clkload112/Y sky130_fd_sc_hd__inv_6
X_08070_ bus2_0\[4\] _03091_ _03092_ bus2_0\[5\] cell0.CB_0.config_dataB\[13\] vssd1
+ vssd1 vccd1 vccd1 _03112_ sky130_fd_sc_hd__a221o_1
Xclkload101 clknet_leaf_95_clk vssd1 vssd1 vccd1 vccd1 clkload101/Y sky130_fd_sc_hd__inv_8
Xclkload134 clknet_1_0__leaf_cell3.LE_0B.sel_clk vssd1 vssd1 vccd1 vccd1 clkload134/X
+ sky130_fd_sc_hd__clkbuf_4
Xclkload123 clknet_leaf_77_clk vssd1 vssd1 vccd1 vccd1 clkload123/Y sky130_fd_sc_hd__clkinvlp_4
X_07021_ bus3_2\[8\] _02085_ vssd1 vssd1 vccd1 vccd1 _02086_ sky130_fd_sc_hd__nand2_1
Xclkload145 clknet_1_1__leaf_cell0.LE_0A.sel_clk vssd1 vssd1 vccd1 vccd1 clkload145/X
+ sky130_fd_sc_hd__clkbuf_4
XTAP_TAPCELL_ROW_58_1185 vssd1 vccd1 sky130_fd_sc_hd__tapvpwrvgnd_1
XTAP_TAPCELL_ROW_58_1174 vssd1 vccd1 sky130_fd_sc_hd__tapvpwrvgnd_1
XFILLER_88_528 vssd1 vssd1 vccd1 vccd1 sky130_fd_sc_hd__fill_4
X_08972_ cell1.CB_0.config_dataA\[19\] _03972_ vssd1 vssd1 vccd1 vccd1 _04004_ sky130_fd_sc_hd__nand2_1
Xhold18 _01373_ vssd1 vssd1 vccd1 vccd1 net977 sky130_fd_sc_hd__dlygate4sd3_1
Xhold29 cell0.LE_0A.config_data\[9\] vssd1 vssd1 vccd1 vccd1 net988 sky130_fd_sc_hd__dlygate4sd3_1
X_07923_ _02388_ _02951_ _02952_ _02456_ _01573_ vssd1 vssd1 vccd1 vccd1 _02967_ sky130_fd_sc_hd__a221o_1
XANTENNA__07158__A1 net2 vssd1 vssd1 vccd1 vccd1 sky130_fd_sc_hd__diode_2
XFILLER_84_701 vssd1 vssd1 vccd1 vccd1 sky130_fd_sc_hd__fill_4
XTAP_TAPCELL_ROW_71_1374 vssd1 vccd1 sky130_fd_sc_hd__tapvpwrvgnd_1
X_07854_ net518 _02897_ vssd1 vssd1 vccd1 vccd1 _02898_ sky130_fd_sc_hd__nand2_1
XANTENNA__06867__C _01931_ vssd1 vssd1 vccd1 vccd1 sky130_fd_sc_hd__diode_2
X_06805_ cell0.SB0.route_sel\[53\] cell0.SB0.route_sel\[52\] vssd1 vssd1 vccd1 vccd1
+ _01875_ sky130_fd_sc_hd__nor2_1
XANTENNA__08107__A0 net342 vssd1 vssd1 vccd1 vccd1 sky130_fd_sc_hd__diode_2
X_07785_ cell0.SB0.route_sel\[47\] cell0.SB0.route_sel\[46\] _01819_ _02829_ vssd1
+ vssd1 vccd1 vccd1 _02830_ sky130_fd_sc_hd__a211oi_1
X_09524_ _04215_ _04543_ vssd1 vssd1 vccd1 vccd1 _04544_ sky130_fd_sc_hd__nor2_1
X_06736_ cell3.CB_0.config_dataA\[0\] vssd1 vssd1 vccd1 vccd1 _01806_ sky130_fd_sc_hd__inv_2
XANTENNA__07044__B _02106_ vssd1 vssd1 vccd1 vccd1 sky130_fd_sc_hd__diode_2
XANTENNA__08658__A1 net458 vssd1 vssd1 vccd1 vccd1 sky130_fd_sc_hd__diode_2
X_06667_ cell3.SB0.route_sel\[99\] vssd1 vssd1 vccd1 vccd1 _01737_ sky130_fd_sc_hd__inv_2
X_09455_ _04469_ _04475_ _04476_ vssd1 vssd1 vccd1 vccd1 _04477_ sky130_fd_sc_hd__a21o_1
XANTENNA__07612__X _02661_ vssd1 vssd1 vccd1 vccd1 sky130_fd_sc_hd__diode_2
XANTENNA__12377__S net908 vssd1 vssd1 vccd1 vccd1 sky130_fd_sc_hd__diode_2
XTAP_TAPCELL_ROW_35_840 vssd1 vccd1 sky130_fd_sc_hd__tapvpwrvgnd_1
XFILLER_12_528 vssd1 vssd1 vccd1 vccd1 sky130_fd_sc_hd__fill_1
X_08406_ _02807_ _03420_ _03422_ _02846_ _01493_ vssd1 vssd1 vccd1 vccd1 _03444_ sky130_fd_sc_hd__a221o_1
X_09386_ _04377_ _04409_ vssd1 vssd1 vccd1 vccd1 _04410_ sky130_fd_sc_hd__nor2_1
XFILLER_61_38 vssd1 vssd1 vccd1 vccd1 sky130_fd_sc_hd__fill_1
X_06598_ cell1.LE_1A.config_data\[16\] vssd1 vssd1 vccd1 vccd1 _01668_ sky130_fd_sc_hd__inv_2
X_08337_ _02037_ _02039_ _03351_ vssd1 vssd1 vccd1 vccd1 _03375_ sky130_fd_sc_hd__o21a_1
XFILLER_138_769 vccd1 vssd1 vccd1 vssd1 sky130_ef_sc_hd__decap_40_12
X_08268_ cell0.LE_1A.config_data\[9\] cell0.LE_1A.config_data\[8\] _03198_ vssd1 vssd1
+ vccd1 vccd1 _03308_ sky130_fd_sc_hd__mux2_1
XANTENNA__07633__A2 _02679_ vssd1 vssd1 vccd1 vccd1 sky130_fd_sc_hd__diode_2
XANTENNA__06841__B1 _01909_ vssd1 vssd1 vccd1 vccd1 sky130_fd_sc_hd__diode_2
X_07219_ cell1.SB0.route_sel\[93\] cell1.SB0.route_sel\[92\] vssd1 vssd1 vccd1 vccd1
+ _02279_ sky130_fd_sc_hd__nand2_1
X_10230_ cell2.LE_0A.config_data\[7\] cell2.LE_0A.config_data\[6\] _05196_ vssd1 vssd1
+ vccd1 vccd1 _05231_ sky130_fd_sc_hd__mux2_1
XFILLER_4_749 vssd1 vssd1 vccd1 vccd1 sky130_fd_sc_hd__fill_4
X_08199_ net539 _02211_ _03238_ net538 vssd1 vssd1 vccd1 vccd1 _03239_ sky130_fd_sc_hd__o211a_1
XANTENNA__08189__A3 net338 vssd1 vssd1 vccd1 vccd1 sky130_fd_sc_hd__diode_2
XFILLER_3_237 vccd1 vssd1 vccd1 vssd1 sky130_ef_sc_hd__decap_40_12
XFILLER_10_53 vccd1 vssd1 vccd1 vssd1 sky130_ef_sc_hd__decap_40_12
XFILLER_126_53 vccd1 vssd1 vccd1 vssd1 sky130_ef_sc_hd__decap_40_12
X_10161_ net312 net306 net318 net304 cell2.LEI0.config_data\[12\] cell2.LEI0.config_data\[13\]
+ vssd1 vssd1 vccd1 vccd1 _05162_ sky130_fd_sc_hd__mux4_1
XFILLER_79_539 vssd1 vssd1 vccd1 vccd1 sky130_fd_sc_hd__fill_1
XFILLER_10_97 vccd1 vssd1 vccd1 vssd1 sky130_ef_sc_hd__decap_40_12
XANTENNA__10940__A2 _05893_ vssd1 vssd1 vccd1 vccd1 sky130_fd_sc_hd__diode_2
X_10092_ _05092_ vssd1 vssd1 vccd1 vccd1 _05093_ sky130_fd_sc_hd__inv_2
X_13920_ clknet_1_0__leaf_cell2.LE_0B.sel_clk _00892_ net752 vssd1 vssd1 vccd1 vccd1
+ cell2.LE_0B.dff0_out sky130_fd_sc_hd__dfrtp_1
XANTENNA__11309__X net149 vssd1 vssd1 vccd1 vccd1 sky130_fd_sc_hd__diode_2
XTAP_TAPCELL_ROW_89_1646 vssd1 vccd1 sky130_fd_sc_hd__tapvpwrvgnd_1
XFILLER_47_447 vssd1 vssd1 vccd1 vccd1 sky130_fd_sc_hd__fill_1
XFILLER_19_51 vssd1 vssd1 vccd1 vccd1 sky130_fd_sc_hd__fill_4
XFILLER_19_73 vssd1 vssd1 vccd1 vccd1 sky130_fd_sc_hd__fill_2
XFILLER_142_52 vssd1 vssd1 vccd1 vccd1 sky130_fd_sc_hd__fill_4
X_13851_ clknet_leaf_45_clk _00823_ net630 vssd1 vssd1 vccd1 vccd1 cell2.CB_1.config_dataB\[0\]
+ sky130_fd_sc_hd__dfstp_1
X_10994_ cell3.CB_0.config_dataA\[6\] _05945_ _05946_ _05947_ vssd1 vssd1 vccd1 vccd1
+ _05948_ sky130_fd_sc_hd__a211o_1
X_12802_ cell2.SB0.route_sel\[44\] cell2.SB0.route_sel\[43\] net813 vssd1 vssd1 vccd1
+ vccd1 _01231_ sky130_fd_sc_hd__mux2_1
XFILLER_74_288 vssd1 vssd1 vccd1 vccd1 sky130_fd_sc_hd__fill_1
X_13782_ clknet_leaf_108_clk _00754_ net651 vssd1 vssd1 vccd1 vccd1 cell1.SB0.route_sel\[59\]
+ sky130_fd_sc_hd__dfstp_1
X_12733_ cell3.CB_0.config_dataA\[0\] net1408 net947 vssd1 vssd1 vccd1 vccd1 _01162_
+ sky130_fd_sc_hd__mux2_1
XANTENNA__09450__A net300 vssd1 vssd1 vccd1 vccd1 sky130_fd_sc_hd__diode_2
XANTENNA__07889__B _02585_ vssd1 vssd1 vccd1 vccd1 sky130_fd_sc_hd__diode_2
XTAP_TAPCELL_ROW_100_1802 vssd1 vccd1 sky130_fd_sc_hd__tapvpwrvgnd_1
XANTENNA__10596__A _05553_ vssd1 vssd1 vccd1 vccd1 sky130_fd_sc_hd__diode_2
XFILLER_42_141 vssd1 vssd1 vccd1 vccd1 sky130_fd_sc_hd__fill_1
X_14403_ clknet_leaf_61_clk net1071 net739 vssd1 vssd1 vccd1 vccd1 cell3.LE_0B.config_data\[12\]
+ sky130_fd_sc_hd__dfrtp_1
X_12664_ cell3.LE_1B.config_data\[1\] net1260 net957 vssd1 vssd1 vccd1 vccd1 _01093_
+ sky130_fd_sc_hd__mux2_1
XANTENNA__10208__A1 net37 vssd1 vssd1 vccd1 vccd1 sky130_fd_sc_hd__diode_2
XTAP_TAPCELL_ROW_100_1813 vssd1 vccd1 sky130_fd_sc_hd__tapvpwrvgnd_1
XTAP_TAPCELL_ROW_13_501 vssd1 vccd1 sky130_fd_sc_hd__tapvpwrvgnd_1
XANTENNA__07872__A2 net350 vssd1 vssd1 vccd1 vccd1 sky130_fd_sc_hd__diode_2
X_12595_ cell3.SB0.route_sel\[60\] cell3.SB0.route_sel\[59\] net909 vssd1 vssd1 vccd1
+ vccd1 _01024_ sky130_fd_sc_hd__mux2_1
XANTENNA__09074__A1 _03868_ vssd1 vssd1 vccd1 vccd1 sky130_fd_sc_hd__diode_2
XANTENNA__09074__B2 _03871_ vssd1 vssd1 vccd1 vccd1 sky130_fd_sc_hd__diode_2
X_11615_ net526 net527 net769 vssd1 vssd1 vccd1 vccd1 _00056_ sky130_fd_sc_hd__mux2_1
XTAP_TAPCELL_ROW_133_2301 vssd1 vccd1 sky130_fd_sc_hd__tapvpwrvgnd_1
XANTENNA__10759__A2 _05501_ vssd1 vssd1 vccd1 vccd1 sky130_fd_sc_hd__diode_2
X_14334_ clknet_leaf_19_clk _01306_ net613 vssd1 vssd1 vccd1 vccd1 cell2.SB0.route_sel\[119\]
+ sky130_fd_sc_hd__dfstp_1
XANTENNA__09449__X _04471_ vssd1 vssd1 vccd1 vccd1 sky130_fd_sc_hd__diode_2
XANTENNA_input82_X net82 vssd1 vssd1 vccd1 vccd1 sky130_fd_sc_hd__diode_2
XFILLER_11_561 vssd1 vssd1 vccd1 vccd1 sky130_fd_sc_hd__fill_4
X_11546_ _02675_ _06364_ vssd1 vssd1 vccd1 vccd1 net241 sky130_fd_sc_hd__and2b_2
X_14265_ clknet_leaf_24_clk _01237_ net607 vssd1 vssd1 vccd1 vccd1 cell2.SB0.route_sel\[50\]
+ sky130_fd_sc_hd__dfstp_1
XFILLER_7_565 vssd1 vssd1 vccd1 vccd1 sky130_fd_sc_hd__fill_2
XFILLER_109_493 vssd1 vssd1 vccd1 vccd1 sky130_fd_sc_hd__fill_2
X_13216_ clknet_leaf_13_clk _00188_ net589 vssd1 vssd1 vccd1 vccd1 cell0.LEI0.config_data\[1\]
+ sky130_fd_sc_hd__dfrtp_1
X_11477_ _02373_ _06318_ vssd1 vssd1 vccd1 vccd1 net218 sky130_fd_sc_hd__and2_1
X_10428_ _01763_ cell2.LE_0B.dff_out vssd1 vssd1 vccd1 vccd1 _05426_ sky130_fd_sc_hd__or2_1
X_14196_ clknet_leaf_54_clk _01168_ net715 vssd1 vssd1 vccd1 vccd1 cell3.CB_0.config_dataA\[6\]
+ sky130_fd_sc_hd__dfstp_1
XANTENNA__12750__S net929 vssd1 vssd1 vccd1 vccd1 sky130_fd_sc_hd__diode_2
X_10359_ net60 _05348_ _05350_ net59 cell2.CB_0.config_dataB\[13\] vssd1 vssd1 vccd1
+ vccd1 _05358_ sky130_fd_sc_hd__a221o_1
X_13147_ clknet_leaf_129_clk _00119_ net578 vssd1 vssd1 vccd1 vccd1 cell0.CB_1.config_dataB\[24\]
+ sky130_fd_sc_hd__dfstp_1
XANTENNA__07129__B net361 vssd1 vssd1 vccd1 vccd1 sky130_fd_sc_hd__diode_2
XFILLER_111_113 vssd1 vssd1 vccd1 vccd1 sky130_fd_sc_hd__fill_1
X_13078_ clknet_leaf_7_clk _00050_ net574 vssd1 vssd1 vccd1 vccd1 cell0.CB_0.config_dataB\[5\]
+ sky130_fd_sc_hd__dfstp_1
XTAP_TAPCELL_ROW_111_1975 vssd1 vccd1 sky130_fd_sc_hd__tapvpwrvgnd_1
X_12029_ cell1.CB_1.config_dataB\[7\] net457 net899 vssd1 vssd1 vccd1 vccd1 _00466_
+ sky130_fd_sc_hd__mux2_1
XANTENNA__08888__B2 _03868_ vssd1 vssd1 vccd1 vccd1 sky130_fd_sc_hd__diode_2
XANTENNA__08888__A1 _03871_ vssd1 vssd1 vccd1 vccd1 sky130_fd_sc_hd__diode_2
XFILLER_81_726 vssd1 vssd1 vccd1 vccd1 sky130_fd_sc_hd__fill_2
X_07570_ cell0.CB_0.config_dataA\[22\] cell0.CB_0.config_dataA\[23\] vssd1 vssd1 vccd1
+ vccd1 _02620_ sky130_fd_sc_hd__or2_2
XFILLER_19_694 vssd1 vssd1 vccd1 vccd1 sky130_fd_sc_hd__fill_1
X_06521_ cell0.SB0.route_sel\[21\] vssd1 vssd1 vccd1 vccd1 _01591_ sky130_fd_sc_hd__inv_2
X_09240_ cell3.CB_0.config_dataA\[24\] cell3.CB_0.config_dataA\[21\] cell3.CB_0.config_dataA\[20\]
+ vssd1 vssd1 vccd1 vccd1 _04267_ sky130_fd_sc_hd__or3b_2
XFILLER_22_804 vssd1 vssd1 vccd1 vccd1 sky130_fd_sc_hd__fill_1
XFILLER_33_163 vssd1 vssd1 vccd1 vccd1 sky130_fd_sc_hd__fill_2
X_06452_ cell1.SB0.route_sel\[58\] vssd1 vssd1 vccd1 vccd1 _01522_ sky130_fd_sc_hd__inv_2
XFILLER_34_697 vssd1 vssd1 vccd1 vccd1 sky130_fd_sc_hd__fill_1
X_09171_ cell3.SB0.route_sel\[6\] cell3.SB0.route_sel\[7\] vssd1 vssd1 vccd1 vccd1
+ _04199_ sky130_fd_sc_hd__nand2_1
X_08122_ cell0.LE_0B.dff0_out cell0.LE_0B.dff1_out cell0.LE_0B.reset_val vssd1 vssd1
+ vccd1 vccd1 cell0.LE_0B.dff_out sky130_fd_sc_hd__mux2_1
XFILLER_107_408 vssd1 vssd1 vccd1 vccd1 sky130_fd_sc_hd__fill_1
X_08053_ net528 _02526_ _03094_ net526 vssd1 vssd1 vccd1 vccd1 _03095_ sky130_fd_sc_hd__o211a_1
X_07004_ cell1.SB0.route_sel\[68\] cell1.SB0.route_sel\[69\] vssd1 vssd1 vccd1 vccd1
+ _02070_ sky130_fd_sc_hd__nand2b_1
XPHY_EDGE_ROW_131_Right_131 vssd1 vssd1 vccd1 vccd1 sky130_fd_sc_hd__decap_3
XFILLER_127_290 vssd1 vssd1 vccd1 vccd1 sky130_fd_sc_hd__fill_1
XTAP_TAPCELL_ROW_73_1403 vssd1 vccd1 sky130_fd_sc_hd__tapvpwrvgnd_1
XANTENNA__07379__A1 net335 vssd1 vssd1 vccd1 vccd1 sky130_fd_sc_hd__diode_2
XANTENNA__08040__A2 bus2_0\[2\] vssd1 vssd1 vccd1 vccd1 sky130_fd_sc_hd__diode_2
XFILLER_0_218 vssd1 vssd1 vccd1 vccd1 sky130_fd_sc_hd__fill_4
XANTENNA__10922__A2 _05871_ vssd1 vssd1 vccd1 vccd1 sky130_fd_sc_hd__diode_2
X_08955_ net465 _03844_ vssd1 vssd1 vccd1 vccd1 _03987_ sky130_fd_sc_hd__nand2_1
Xinput108 SBwest_in[1] vssd1 vssd1 vccd1 vccd1 net108 sky130_fd_sc_hd__clkbuf_1
XFILLER_69_561 vssd1 vssd1 vccd1 vccd1 sky130_fd_sc_hd__fill_1
X_07906_ net516 _02894_ _02949_ net514 vssd1 vssd1 vccd1 vccd1 _02950_ sky130_fd_sc_hd__o211a_1
Xinput119 SBwest_in[2] vssd1 vssd1 vccd1 vccd1 net119 sky130_fd_sc_hd__buf_1
XANTENNA_fanout579_A net581 vssd1 vssd1 vccd1 vccd1 sky130_fd_sc_hd__diode_2
X_08886_ net474 _03862_ vssd1 vssd1 vccd1 vccd1 _03918_ sky130_fd_sc_hd__nand2_1
XFILLER_29_425 vssd1 vssd1 vccd1 vccd1 sky130_fd_sc_hd__fill_1
X_07837_ _02879_ _02880_ cell0.CB_0.config_dataA\[8\] vssd1 vssd1 vccd1 vccd1 _02881_
+ sky130_fd_sc_hd__or3b_1
XFILLER_57_789 vssd1 vssd1 vccd1 vccd1 sky130_fd_sc_hd__fill_1
XFILLER_29_447 vssd1 vssd1 vccd1 vccd1 sky130_fd_sc_hd__fill_1
XANTENNA_fanout746_A net749 vssd1 vssd1 vccd1 vccd1 sky130_fd_sc_hd__diode_2
XFILLER_84_586 vssd1 vssd1 vccd1 vccd1 sky130_fd_sc_hd__fill_2
XFILLER_84_575 vssd1 vssd1 vccd1 vccd1 sky130_fd_sc_hd__fill_2
X_07768_ _01885_ _02057_ vssd1 vssd1 vccd1 vccd1 _02814_ sky130_fd_sc_hd__or2_1
XFILLER_44_417 vssd1 vssd1 vccd1 vccd1 sky130_fd_sc_hd__fill_1
X_06719_ cell3.CB_1.config_dataA\[9\] vssd1 vssd1 vccd1 vccd1 _01789_ sky130_fd_sc_hd__inv_2
X_09507_ _02106_ _04526_ vssd1 vssd1 vccd1 vccd1 _04527_ sky130_fd_sc_hd__and2_2
XTAP_TAPCELL_ROW_84_1565 vssd1 vccd1 sky130_fd_sc_hd__tapvpwrvgnd_1
X_07699_ _01933_ _02609_ bus1_0\[3\] vssd1 vssd1 vccd1 vccd1 _02746_ sky130_fd_sc_hd__o21ai_1
XANTENNA__11203__A1_N _05921_ vssd1 vssd1 vccd1 vccd1 sky130_fd_sc_hd__diode_2
X_09438_ cell3.SB0.route_sel\[40\] cell3.SB0.route_sel\[41\] net281 _04459_ vssd1
+ vssd1 vccd1 vccd1 _04461_ sky130_fd_sc_hd__a22o_1
XFILLER_24_174 vssd1 vssd1 vccd1 vccd1 sky130_fd_sc_hd__fill_1
X_09369_ net305 _04390_ _04392_ vssd1 vssd1 vccd1 vccd1 _04393_ sky130_fd_sc_hd__a21oi_1
XFILLER_8_307 vssd1 vssd1 vccd1 vccd1 sky130_fd_sc_hd__fill_1
XANTENNA__08803__A1 bus3_1\[9\] vssd1 vssd1 vccd1 vccd1 sky130_fd_sc_hd__diode_2
X_12380_ cell1.SB0.route_sel\[118\] cell1.SB0.route_sel\[117\] net881 vssd1 vssd1
+ vccd1 vccd1 _00813_ sky130_fd_sc_hd__mux2_1
X_11400_ cell0.SB0.route_sel\[72\] cell0.SB0.route_sel\[73\] vssd1 vssd1 vccd1 vccd1
+ _06267_ sky130_fd_sc_hd__nor2_1
XANTENNA__07067__B1 _02130_ vssd1 vssd1 vccd1 vccd1 sky130_fd_sc_hd__diode_2
X_11331_ net278 _05913_ _04314_ vssd1 vssd1 vccd1 vccd1 _06231_ sky130_fd_sc_hd__mux2_1
XTAP_TAPCELL_ROW_115_2031 vssd1 vccd1 sky130_fd_sc_hd__tapvpwrvgnd_1
X_11262_ _06198_ net309 _04438_ vssd1 vssd1 vccd1 vccd1 net193 sky130_fd_sc_hd__mux2_2
X_14050_ clknet_leaf_45_clk _01022_ net703 vssd1 vssd1 vccd1 vccd1 cell3.SB0.route_sel\[58\]
+ sky130_fd_sc_hd__dfstp_1
XFILLER_4_557 vccd1 vssd1 vccd1 vssd1 sky130_ef_sc_hd__decap_40_12
XFILLER_134_794 vccd1 vssd1 vccd1 vssd1 sky130_ef_sc_hd__decap_40_12
X_11193_ net383 net382 vssd1 vssd1 vccd1 vccd1 _06145_ sky130_fd_sc_hd__nor2_1
X_13001_ net1473 cell3.LEI0.config_data\[21\] net947 vssd1 vssd1 vccd1 vccd1 _01429_
+ sky130_fd_sc_hd__mux2_1
X_10213_ net414 _05211_ _05212_ _05213_ vssd1 vssd1 vccd1 vccd1 _05214_ sky130_fd_sc_hd__a31o_1
XFILLER_79_303 vssd1 vssd1 vccd1 vccd1 sky130_fd_sc_hd__fill_1
XANTENNA_input42_A CBnorth_in[18] vssd1 vssd1 vccd1 vccd1 sky130_fd_sc_hd__diode_2
X_10144_ net418 _05144_ vssd1 vssd1 vccd1 vccd1 _05145_ sky130_fd_sc_hd__nand2_1
XFILLER_79_358 vssd1 vssd1 vccd1 vccd1 sky130_fd_sc_hd__fill_1
XFILLER_79_325 vssd1 vssd1 vccd1 vccd1 sky130_fd_sc_hd__fill_1
XANTENNA__09597__A2_N _02289_ vssd1 vssd1 vccd1 vccd1 sky130_fd_sc_hd__diode_2
XFILLER_79_369 vssd1 vssd1 vccd1 vccd1 sky130_fd_sc_hd__fill_2
X_10075_ cell2.LE_1B.dff0_out cell2.LE_1B.dff1_out cell2.LE_1B.reset_val vssd1 vssd1
+ vccd1 vccd1 cell2.LE_1B.dff_out sky130_fd_sc_hd__mux2_1
X_13903_ clknet_leaf_36_clk _00875_ net639 vssd1 vssd1 vccd1 vccd1 cell2.LE_0B.config_data\[4\]
+ sky130_fd_sc_hd__dfrtp_1
XANTENNA__09819__A0 net313 vssd1 vssd1 vccd1 vccd1 sky130_fd_sc_hd__diode_2
XTAP_TAPCELL_ROW_126_2193 vssd1 vccd1 sky130_fd_sc_hd__tapvpwrvgnd_1
XANTENNA__10103__B _05103_ vssd1 vssd1 vccd1 vccd1 sky130_fd_sc_hd__diode_2
X_13834_ clknet_leaf_111_clk _00806_ net655 vssd1 vssd1 vccd1 vccd1 cell1.SB0.route_sel\[111\]
+ sky130_fd_sc_hd__dfstp_1
XANTENNA__07252__X _02311_ vssd1 vssd1 vccd1 vccd1 sky130_fd_sc_hd__diode_2
X_10977_ cell3.CB_0.config_dataA\[5\] _05850_ vssd1 vssd1 vccd1 vccd1 _05931_ sky130_fd_sc_hd__nand2_1
XANTENNA__09834__A3 bus3_2\[11\] vssd1 vssd1 vccd1 vccd1 sky130_fd_sc_hd__diode_2
X_13765_ clknet_leaf_110_clk _00737_ net654 vssd1 vssd1 vccd1 vccd1 cell1.SB0.route_sel\[42\]
+ sky130_fd_sc_hd__dfstp_1
X_12716_ cell3.CB_0.config_dataB\[8\] cell3.CB_0.config_dataB\[7\] net931 vssd1 vssd1
+ vccd1 vccd1 _01145_ sky130_fd_sc_hd__mux2_1
X_13696_ clknet_leaf_33_clk _00668_ net621 vssd1 vssd1 vccd1 vccd1 cell2.CB_0.config_dataB\[23\]
+ sky130_fd_sc_hd__dfstp_2
XTAP_TAPCELL_ROW_26_692 vssd1 vccd1 sky130_fd_sc_hd__tapvpwrvgnd_1
X_12647_ cell3.SB0.route_sel\[112\] cell3.SB0.route_sel\[111\] net922 vssd1 vssd1
+ vccd1 vccd1 _01076_ sky130_fd_sc_hd__mux2_1
XFILLER_129_544 vssd1 vssd1 vccd1 vccd1 sky130_fd_sc_hd__fill_1
XFILLER_30_166 vssd1 vssd1 vccd1 vccd1 sky130_fd_sc_hd__fill_1
X_12578_ cell3.SB0.route_sel\[43\] cell3.SB0.route_sel\[42\] net914 vssd1 vssd1 vccd1
+ vccd1 _01007_ sky130_fd_sc_hd__mux2_1
XFILLER_11_380 vssd1 vssd1 vccd1 vccd1 sky130_fd_sc_hd__fill_1
XFILLER_116_227 vssd1 vssd1 vccd1 vccd1 sky130_fd_sc_hd__fill_1
X_14317_ clknet_leaf_18_clk _01289_ net615 vssd1 vssd1 vccd1 vccd1 cell2.SB0.route_sel\[102\]
+ sky130_fd_sc_hd__dfstp_1
X_11529_ _01645_ cell2.SB0.route_sel\[114\] vssd1 vssd1 vccd1 vccd1 _06353_ sky130_fd_sc_hd__nand2_1
Xhold307 cell0.LE_1A.config_data\[10\] vssd1 vssd1 vccd1 vccd1 net1266 sky130_fd_sc_hd__dlygate4sd3_1
Xhold329 cell2.LE_0B.config_data\[10\] vssd1 vssd1 vccd1 vccd1 net1288 sky130_fd_sc_hd__dlygate4sd3_1
X_14248_ clknet_leaf_27_clk _01220_ net615 vssd1 vssd1 vccd1 vccd1 cell2.SB0.route_sel\[33\]
+ sky130_fd_sc_hd__dfstp_1
Xhold318 _00595_ vssd1 vssd1 vccd1 vccd1 net1277 sky130_fd_sc_hd__dlygate4sd3_1
XANTENNA__08558__A0 net1 vssd1 vssd1 vccd1 vccd1 sky130_fd_sc_hd__diode_2
X_14179_ clknet_leaf_56_clk _01151_ net722 vssd1 vssd1 vccd1 vccd1 cell3.CB_0.config_dataB\[14\]
+ sky130_fd_sc_hd__dfstp_1
XFILLER_125_783 vssd1 vssd1 vccd1 vccd1 sky130_fd_sc_hd__fill_1
XTAP_TAPCELL_ROW_55_1133 vssd1 vccd1 sky130_fd_sc_hd__tapvpwrvgnd_1
XFILLER_140_731 vccd1 vssd1 vccd1 vssd1 sky130_ef_sc_hd__decap_40_12
Xfanout809 net811 vssd1 vssd1 vccd1 vccd1 net809 sky130_fd_sc_hd__clkbuf_4
XANTENNA__06979__A net81 vssd1 vssd1 vccd1 vccd1 sky130_fd_sc_hd__diode_2
XANTENNA__10380__A3 net302 vssd1 vssd1 vccd1 vccd1 sky130_fd_sc_hd__diode_2
XFILLER_97_155 vssd1 vssd1 vccd1 vccd1 sky130_fd_sc_hd__fill_2
XFILLER_85_306 vssd1 vssd1 vccd1 vccd1 sky130_fd_sc_hd__fill_2
XANTENNA__10117__A0 net36 vssd1 vssd1 vccd1 vccd1 sky130_fd_sc_hd__diode_2
XFILLER_100_639 vssd1 vssd1 vccd1 vccd1 sky130_fd_sc_hd__fill_1
XANTENNA__07146__Y _02208_ vssd1 vssd1 vccd1 vccd1 sky130_fd_sc_hd__diode_2
X_08740_ _03477_ _03772_ _03773_ _03473_ cell1.CB_1.config_dataB\[17\] vssd1 vssd1
+ vccd1 vccd1 _03774_ sky130_fd_sc_hd__a221o_1
XFILLER_78_391 vssd1 vssd1 vccd1 vccd1 sky130_fd_sc_hd__fill_2
X_08671_ net460 net462 vssd1 vssd1 vccd1 vccd1 _03705_ sky130_fd_sc_hd__nor2_1
X_07622_ net354 _02624_ bus2_0\[1\] vssd1 vssd1 vccd1 vccd1 _02671_ sky130_fd_sc_hd__o21ai_1
X_07553_ cell2.SB0.route_sel\[121\] cell2.SB0.route_sel\[120\] vssd1 vssd1 vccd1 vccd1
+ _02604_ sky130_fd_sc_hd__nand2b_1
XFILLER_81_589 vssd1 vssd1 vccd1 vccd1 sky130_fd_sc_hd__fill_1
X_07484_ net818 _02536_ vssd1 vssd1 vccd1 vccd1 _02537_ sky130_fd_sc_hd__or2_1
XTAP_TAPCELL_ROW_66_1295 vssd1 vccd1 sky130_fd_sc_hd__tapvpwrvgnd_1
X_06504_ cell0.CB_0.config_dataA\[14\] vssd1 vssd1 vccd1 vccd1 _01574_ sky130_fd_sc_hd__inv_2
XTAP_TAPCELL_ROW_45_990 vssd1 vccd1 sky130_fd_sc_hd__tapvpwrvgnd_1
XFILLER_21_111 vssd1 vssd1 vccd1 vccd1 sky130_fd_sc_hd__fill_1
X_09223_ cell2.SB0.route_sel\[11\] cell2.SB0.route_sel\[10\] _04242_ _04248_ _04249_
+ vssd1 vssd1 vccd1 vccd1 _04250_ sky130_fd_sc_hd__a221o_1
XFILLER_42_29 vccd1 vssd1 vccd1 vssd1 sky130_ef_sc_hd__decap_40_12
X_06435_ cell1.SB0.route_sel\[18\] vssd1 vssd1 vccd1 vccd1 _01505_ sky130_fd_sc_hd__inv_2
X_09154_ _02030_ _02623_ _02630_ _02901_ vssd1 vssd1 vccd1 vccd1 _04182_ sky130_fd_sc_hd__a211o_1
X_08105_ _03138_ _03144_ _01561_ vssd1 vssd1 vccd1 vccd1 _03147_ sky130_fd_sc_hd__mux2_1
XANTENNA_clkbuf_4_3_0_clk_X clknet_4_3_0_clk vssd1 vssd1 vccd1 vccd1 sky130_fd_sc_hd__diode_2
X_09085_ _04113_ _04114_ cell1.CB_0.config_dataB\[12\] vssd1 vssd1 vccd1 vccd1 _04115_
+ sky130_fd_sc_hd__or3b_1
X_08036_ cell0.CB_0.config_dataB\[3\] cell0.CB_0.config_dataB\[2\] vssd1 vssd1 vccd1
+ vccd1 _03078_ sky130_fd_sc_hd__nor2_1
Xinput90 SBsouth_in[3] vssd1 vssd1 vccd1 vccd1 net90 sky130_fd_sc_hd__dlymetal6s2s_1
XFILLER_116_772 vssd1 vssd1 vccd1 vccd1 sky130_fd_sc_hd__fill_1
XANTENNA_fanout696_A net700 vssd1 vssd1 vccd1 vccd1 sky130_fd_sc_hd__diode_2
XANTENNA__09536__Y _04555_ vssd1 vssd1 vccd1 vccd1 sky130_fd_sc_hd__diode_2
XANTENNA__08013__A2 net350 vssd1 vssd1 vccd1 vccd1 sky130_fd_sc_hd__diode_2
XFILLER_1_505 vccd1 vssd1 vccd1 vssd1 sky130_ef_sc_hd__decap_40_12
X_09987_ cell2.LEI0.config_data\[22\] _04987_ _04990_ vssd1 vssd1 vccd1 vccd1 _04991_
+ sky130_fd_sc_hd__o21a_1
XANTENNA_fanout863_A net884 vssd1 vssd1 vccd1 vccd1 sky130_fd_sc_hd__diode_2
X_08938_ _03969_ _03937_ _03902_ vssd1 vssd1 vccd1 vccd1 _03970_ sky130_fd_sc_hd__mux2_1
XTAP_TAPCELL_ROW_86_1605 vssd1 vccd1 sky130_fd_sc_hd__tapvpwrvgnd_1
X_08869_ cell1.LEI0.config_data\[14\] _03900_ vssd1 vssd1 vccd1 vccd1 _03901_ sky130_fd_sc_hd__nand2b_1
XTAP_TAPCELL_ROW_4_365 vssd1 vccd1 sky130_fd_sc_hd__tapvpwrvgnd_1
XANTENNA_fanout749_X net749 vssd1 vssd1 vccd1 vccd1 sky130_fd_sc_hd__diode_2
XFILLER_123_65 vssd1 vssd1 vccd1 vccd1 sky130_fd_sc_hd__fill_2
X_10900_ cell3.SB0.route_sel\[101\] cell3.SB0.route_sel\[100\] vssd1 vssd1 vccd1 vccd1
+ _05854_ sky130_fd_sc_hd__and2b_1
XANTENNA__08721__A0 net31 vssd1 vssd1 vccd1 vccd1 sky130_fd_sc_hd__diode_2
XFILLER_84_383 vssd1 vssd1 vccd1 vccd1 sky130_fd_sc_hd__fill_1
XFILLER_72_545 vssd1 vssd1 vccd1 vccd1 sky130_fd_sc_hd__fill_1
XFILLER_45_748 vssd1 vssd1 vccd1 vccd1 sky130_fd_sc_hd__fill_1
X_11880_ net466 net467 net881 vssd1 vssd1 vccd1 vccd1 _00317_ sky130_fd_sc_hd__mux2_1
XFILLER_44_225 vssd1 vssd1 vccd1 vccd1 sky130_fd_sc_hd__fill_1
XANTENNA__07072__X _02136_ vssd1 vssd1 vccd1 vccd1 sky130_fd_sc_hd__diode_2
X_10831_ cell3.CB_1.config_dataB\[14\] _05776_ _05786_ vssd1 vssd1 vccd1 vccd1 _05787_
+ sky130_fd_sc_hd__nor3_1
XFILLER_16_41 vccd1 vssd1 vccd1 vssd1 sky130_ef_sc_hd__decap_40_12
X_10762_ _01777_ _05705_ _05706_ _05713_ _05717_ vssd1 vssd1 vccd1 vccd1 _05718_ sky130_fd_sc_hd__o311a_1
X_13550_ clknet_leaf_90_clk _00522_ net699 vssd1 vssd1 vccd1 vccd1 cell1.LE_0B.config_data\[15\]
+ sky130_fd_sc_hd__dfrtp_1
XANTENNA__07827__A2 bus2_0\[14\] vssd1 vssd1 vccd1 vccd1 sky130_fd_sc_hd__diode_2
XTAP_TAPCELL_ROW_43_949 vssd1 vccd1 sky130_fd_sc_hd__tapvpwrvgnd_1
XPHY_EDGE_ROW_11_Right_11 vssd1 vssd1 vccd1 vccd1 sky130_fd_sc_hd__decap_3
X_12501_ net1544 cell2.LEI0.config_data\[14\] net841 vssd1 vssd1 vccd1 vccd1 _00930_
+ sky130_fd_sc_hd__mux2_1
XANTENNA__14119__Q net262 vssd1 vssd1 vccd1 vccd1 sky130_fd_sc_hd__diode_2
XANTENNA__09029__A1 bus3_1\[7\] vssd1 vssd1 vccd1 vccd1 sky130_fd_sc_hd__diode_2
X_13481_ clknet_leaf_10_clk _00453_ net569 vssd1 vssd1 vccd1 vccd1 cell0.SB0.route_sel\[122\]
+ sky130_fd_sc_hd__dfstp_1
X_12432_ net1391 net1315 net849 vssd1 vssd1 vccd1 vccd1 _00864_ sky130_fd_sc_hd__mux2_1
X_10693_ _01792_ _05648_ _05650_ vssd1 vssd1 vccd1 vccd1 _05651_ sky130_fd_sc_hd__a21oi_1
XFILLER_9_627 vccd1 vssd1 vccd1 vssd1 sky130_ef_sc_hd__decap_40_12
XFILLER_13_689 vssd1 vssd1 vccd1 vccd1 sky130_fd_sc_hd__fill_1
XTAP_TAPCELL_ROW_23_651 vssd1 vccd1 sky130_fd_sc_hd__tapvpwrvgnd_1
XFILLER_8_137 vssd1 vssd1 vccd1 vccd1 sky130_fd_sc_hd__fill_2
XFILLER_32_73 vssd1 vssd1 vccd1 vccd1 sky130_fd_sc_hd__fill_1
XTAP_TAPCELL_ROW_97_1767 vssd1 vccd1 sky130_fd_sc_hd__tapvpwrvgnd_1
XTAP_TAPCELL_ROW_97_1756 vssd1 vccd1 sky130_fd_sc_hd__tapvpwrvgnd_1
XANTENNA__07055__A3 net128 vssd1 vssd1 vccd1 vccd1 sky130_fd_sc_hd__diode_2
X_12363_ cell1.SB0.route_sel\[101\] cell1.SB0.route_sel\[100\] net869 vssd1 vssd1
+ vccd1 vccd1 _00796_ sky130_fd_sc_hd__mux2_1
X_14102_ clknet_leaf_50_clk _01074_ net711 vssd1 vssd1 vccd1 vccd1 cell3.SB0.route_sel\[110\]
+ sky130_fd_sc_hd__dfstp_1
X_11314_ _04592_ _05540_ vssd1 vssd1 vccd1 vccd1 _06222_ sky130_fd_sc_hd__and2b_1
X_12294_ cell1.SB0.route_sel\[32\] cell1.SB0.route_sel\[31\] net857 vssd1 vssd1 vccd1
+ vccd1 _00727_ sky130_fd_sc_hd__mux2_1
XFILLER_107_772 vssd1 vssd1 vccd1 vccd1 sky130_fd_sc_hd__fill_1
X_14033_ clknet_leaf_50_clk _01005_ net705 vssd1 vssd1 vccd1 vccd1 cell3.SB0.route_sel\[41\]
+ sky130_fd_sc_hd__dfstp_2
X_11245_ clknet_leaf_89_clk cell1.LE_1A.edge_mode vssd1 vssd1 vccd1 vccd1 cell1.LE_1A.sel_clk
+ sky130_fd_sc_hd__xnor2_2
XFILLER_79_111 vssd1 vssd1 vccd1 vccd1 sky130_fd_sc_hd__fill_1
XPHY_EDGE_ROW_20_Right_20 vssd1 vssd1 vccd1 vccd1 sky130_fd_sc_hd__decap_3
XANTENNA_input45_X net45 vssd1 vssd1 vccd1 vccd1 sky130_fd_sc_hd__diode_2
X_11176_ net384 _06126_ _06127_ vssd1 vssd1 vccd1 vccd1 _06128_ sky130_fd_sc_hd__a21oi_1
XANTENNA__13123__SET_B net584 vssd1 vssd1 vccd1 vccd1 sky130_fd_sc_hd__diode_2
XTAP_TAPCELL_ROW_128_2233 vssd1 vccd1 sky130_fd_sc_hd__tapvpwrvgnd_1
XTAP_TAPCELL_ROW_128_2222 vssd1 vccd1 sky130_fd_sc_hd__tapvpwrvgnd_1
X_10127_ _02008_ _05127_ vssd1 vssd1 vccd1 vccd1 _05128_ sky130_fd_sc_hd__nand2_4
X_10058_ cell2.CB_1.config_dataB\[19\] _05047_ _05061_ vssd1 vssd1 vccd1 vccd1 _05062_
+ sky130_fd_sc_hd__or3_1
XTAP_TAPCELL_ROW_50_1063 vssd1 vccd1 sky130_fd_sc_hd__tapvpwrvgnd_1
XTAP_TAPCELL_ROW_50_1052 vssd1 vccd1 sky130_fd_sc_hd__tapvpwrvgnd_1
XTAP_TAPCELL_ROW_141_2422 vssd1 vccd1 sky130_fd_sc_hd__tapvpwrvgnd_1
XFILLER_63_501 vssd1 vssd1 vccd1 vccd1 sky130_fd_sc_hd__fill_2
XFILLER_23_409 vssd1 vssd1 vccd1 vccd1 sky130_fd_sc_hd__fill_1
X_13817_ clknet_leaf_104_clk _00789_ net662 vssd1 vssd1 vccd1 vccd1 cell1.SB0.route_sel\[94\]
+ sky130_fd_sc_hd__dfstp_1
XTAP_TAPCELL_ROW_106_1896 vssd1 vccd1 sky130_fd_sc_hd__tapvpwrvgnd_1
XANTENNA__07142__B _02032_ vssd1 vssd1 vccd1 vccd1 sky130_fd_sc_hd__diode_2
X_13748_ clknet_leaf_107_clk _00720_ net652 vssd1 vssd1 vccd1 vccd1 cell1.SB0.route_sel\[25\]
+ sky130_fd_sc_hd__dfstp_2
XANTENNA__10822__A1 _05531_ vssd1 vssd1 vccd1 vccd1 sky130_fd_sc_hd__diode_2
XANTENNA__14029__Q cell3.SB0.route_sel\[37\] vssd1 vssd1 vccd1 vccd1 sky130_fd_sc_hd__diode_2
XFILLER_31_453 vssd1 vssd1 vccd1 vccd1 sky130_fd_sc_hd__fill_2
X_13679_ clknet_leaf_30_clk _00651_ net620 vssd1 vssd1 vccd1 vccd1 cell2.CB_0.config_dataB\[6\]
+ sky130_fd_sc_hd__dfstp_1
XFILLER_85_3 vssd1 vssd1 vccd1 vccd1 sky130_fd_sc_hd__fill_4
XTAP_TAPCELL_ROW_139_2395 vssd1 vccd1 sky130_fd_sc_hd__tapvpwrvgnd_1
XANTENNA__09425__D1 cell3.SB0.route_sel\[44\] vssd1 vssd1 vccd1 vccd1 sky130_fd_sc_hd__diode_2
XANTENNA__12047__Y _06377_ vssd1 vssd1 vccd1 vccd1 sky130_fd_sc_hd__diode_2
XANTENNA__09991__A2 _04696_ vssd1 vssd1 vccd1 vccd1 sky130_fd_sc_hd__diode_2
Xhold126 cell0.LE_0A.config_data\[15\] vssd1 vssd1 vccd1 vccd1 net1085 sky130_fd_sc_hd__dlygate4sd3_1
Xhold104 cell0.LE_0A.config_data\[6\] vssd1 vssd1 vccd1 vccd1 net1063 sky130_fd_sc_hd__dlygate4sd3_1
Xhold115 cell1.LEI0.config_data\[32\] vssd1 vssd1 vccd1 vccd1 net1074 sky130_fd_sc_hd__dlygate4sd3_1
XFILLER_8_693 vssd1 vssd1 vccd1 vccd1 sky130_fd_sc_hd__fill_4
XFILLER_7_181 vssd1 vssd1 vccd1 vccd1 sky130_fd_sc_hd__fill_2
XANTENNA__07451__B1 net335 vssd1 vssd1 vccd1 vccd1 sky130_fd_sc_hd__diode_2
Xhold148 cell3.LE_0A.config_data\[10\] vssd1 vssd1 vccd1 vccd1 net1107 sky130_fd_sc_hd__dlygate4sd3_1
Xhold137 _00947_ vssd1 vssd1 vccd1 vccd1 net1096 sky130_fd_sc_hd__dlygate4sd3_1
X_09910_ cell2.LE_1A.config_data\[9\] cell2.LE_1A.config_data\[8\] _04831_ vssd1 vssd1
+ vccd1 vccd1 _04916_ sky130_fd_sc_hd__mux2_1
Xhold159 cell0.LE_0A.config_data\[12\] vssd1 vssd1 vccd1 vccd1 net1118 sky130_fd_sc_hd__dlygate4sd3_1
XFILLER_113_742 vssd1 vssd1 vccd1 vccd1 sky130_fd_sc_hd__fill_1
Xfanout606 net623 vssd1 vssd1 vccd1 vccd1 net606 sky130_fd_sc_hd__dlymetal6s2s_1
Xfanout639 net640 vssd1 vssd1 vccd1 vccd1 net639 sky130_fd_sc_hd__buf_2
XANTENNA_clkload14_A clknet_4_15_0_clk vssd1 vssd1 vccd1 vccd1 sky130_fd_sc_hd__diode_2
Xfanout617 net619 vssd1 vssd1 vccd1 vccd1 net617 sky130_fd_sc_hd__clkbuf_4
Xfanout628 net632 vssd1 vssd1 vccd1 vccd1 net628 sky130_fd_sc_hd__clkbuf_4
X_09841_ cell2.CB_1.config_dataA\[12\] _04845_ _04846_ _04839_ vssd1 vssd1 vccd1 vccd1
+ _04847_ sky130_fd_sc_hd__o31a_1
XFILLER_86_604 vssd1 vssd1 vccd1 vccd1 sky130_fd_sc_hd__fill_2
X_09772_ _04777_ vssd1 vssd1 vccd1 vccd1 _04778_ sky130_fd_sc_hd__inv_2
X_06984_ cell1.CB_1.config_dataA\[24\] cell1.CB_1.config_dataA\[21\] cell1.CB_1.config_dataA\[20\]
+ vssd1 vssd1 vccd1 vccd1 _02050_ sky130_fd_sc_hd__or3_2
X_08723_ _03755_ _03756_ cell1.CB_1.config_dataB\[12\] vssd1 vssd1 vccd1 vccd1 _03757_
+ sky130_fd_sc_hd__mux2_1
XANTENNA__10959__A _05912_ vssd1 vssd1 vccd1 vccd1 sky130_fd_sc_hd__diode_2
XFILLER_85_169 vssd1 vssd1 vccd1 vccd1 sky130_fd_sc_hd__fill_8
XTAP_TAPCELL_ROW_1_324 vssd1 vccd1 sky130_fd_sc_hd__tapvpwrvgnd_1
XFILLER_81_331 vssd1 vssd1 vccd1 vccd1 sky130_fd_sc_hd__fill_1
XTAP_TAPCELL_ROW_68_1335 vssd1 vccd1 sky130_fd_sc_hd__tapvpwrvgnd_1
XTAP_TAPCELL_ROW_68_1324 vssd1 vccd1 sky130_fd_sc_hd__tapvpwrvgnd_1
X_08654_ net4 net5 net6 net7 net459 cell1.CB_1.config_dataB\[6\] vssd1 vssd1 vccd1
+ vccd1 _03688_ sky130_fd_sc_hd__mux4_1
XFILLER_26_214 vssd1 vssd1 vccd1 vccd1 sky130_fd_sc_hd__fill_1
X_08585_ _03584_ _03620_ _03583_ vssd1 vssd1 vccd1 vccd1 _03621_ sky130_fd_sc_hd__mux2_1
X_07605_ cell1.SB0.route_sel\[0\] cell1.SB0.route_sel\[1\] _02645_ _02654_ net885
+ vssd1 vssd1 vccd1 vccd1 _02655_ sky130_fd_sc_hd__a311o_2
X_07536_ cell2.SB0.route_sel\[125\] cell2.SB0.route_sel\[124\] _02551_ vssd1 vssd1
+ vccd1 vccd1 _02587_ sky130_fd_sc_hd__a21bo_1
XTAP_TAPCELL_ROW_81_1524 vssd1 vccd1 sky130_fd_sc_hd__tapvpwrvgnd_1
XFILLER_139_105 vssd1 vssd1 vccd1 vccd1 sky130_fd_sc_hd__fill_4
XTAP_TAPCELL_ROW_40_908 vssd1 vccd1 sky130_fd_sc_hd__tapvpwrvgnd_1
X_07467_ net302 _02519_ vssd1 vssd1 vccd1 vccd1 _02520_ sky130_fd_sc_hd__nor2_1
X_09206_ _01686_ _01687_ vssd1 vssd1 vccd1 vccd1 _04233_ sky130_fd_sc_hd__nor2_1
XFILLER_22_464 vssd1 vssd1 vccd1 vccd1 sky130_fd_sc_hd__fill_2
X_07398_ cell0.SB0.route_sel\[110\] cell0.SB0.route_sel\[111\] vssd1 vssd1 vccd1 vccd1
+ _02453_ sky130_fd_sc_hd__nand2b_1
X_06418_ cell0.SB0.route_sel\[124\] vssd1 vssd1 vccd1 vccd1 _01488_ sky130_fd_sc_hd__inv_2
XTAP_TAPCELL_ROW_20_610 vssd1 vccd1 sky130_fd_sc_hd__tapvpwrvgnd_1
XANTENNA__10577__A0 net21 vssd1 vssd1 vccd1 vccd1 sky130_fd_sc_hd__diode_2
X_09137_ cell1.LE_0B.config_data\[9\] cell1.LE_0B.config_data\[8\] _04086_ vssd1 vssd1
+ vccd1 vccd1 _04167_ sky130_fd_sc_hd__mux2_1
XFILLER_118_21 vssd1 vssd1 vccd1 vccd1 sky130_fd_sc_hd__fill_4
XTAP_TAPCELL_ROW_79_1486 vssd1 vccd1 sky130_fd_sc_hd__tapvpwrvgnd_1
X_09068_ net480 _03817_ _04097_ cell1.CB_0.config_dataB\[11\] vssd1 vssd1 vccd1 vccd1
+ _04098_ sky130_fd_sc_hd__o211a_1
XTAP_TAPCELL_ROW_79_1497 vssd1 vccd1 sky130_fd_sc_hd__tapvpwrvgnd_1
X_08019_ net532 net534 vssd1 vssd1 vccd1 vccd1 _03061_ sky130_fd_sc_hd__and2b_1
XFILLER_2_825 vssd1 vssd1 vccd1 vccd1 sky130_fd_sc_hd__fill_4
XTAP_TAPCELL_ROW_9_446 vssd1 vccd1 sky130_fd_sc_hd__tapvpwrvgnd_1
X_11030_ net374 _05982_ _05983_ vssd1 vssd1 vccd1 vccd1 _05984_ sky130_fd_sc_hd__a21oi_1
XTAP_TAPCELL_ROW_92_1686 vssd1 vccd1 sky130_fd_sc_hd__tapvpwrvgnd_1
XFILLER_1_335 vssd1 vssd1 vccd1 vccd1 sky130_fd_sc_hd__fill_1
XFILLER_134_53 vccd1 vssd1 vccd1 vssd1 sky130_ef_sc_hd__decap_40_12
XFILLER_76_158 vccd1 vssd1 vccd1 vssd1 sky130_ef_sc_hd__decap_40_12
XFILLER_76_136 vssd1 vssd1 vccd1 vccd1 sky130_fd_sc_hd__fill_2
X_12981_ cell3.LEI0.config_data\[2\] net1394 net945 vssd1 vssd1 vccd1 vccd1 _01409_
+ sky130_fd_sc_hd__mux2_1
XFILLER_73_843 vssd1 vssd1 vccd1 vccd1 sky130_fd_sc_hd__fill_1
XFILLER_27_51 vssd1 vssd1 vccd1 vccd1 sky130_fd_sc_hd__fill_4
XTAP_TAPCELL_ROW_28_721 vssd1 vccd1 sky130_fd_sc_hd__tapvpwrvgnd_1
XTAP_TAPCELL_ROW_28_732 vssd1 vccd1 sky130_fd_sc_hd__tapvpwrvgnd_1
X_11932_ cell0.SB0.route_sel\[38\] cell0.SB0.route_sel\[37\] net758 vssd1 vssd1 vccd1
+ vccd1 _00369_ sky130_fd_sc_hd__mux2_1
XTAP_TAPCELL_ROW_123_2152 vssd1 vccd1 sky130_fd_sc_hd__tapvpwrvgnd_1
X_11863_ cell1.CB_0.config_dataB\[19\] cell1.CB_0.config_dataB\[18\] net898 vssd1
+ vssd1 vccd1 vccd1 _00300_ sky130_fd_sc_hd__mux2_1
XANTENNA__11057__B2 _05898_ vssd1 vssd1 vccd1 vccd1 sky130_fd_sc_hd__diode_2
X_10814_ net8 net9 net10 net11 cell3.CB_1.config_dataB\[10\] cell3.CB_1.config_dataB\[11\]
+ vssd1 vssd1 vccd1 vccd1 _05770_ sky130_fd_sc_hd__mux4_1
X_13602_ clknet_leaf_95_clk net1339 net686 vssd1 vssd1 vccd1 vccd1 cell1.LEI0.config_data\[23\]
+ sky130_fd_sc_hd__dfrtp_1
XANTENNA__10804__A1 _05475_ vssd1 vssd1 vccd1 vccd1 sky130_fd_sc_hd__diode_2
XANTENNA__10875__Y _05831_ vssd1 vssd1 vccd1 vccd1 sky130_fd_sc_hd__diode_2
X_11794_ net1374 net1335 net792 vssd1 vssd1 vccd1 vccd1 _00231_ sky130_fd_sc_hd__mux2_1
XFILLER_13_420 vssd1 vssd1 vccd1 vccd1 sky130_fd_sc_hd__fill_1
XANTENNA__07530__X bus1_0\[15\] vssd1 vssd1 vccd1 vccd1 sky130_fd_sc_hd__diode_2
X_10745_ _01778_ net370 _05553_ _01777_ vssd1 vssd1 vccd1 vccd1 _05701_ sky130_fd_sc_hd__o31ai_1
X_13533_ clknet_1_1__leaf_cell1.LE_1B.sel_clk _00505_ net753 vssd1 vssd1 vccd1 vccd1
+ cell1.LE_1B.dff1_out sky130_fd_sc_hd__dfstp_1
XANTENNA__07276__A3 net100 vssd1 vssd1 vccd1 vccd1 sky130_fd_sc_hd__diode_2
X_10676_ cell3.LEI0.config_data\[31\] _05633_ vssd1 vssd1 vccd1 vccd1 _05634_ sky130_fd_sc_hd__nor2_1
XANTENNA__10280__A2 _05131_ vssd1 vssd1 vccd1 vccd1 sky130_fd_sc_hd__diode_2
X_13464_ clknet_leaf_3_clk _00436_ net565 vssd1 vssd1 vccd1 vccd1 cell0.SB0.route_sel\[105\]
+ sky130_fd_sc_hd__dfstp_2
XANTENNA_output196_A net196 vssd1 vssd1 vccd1 vccd1 sky130_fd_sc_hd__diode_2
X_12415_ net755 _05078_ vssd1 vssd1 vccd1 vccd1 _06381_ sky130_fd_sc_hd__nand2_1
XANTENNA__12557__A1 cell3.SB0.route_sel\[21\] vssd1 vssd1 vccd1 vccd1 sky130_fd_sc_hd__diode_2
X_13395_ clknet_leaf_1_clk _00367_ net554 vssd1 vssd1 vccd1 vccd1 cell0.SB0.route_sel\[36\]
+ sky130_fd_sc_hd__dfstp_1
XANTENNA__10032__A2 bus3_2\[10\] vssd1 vssd1 vccd1 vccd1 sky130_fd_sc_hd__diode_2
XANTENNA__10568__B1 cell3.SB0.route_sel\[101\] vssd1 vssd1 vccd1 vccd1 sky130_fd_sc_hd__diode_2
XANTENNA__07433__B1 bus2_0\[14\] vssd1 vssd1 vccd1 vccd1 sky130_fd_sc_hd__diode_2
XFILLER_5_641 vccd1 vssd1 vccd1 vssd1 sky130_ef_sc_hd__decap_40_12
X_12346_ cell1.SB0.route_sel\[84\] cell1.SB0.route_sel\[83\] net862 vssd1 vssd1 vccd1
+ vccd1 _00779_ sky130_fd_sc_hd__mux2_1
XANTENNA__09973__A2 bus3_2\[13\] vssd1 vssd1 vccd1 vccd1 sky130_fd_sc_hd__diode_2
XANTENNA__07984__A1 cell0.LE_0A.config_data\[16\] vssd1 vssd1 vccd1 vccd1 sky130_fd_sc_hd__diode_2
Xoutput209 net209 vssd1 vssd1 vccd1 vccd1 SBsouth_out[1] sky130_fd_sc_hd__buf_2
X_12277_ cell1.SB0.route_sel\[15\] cell1.SB0.route_sel\[14\] net864 vssd1 vssd1 vccd1
+ vccd1 _00710_ sky130_fd_sc_hd__mux2_1
XFILLER_5_685 vccd1 vssd1 vccd1 vssd1 sky130_ef_sc_hd__decap_40_12
X_11228_ cell3.LE_0B.config_data\[8\] cell3.LE_0B.config_data\[9\] _06076_ vssd1 vssd1
+ vccd1 vccd1 _06180_ sky130_fd_sc_hd__mux2_1
X_14016_ clknet_leaf_80_clk _00988_ net707 vssd1 vssd1 vccd1 vccd1 cell3.SB0.route_sel\[24\]
+ sky130_fd_sc_hd__dfstp_1
XFILLER_4_195 vssd1 vssd1 vccd1 vccd1 sky130_fd_sc_hd__fill_1
XFILLER_4_77 vssd1 vssd1 vccd1 vccd1 sky130_fd_sc_hd__fill_4
X_11159_ net49 net50 net51 net52 net385 cell3.CB_0.config_dataB\[11\] vssd1 vssd1
+ vccd1 vccd1 _06111_ sky130_fd_sc_hd__mux4_1
XFILLER_122_583 vssd1 vssd1 vccd1 vccd1 sky130_fd_sc_hd__fill_1
XANTENNA__10740__A0 net21 vssd1 vssd1 vccd1 vccd1 sky130_fd_sc_hd__diode_2
XANTENNA__10779__A _05553_ vssd1 vssd1 vccd1 vccd1 sky130_fd_sc_hd__diode_2
XFILLER_95_478 vssd1 vssd1 vccd1 vccd1 sky130_fd_sc_hd__fill_2
XFILLER_67_169 vssd1 vssd1 vccd1 vccd1 sky130_fd_sc_hd__fill_1
XANTENNA__10099__A2 _05096_ vssd1 vssd1 vccd1 vccd1 sky130_fd_sc_hd__diode_2
XTAP_TAPCELL_ROW_108_1925 vssd1 vccd1 sky130_fd_sc_hd__tapvpwrvgnd_1
XFILLER_48_383 vssd1 vssd1 vccd1 vccd1 sky130_fd_sc_hd__fill_1
X_08370_ net504 _02761_ vssd1 vssd1 vccd1 vccd1 _03408_ sky130_fd_sc_hd__nand2_1
XFILLER_23_217 vssd1 vssd1 vccd1 vccd1 sky130_fd_sc_hd__fill_1
X_07321_ _02377_ vssd1 vssd1 vccd1 vccd1 _02378_ sky130_fd_sc_hd__inv_2
XFILLER_90_194 vssd1 vssd1 vccd1 vccd1 sky130_fd_sc_hd__fill_2
XFILLER_23_239 vssd1 vssd1 vccd1 vccd1 sky130_fd_sc_hd__fill_1
XANTENNA__09661__A1 _04668_ vssd1 vssd1 vccd1 vccd1 sky130_fd_sc_hd__diode_2
XTAP_TAPCELL_ROW_63_1254 vssd1 vccd1 sky130_fd_sc_hd__tapvpwrvgnd_1
X_07252_ _01995_ _02088_ vssd1 vssd1 vccd1 vccd1 _02311_ sky130_fd_sc_hd__or2_2
XFILLER_136_119 vssd1 vssd1 vccd1 vccd1 sky130_fd_sc_hd__fill_1
X_07183_ _02243_ vssd1 vssd1 vccd1 vccd1 _02244_ sky130_fd_sc_hd__inv_2
XFILLER_105_517 vssd1 vssd1 vccd1 vccd1 sky130_fd_sc_hd__fill_1
XFILLER_105_539 vssd1 vssd1 vccd1 vccd1 sky130_fd_sc_hd__fill_1
Xfanout414 cell2.CB_0.config_dataA\[11\] vssd1 vssd1 vccd1 vccd1 net414 sky130_fd_sc_hd__clkbuf_2
Xfanout403 cell2.CB_1.config_dataB\[10\] vssd1 vssd1 vccd1 vccd1 net403 sky130_fd_sc_hd__buf_2
XTAP_TAPCELL_ROW_6_405 vssd1 vccd1 sky130_fd_sc_hd__tapvpwrvgnd_1
Xfanout436 cell2.CB_0.config_dataB\[0\] vssd1 vssd1 vccd1 vccd1 net436 sky130_fd_sc_hd__buf_2
Xfanout425 cell2.CB_0.config_dataB\[15\] vssd1 vssd1 vccd1 vccd1 net425 sky130_fd_sc_hd__clkbuf_2
X_09824_ cell2.CB_1.config_dataA\[3\] cell2.CB_1.config_dataA\[2\] cell2.CB_1.config_dataA\[4\]
+ _04792_ vssd1 vssd1 vccd1 vccd1 _04830_ sky130_fd_sc_hd__or4bb_1
Xfanout447 cell2.CB_1.config_dataA\[0\] vssd1 vssd1 vccd1 vccd1 net447 sky130_fd_sc_hd__buf_2
XANTENNA__07047__B net355 vssd1 vssd1 vccd1 vccd1 sky130_fd_sc_hd__diode_2
XFILLER_98_294 vssd1 vssd1 vccd1 vccd1 sky130_fd_sc_hd__fill_2
XFILLER_86_434 vssd1 vssd1 vccd1 vccd1 sky130_fd_sc_hd__fill_2
Xfanout469 cell1.CB_0.config_dataA\[6\] vssd1 vssd1 vccd1 vccd1 net469 sky130_fd_sc_hd__buf_2
Xfanout458 cell1.CB_1.config_dataB\[5\] vssd1 vssd1 vccd1 vccd1 net458 sky130_fd_sc_hd__clkbuf_2
X_09755_ _04527_ _04759_ _04760_ _04756_ vssd1 vssd1 vccd1 vccd1 _04761_ sky130_fd_sc_hd__o211a_1
XFILLER_58_169 vssd1 vssd1 vccd1 vccd1 sky130_fd_sc_hd__fill_1
X_06967_ _02031_ _02032_ vssd1 vssd1 vccd1 vccd1 _02033_ sky130_fd_sc_hd__nor2_1
X_09686_ _04307_ _04646_ vssd1 vssd1 vccd1 vccd1 _04700_ sky130_fd_sc_hd__nor2_1
XANTENNA__07334__Y _02391_ vssd1 vssd1 vccd1 vccd1 sky130_fd_sc_hd__diode_2
XFILLER_39_383 vssd1 vssd1 vccd1 vccd1 sky130_fd_sc_hd__fill_1
XFILLER_39_372 vssd1 vssd1 vccd1 vccd1 sky130_fd_sc_hd__fill_1
X_06898_ net321 net30 _01963_ vssd1 vssd1 vccd1 vccd1 _01966_ sky130_fd_sc_hd__mux2_1
X_08706_ _03517_ _03514_ _03504_ _03510_ net455 net454 vssd1 vssd1 vccd1 vccd1 _03740_
+ sky130_fd_sc_hd__mux4_1
XFILLER_104_89 vssd1 vssd1 vccd1 vccd1 sky130_fd_sc_hd__fill_1
XFILLER_64_38 vssd1 vssd1 vccd1 vccd1 sky130_fd_sc_hd__fill_1
X_08637_ net457 net458 vssd1 vssd1 vccd1 vccd1 _03671_ sky130_fd_sc_hd__nor2_1
XANTENNA_fanout826_A net827 vssd1 vssd1 vccd1 vccd1 sky130_fd_sc_hd__diode_2
XANTENNA__10976__X _05930_ vssd1 vssd1 vccd1 vccd1 sky130_fd_sc_hd__diode_2
XFILLER_14_206 vssd1 vssd1 vccd1 vccd1 sky130_fd_sc_hd__fill_4
XANTENNA__09101__A0 bus3_1\[0\] vssd1 vssd1 vccd1 vccd1 sky130_fd_sc_hd__diode_2
X_08568_ net491 net490 _03498_ _03603_ cell1.CB_1.config_dataA\[12\] vssd1 vssd1 vccd1
+ vccd1 _03604_ sky130_fd_sc_hd__o311a_1
XANTENNA__09652__A1 net330 vssd1 vssd1 vccd1 vccd1 sky130_fd_sc_hd__diode_2
X_07519_ _02565_ _02570_ vssd1 vssd1 vccd1 vccd1 _02571_ sky130_fd_sc_hd__nor2_1
X_08499_ cell1.SB0.route_sel\[40\] cell1.SB0.route_sel\[41\] vssd1 vssd1 vccd1 vccd1
+ _03535_ sky130_fd_sc_hd__nand2b_1
XANTENNA__08455__A2 _03486_ vssd1 vssd1 vccd1 vccd1 sky130_fd_sc_hd__diode_2
X_10530_ _01701_ cell3.SB0.route_sel\[39\] _05487_ vssd1 vssd1 vccd1 vccd1 _05488_
+ sky130_fd_sc_hd__o21ai_2
XFILLER_10_434 vssd1 vssd1 vccd1 vccd1 sky130_fd_sc_hd__fill_1
X_10461_ cell3.SB0.route_sel\[88\] cell3.SB0.route_sel\[89\] cell3.SB0.route_sel\[92\]
+ _01735_ _05447_ vssd1 vssd1 vccd1 vccd1 _05448_ sky130_fd_sc_hd__o221a_1
XANTENNA__11211__A1 net54 vssd1 vssd1 vccd1 vccd1 sky130_fd_sc_hd__diode_2
XANTENNA__09404__A1 net301 vssd1 vssd1 vccd1 vccd1 sky130_fd_sc_hd__diode_2
X_12200_ cell2.CB_1.config_dataA\[13\] cell2.CB_1.config_dataA\[12\] net913 vssd1
+ vssd1 vccd1 vccd1 _00633_ sky130_fd_sc_hd__mux2_1
XTAP_TAPCELL_ROW_94_1715 vssd1 vccd1 sky130_fd_sc_hd__tapvpwrvgnd_1
XANTENNA__12415__Y _06381_ vssd1 vssd1 vccd1 vccd1 sky130_fd_sc_hd__diode_2
X_10392_ _02106_ _05096_ _05386_ _05385_ _05093_ vssd1 vssd1 vccd1 vccd1 _05391_ sky130_fd_sc_hd__a32o_1
XANTENNA__09955__A2 bus3_2\[1\] vssd1 vssd1 vccd1 vccd1 sky130_fd_sc_hd__diode_2
XFILLER_89_35 vssd1 vssd1 vccd1 vccd1 sky130_fd_sc_hd__fill_8
X_13180_ clknet_leaf_14_clk _00152_ net631 vssd1 vssd1 vccd1 vccd1 cell0.LE_0B.config_data\[9\]
+ sky130_fd_sc_hd__dfrtp_1
XANTENNA__07966__A1 net347 vssd1 vssd1 vccd1 vccd1 sky130_fd_sc_hd__diode_2
X_12131_ net1358 cell1.LEI0.config_data\[12\] net895 vssd1 vssd1 vccd1 vccd1 _00564_
+ sky130_fd_sc_hd__mux2_1
X_12062_ net991 cell1.LE_1A.config_data\[12\] net888 vssd1 vssd1 vccd1 vccd1 _00498_
+ sky130_fd_sc_hd__mux2_1
Xhold490 _00241_ vssd1 vssd1 vccd1 vccd1 net1449 sky130_fd_sc_hd__dlygate4sd3_1
X_11013_ net374 _05962_ _05966_ vssd1 vssd1 vccd1 vccd1 _05967_ sky130_fd_sc_hd__a21oi_1
XFILLER_77_412 vssd1 vssd1 vccd1 vccd1 sky130_fd_sc_hd__fill_4
XFILLER_2_699 vssd1 vssd1 vccd1 vccd1 sky130_fd_sc_hd__fill_1
XFILLER_1_165 vssd1 vssd1 vccd1 vccd1 sky130_fd_sc_hd__fill_2
XFILLER_38_61 vssd1 vssd1 vccd1 vccd1 sky130_fd_sc_hd__fill_2
XFILLER_18_501 vssd1 vssd1 vccd1 vccd1 sky130_fd_sc_hd__fill_8
X_12964_ cell3.LE_0A.config_data\[7\] net1190 net853 vssd1 vssd1 vccd1 vccd1 _01392_
+ sky130_fd_sc_hd__mux2_1
XANTENNA__09340__B1 net43 vssd1 vssd1 vccd1 vccd1 sky130_fd_sc_hd__diode_2
X_11915_ cell0.SB0.route_sel\[21\] cell0.SB0.route_sel\[20\] net763 vssd1 vssd1 vccd1
+ vccd1 _00352_ sky130_fd_sc_hd__mux2_1
X_12895_ cell3.CB_1.config_dataB\[9\] cell3.CB_1.config_dataB\[8\] net943 vssd1 vssd1
+ vccd1 vccd1 _01324_ sky130_fd_sc_hd__mux2_1
XANTENNA_output209_A net209 vssd1 vssd1 vccd1 vccd1 sky130_fd_sc_hd__diode_2
XANTENNA__08694__A2 _03504_ vssd1 vssd1 vccd1 vccd1 sky130_fd_sc_hd__diode_2
XANTENNA__09628__D1 cell3.SB0.route_sel\[101\] vssd1 vssd1 vccd1 vccd1 sky130_fd_sc_hd__diode_2
X_11846_ cell1.CB_0.config_dataB\[2\] net484 net919 vssd1 vssd1 vccd1 vccd1 _00283_
+ sky130_fd_sc_hd__mux2_1
XANTENNA__09643__A1 net53 vssd1 vssd1 vccd1 vccd1 sky130_fd_sc_hd__diode_2
XTAP_TAPCELL_ROW_103_1855 vssd1 vccd1 sky130_fd_sc_hd__tapvpwrvgnd_1
X_11777_ cell0.LEI0.config_data\[27\] net1441 net792 vssd1 vssd1 vccd1 vccd1 _00214_
+ sky130_fd_sc_hd__mux2_1
XANTENNA_clkbuf_4_11_0_clk_X clknet_4_11_0_clk vssd1 vssd1 vccd1 vccd1 sky130_fd_sc_hd__diode_2
XANTENNA__08446__A2 net2 vssd1 vssd1 vccd1 vccd1 sky130_fd_sc_hd__diode_2
XFILLER_119_609 vssd1 vssd1 vccd1 vccd1 sky130_fd_sc_hd__fill_1
X_10728_ _05637_ _05685_ _05682_ _05673_ vssd1 vssd1 vccd1 vccd1 _05686_ sky130_fd_sc_hd__a211oi_1
X_13516_ clknet_leaf_99_clk net1002 net681 vssd1 vssd1 vccd1 vccd1 cell1.LE_1A.config_data\[3\]
+ sky130_fd_sc_hd__dfrtp_1
XTAP_TAPCELL_ROW_136_2354 vssd1 vccd1 sky130_fd_sc_hd__tapvpwrvgnd_1
XTAP_TAPCELL_ROW_136_2343 vssd1 vccd1 sky130_fd_sc_hd__tapvpwrvgnd_1
XANTENNA__14307__Q cell2.SB0.route_sel\[92\] vssd1 vssd1 vccd1 vccd1 sky130_fd_sc_hd__diode_2
XANTENNA__12753__S net932 vssd1 vssd1 vccd1 vccd1 sky130_fd_sc_hd__diode_2
X_10659_ _05484_ _05602_ vssd1 vssd1 vccd1 vccd1 _05617_ sky130_fd_sc_hd__nand2_1
Xclkload13 clknet_4_14_0_clk vssd1 vssd1 vccd1 vccd1 clkload13/Y sky130_fd_sc_hd__clkinvlp_4
XANTENNA__11510__X net245 vssd1 vssd1 vccd1 vccd1 sky130_fd_sc_hd__diode_2
Xclkload24 clknet_leaf_6_clk vssd1 vssd1 vccd1 vccd1 clkload24/Y sky130_fd_sc_hd__inv_6
Xclkload35 clknet_leaf_11_clk vssd1 vssd1 vccd1 vccd1 clkload35/Y sky130_fd_sc_hd__inv_8
XTAP_TAPCELL_ROW_11_473 vssd1 vccd1 sky130_fd_sc_hd__tapvpwrvgnd_1
X_13447_ clknet_leaf_123_clk _00419_ net580 vssd1 vssd1 vccd1 vccd1 cell0.SB0.route_sel\[88\]
+ sky130_fd_sc_hd__dfstp_1
Xclkload68 clknet_leaf_40_clk vssd1 vssd1 vccd1 vccd1 clkload68/Y sky130_fd_sc_hd__inv_8
Xclkload57 clknet_leaf_17_clk vssd1 vssd1 vccd1 vccd1 clkload57/Y sky130_fd_sc_hd__inv_12
Xclkload46 clknet_leaf_22_clk vssd1 vssd1 vccd1 vccd1 clkload46/Y sky130_fd_sc_hd__inv_6
X_13378_ clknet_leaf_131_clk _00350_ net558 vssd1 vssd1 vccd1 vccd1 cell0.SB0.route_sel\[19\]
+ sky130_fd_sc_hd__dfstp_1
Xclkload79 clknet_leaf_82_clk vssd1 vssd1 vccd1 vccd1 clkload79/X sky130_fd_sc_hd__clkbuf_4
XFILLER_5_482 vssd1 vssd1 vccd1 vccd1 sky130_fd_sc_hd__fill_1
X_12329_ cell1.SB0.route_sel\[67\] cell1.SB0.route_sel\[66\] net887 vssd1 vssd1 vccd1
+ vccd1 _00762_ sky130_fd_sc_hd__mux2_1
XANTENNA__10308__A3 net302 vssd1 vssd1 vccd1 vccd1 sky130_fd_sc_hd__diode_2
XANTENNA__10713__A0 net286 vssd1 vssd1 vccd1 vccd1 sky130_fd_sc_hd__diode_2
XFILLER_110_531 vssd1 vssd1 vccd1 vccd1 sky130_fd_sc_hd__fill_1
X_07870_ cell0.CB_0.config_dataA\[9\] _02881_ _02913_ vssd1 vssd1 vccd1 vccd1 _02914_
+ sky130_fd_sc_hd__nand3b_1
XANTENNA__09363__A net314 vssd1 vssd1 vccd1 vccd1 sky130_fd_sc_hd__diode_2
X_06821_ _01887_ _01889_ vssd1 vssd1 vccd1 vccd1 _01891_ sky130_fd_sc_hd__nand2_1
X_06752_ net313 vssd1 vssd1 vccd1 vccd1 _01822_ sky130_fd_sc_hd__inv_2
X_09540_ _02167_ _04556_ _04558_ vssd1 vssd1 vccd1 vccd1 _04559_ sky130_fd_sc_hd__a21o_1
XANTENNA__09082__B _03881_ vssd1 vssd1 vccd1 vccd1 sky130_fd_sc_hd__diode_2
X_09471_ cell3.SB0.route_sel\[48\] _01709_ vssd1 vssd1 vccd1 vccd1 _04493_ sky130_fd_sc_hd__nand2_1
XFILLER_36_342 vssd1 vssd1 vccd1 vccd1 sky130_fd_sc_hd__fill_1
X_06683_ cell2.LEI0.config_data\[43\] vssd1 vssd1 vccd1 vccd1 _01753_ sky130_fd_sc_hd__inv_2
X_08422_ _03459_ _03456_ _03415_ vssd1 vssd1 vccd1 vccd1 _03460_ sky130_fd_sc_hd__mux2_1
XFILLER_24_526 vssd1 vssd1 vccd1 vccd1 sky130_fd_sc_hd__fill_4
XANTENNA__08685__A2 _03533_ vssd1 vssd1 vccd1 vccd1 sky130_fd_sc_hd__diode_2
XTAP_TAPCELL_ROW_19_595 vssd1 vccd1 sky130_fd_sc_hd__tapvpwrvgnd_1
XANTENNA__10229__C1 _05229_ vssd1 vssd1 vccd1 vccd1 sky130_fd_sc_hd__diode_2
X_08353_ net503 _02277_ vssd1 vssd1 vccd1 vccd1 _03391_ sky130_fd_sc_hd__nand2_1
XANTENNA__07611__A net338 vssd1 vssd1 vccd1 vccd1 sky130_fd_sc_hd__diode_2
X_08284_ net506 _02494_ vssd1 vssd1 vccd1 vccd1 _03322_ sky130_fd_sc_hd__nor2_1
X_07304_ net4 _02357_ _02360_ _02361_ vssd1 vssd1 vccd1 vccd1 _02362_ sky130_fd_sc_hd__o211a_1
Xclkload7 clknet_4_7_0_clk vssd1 vssd1 vccd1 vccd1 clkload7/X sky130_fd_sc_hd__clkbuf_8
X_07235_ _02256_ _02288_ _02294_ net869 vssd1 vssd1 vccd1 vccd1 _02295_ sky130_fd_sc_hd__a211o_2
XANTENNA__11420__X net233 vssd1 vssd1 vccd1 vccd1 sky130_fd_sc_hd__diode_2
XTAP_TAPCELL_ROW_30_760 vssd1 vccd1 sky130_fd_sc_hd__tapvpwrvgnd_1
X_07166_ _02226_ _02227_ _02224_ vssd1 vssd1 vccd1 vccd1 _02228_ sky130_fd_sc_hd__a21o_1
XTAP_TAPCELL_ROW_76_1445 vssd1 vccd1 sky130_fd_sc_hd__tapvpwrvgnd_1
XANTENNA__07948__B2 _02890_ vssd1 vssd1 vccd1 vccd1 sky130_fd_sc_hd__diode_2
X_07097_ cell1.SB0.route_sel\[74\] _01530_ cell1.SB0.route_sel\[77\] _01531_ _02160_
+ vssd1 vssd1 vccd1 vccd1 _02161_ sky130_fd_sc_hd__a221o_1
XANTENNA_fanout776_A net780 vssd1 vssd1 vccd1 vccd1 sky130_fd_sc_hd__diode_2
XANTENNA__10704__A0 net8 vssd1 vssd1 vccd1 vccd1 sky130_fd_sc_hd__diode_2
Xfanout277 net278 vssd1 vssd1 vccd1 vccd1 net277 sky130_fd_sc_hd__buf_2
XANTENNA_fanout943_A net944 vssd1 vssd1 vccd1 vccd1 sky130_fd_sc_hd__diode_2
X_09807_ net446 _04810_ _04811_ _04812_ vssd1 vssd1 vccd1 vccd1 _04813_ sky130_fd_sc_hd__a31o_1
Xfanout288 net289 vssd1 vssd1 vccd1 vccd1 net288 sky130_fd_sc_hd__buf_1
X_07999_ net530 _01913_ _03040_ net529 vssd1 vssd1 vccd1 vccd1 _03041_ sky130_fd_sc_hd__o211a_1
XANTENNA__08912__A3 bus3_1\[3\] vssd1 vssd1 vccd1 vccd1 sky130_fd_sc_hd__diode_2
X_09738_ _01586_ cell2.SB0.route_sel\[17\] cell2.SB0.route_sel\[23\] cell2.SB0.route_sel\[22\]
+ _04747_ vssd1 vssd1 vccd1 vccd1 _04748_ sky130_fd_sc_hd__o221a_1
XANTENNA__10750__A1_N _05489_ vssd1 vssd1 vccd1 vccd1 sky130_fd_sc_hd__diode_2
XANTENNA__09560__X bus3_1\[9\] vssd1 vssd1 vccd1 vccd1 sky130_fd_sc_hd__diode_2
XFILLER_27_331 vssd1 vssd1 vccd1 vccd1 sky130_fd_sc_hd__fill_1
XTAP_TAPCELL_ROW_120_2111 vssd1 vccd1 sky130_fd_sc_hd__tapvpwrvgnd_1
X_09669_ _04267_ _04656_ vssd1 vssd1 vccd1 vccd1 _04684_ sky130_fd_sc_hd__nor2_1
XANTENNA__09873__A1 bus3_2\[14\] vssd1 vssd1 vccd1 vccd1 sky130_fd_sc_hd__diode_2
XTAP_TAPCELL_ROW_38_882 vssd1 vccd1 sky130_fd_sc_hd__tapvpwrvgnd_1
XTAP_TAPCELL_ROW_38_871 vssd1 vccd1 sky130_fd_sc_hd__tapvpwrvgnd_1
XFILLER_27_375 vssd1 vssd1 vccd1 vccd1 sky130_fd_sc_hd__fill_1
X_12680_ cell3.LE_1B.edge_mode cell3.LE_1B.config_data\[16\] net953 vssd1 vssd1 vccd1
+ vccd1 _01109_ sky130_fd_sc_hd__mux2_1
X_11700_ cell0.LE_1A.reset_mode net1548 net804 vssd1 vssd1 vccd1 vccd1 _00140_ sky130_fd_sc_hd__mux2_1
XANTENNA__07884__A0 bus2_0\[6\] vssd1 vssd1 vccd1 vccd1 sky130_fd_sc_hd__diode_2
XANTENNA_input107_A SBwest_in[19] vssd1 vssd1 vccd1 vccd1 sky130_fd_sc_hd__diode_2
X_11631_ cell0.CB_0.config_dataA\[2\] net520 net769 vssd1 vssd1 vccd1 vccd1 _00072_
+ sky130_fd_sc_hd__mux2_1
XFILLER_24_41 vccd1 vssd1 vccd1 vssd1 sky130_ef_sc_hd__decap_40_12
X_14350_ clknet_leaf_67_clk _01322_ net736 vssd1 vssd1 vccd1 vccd1 cell3.CB_1.config_dataB\[7\]
+ sky130_fd_sc_hd__dfstp_1
X_11562_ net1136 cell0.LE_1B.config_data\[2\] net801 vssd1 vssd1 vccd1 vccd1 _00003_
+ sky130_fd_sc_hd__mux2_1
XFILLER_23_570 vssd1 vssd1 vccd1 vccd1 sky130_fd_sc_hd__fill_2
X_10513_ _03489_ net322 _02567_ vssd1 vssd1 vccd1 vccd1 _05472_ sky130_fd_sc_hd__mux2_1
XFILLER_7_725 vssd1 vssd1 vccd1 vccd1 sky130_fd_sc_hd__fill_2
XFILLER_11_765 vssd1 vssd1 vccd1 vccd1 sky130_fd_sc_hd__fill_1
X_13301_ clknet_leaf_99_clk _00273_ net680 vssd1 vssd1 vccd1 vccd1 cell1.CB_1.config_dataA\[17\]
+ sky130_fd_sc_hd__dfstp_2
XANTENNA__11330__X net174 vssd1 vssd1 vccd1 vccd1 sky130_fd_sc_hd__diode_2
XTAP_TAPCELL_ROW_118_2073 vssd1 vccd1 sky130_fd_sc_hd__tapvpwrvgnd_1
X_14281_ clknet_leaf_21_clk _01253_ net610 vssd1 vssd1 vccd1 vccd1 cell2.SB0.route_sel\[66\]
+ sky130_fd_sc_hd__dfstp_1
X_11493_ cell2.SB0.route_sel\[20\] cell2.SB0.route_sel\[21\] vssd1 vssd1 vccd1 vccd1
+ _06329_ sky130_fd_sc_hd__nand2b_1
XTAP_TAPCELL_ROW_118_2084 vssd1 vccd1 sky130_fd_sc_hd__tapvpwrvgnd_1
X_10444_ _04463_ _05436_ vssd1 vssd1 vccd1 vccd1 bus3_2\[5\] sky130_fd_sc_hd__and2_2
X_13232_ clknet_leaf_10_clk _00204_ net569 vssd1 vssd1 vccd1 vccd1 cell0.LEI0.config_data\[17\]
+ sky130_fd_sc_hd__dfrtp_1
XFILLER_40_62 vssd1 vssd1 vccd1 vccd1 sky130_fd_sc_hd__fill_1
XANTENNA_input72_A SBsouth_in[16] vssd1 vssd1 vccd1 vccd1 sky130_fd_sc_hd__diode_2
X_10375_ net63 net64 net34 net35 net429 net427 vssd1 vssd1 vccd1 vccd1 _05374_ sky130_fd_sc_hd__mux4_1
X_13163_ clknet_leaf_116_clk net1073 net667 vssd1 vssd1 vccd1 vccd1 cell0.LE_1A.config_data\[14\]
+ sky130_fd_sc_hd__dfrtp_1
XTAP_TAPCELL_ROW_131_2273 vssd1 vccd1 sky130_fd_sc_hd__tapvpwrvgnd_1
X_12114_ cell1.LE_0A.reset_mode net1546 net905 vssd1 vssd1 vccd1 vccd1 _00548_ sky130_fd_sc_hd__mux2_1
X_13094_ clknet_leaf_11_clk _00066_ net588 vssd1 vssd1 vccd1 vccd1 cell0.CB_0.config_dataB\[21\]
+ sky130_fd_sc_hd__dfstp_2
X_12045_ net449 net450 net885 vssd1 vssd1 vccd1 vccd1 _00482_ sky130_fd_sc_hd__mux2_1
XFILLER_65_415 vssd1 vssd1 vccd1 vccd1 sky130_fd_sc_hd__fill_1
XFILLER_92_212 vssd1 vssd1 vccd1 vccd1 sky130_fd_sc_hd__fill_1
X_13996_ clknet_leaf_74_clk _00968_ net725 vssd1 vssd1 vccd1 vccd1 cell3.SB0.route_sel\[4\]
+ sky130_fd_sc_hd__dfstp_1
X_12947_ cell3.LE_0B.config_data\[12\] net1070 net950 vssd1 vssd1 vccd1 vccd1 _01375_
+ sky130_fd_sc_hd__mux2_1
XANTENNA__12748__S net929 vssd1 vssd1 vccd1 vccd1 sky130_fd_sc_hd__diode_2
XFILLER_65_70 vssd1 vssd1 vccd1 vccd1 sky130_fd_sc_hd__fill_2
XFILLER_61_621 vssd1 vssd1 vccd1 vccd1 sky130_fd_sc_hd__fill_1
XTAP_TAPCELL_ROW_47_1013 vssd1 vccd1 sky130_fd_sc_hd__tapvpwrvgnd_1
X_12878_ cell2.SB0.route_sel\[120\] cell2.SB0.route_sel\[119\] net820 vssd1 vssd1
+ vccd1 vccd1 _01307_ sky130_fd_sc_hd__mux2_1
XFILLER_18_397 vssd1 vssd1 vccd1 vccd1 sky130_fd_sc_hd__fill_2
XTAP_TAPCELL_ROW_16_543 vssd1 vccd1 sky130_fd_sc_hd__tapvpwrvgnd_1
XTAP_TAPCELL_ROW_16_554 vssd1 vccd1 sky130_fd_sc_hd__tapvpwrvgnd_1
X_11829_ net492 cell1.CB_1.config_dataA\[9\] net890 vssd1 vssd1 vccd1 vccd1 _00266_
+ sky130_fd_sc_hd__mux2_1
XFILLER_33_367 vssd1 vssd1 vccd1 vccd1 sky130_fd_sc_hd__fill_1
XTAP_TAPCELL_ROW_60_1213 vssd1 vccd1 sky130_fd_sc_hd__tapvpwrvgnd_1
XTAP_TAPCELL_ROW_60_1202 vssd1 vccd1 sky130_fd_sc_hd__tapvpwrvgnd_1
XFILLER_33_389 vssd1 vssd1 vccd1 vccd1 sky130_fd_sc_hd__fill_1
XPHY_EDGE_ROW_112_Right_112 vssd1 vssd1 vccd1 vccd1 sky130_fd_sc_hd__decap_3
XANTENNA__14037__Q cell3.SB0.route_sel\[45\] vssd1 vssd1 vccd1 vccd1 sky130_fd_sc_hd__diode_2
Xclkload113 clknet_leaf_56_clk vssd1 vssd1 vccd1 vccd1 clkload113/Y sky130_fd_sc_hd__inv_6
X_14479_ clknet_leaf_60_clk _01451_ net737 vssd1 vssd1 vccd1 vccd1 cell3.LEI0.config_data\[44\]
+ sky130_fd_sc_hd__dfrtp_1
Xclkload102 clknet_leaf_46_clk vssd1 vssd1 vccd1 vccd1 clkload102/Y sky130_fd_sc_hd__inv_4
Xclkload135 clknet_1_1__leaf_cell3.LE_1A.sel_clk vssd1 vssd1 vccd1 vccd1 clkload135/X
+ sky130_fd_sc_hd__clkbuf_4
Xclkload124 clknet_leaf_59_clk vssd1 vssd1 vccd1 vccd1 clkload124/Y sky130_fd_sc_hd__inv_12
X_07020_ net356 _02083_ vssd1 vssd1 vccd1 vccd1 _02085_ sky130_fd_sc_hd__nand2_1
Xclkload146 clknet_1_1__leaf_cell0.LE_0B.sel_clk vssd1 vssd1 vccd1 vccd1 clkload146/X
+ sky130_fd_sc_hd__clkbuf_4
XANTENNA__11726__A2 net548 vssd1 vssd1 vccd1 vccd1 sky130_fd_sc_hd__diode_2
XPHY_EDGE_ROW_49_Right_49 vssd1 vssd1 vccd1 vccd1 sky130_fd_sc_hd__decap_3
XANTENNA__07149__Y _02211_ vssd1 vssd1 vccd1 vccd1 sky130_fd_sc_hd__diode_2
XTAP_TAPCELL_ROW_58_1175 vssd1 vccd1 sky130_fd_sc_hd__tapvpwrvgnd_1
XFILLER_142_475 vssd1 vssd1 vccd1 vccd1 sky130_fd_sc_hd__fill_1
X_08971_ cell1.LEI0.config_data\[36\] _01821_ _04002_ cell1.LEI0.config_data\[37\]
+ vssd1 vssd1 vccd1 vccd1 _04003_ sky130_fd_sc_hd__o211a_1
Xhold19 cell3.LE_1A.config_data\[13\] vssd1 vssd1 vccd1 vccd1 net978 sky130_fd_sc_hd__dlygate4sd3_1
X_07922_ net515 _02526_ _02965_ net514 vssd1 vssd1 vccd1 vccd1 _02966_ sky130_fd_sc_hd__o211a_1
XFILLER_96_573 vssd1 vssd1 vccd1 vccd1 sky130_fd_sc_hd__fill_8
XTAP_TAPCELL_ROW_71_1375 vssd1 vccd1 sky130_fd_sc_hd__tapvpwrvgnd_1
XFILLER_68_242 vssd1 vssd1 vccd1 vccd1 sky130_fd_sc_hd__fill_1
X_07853_ net268 _02896_ vssd1 vssd1 vccd1 vccd1 _02897_ sky130_fd_sc_hd__nand2_4
XANTENNA__08355__A1 _02136_ vssd1 vssd1 vccd1 vccd1 sky130_fd_sc_hd__diode_2
XFILLER_84_757 vssd1 vssd1 vccd1 vccd1 sky130_fd_sc_hd__fill_1
XFILLER_83_223 vssd1 vssd1 vccd1 vccd1 sky130_fd_sc_hd__fill_1
X_06804_ cell0.SB0.route_sel\[48\] cell0.SB0.route_sel\[49\] _01861_ _01873_ net760
+ vssd1 vssd1 vccd1 vccd1 _01874_ sky130_fd_sc_hd__a311oi_4
XFILLER_28_139 vssd1 vssd1 vccd1 vccd1 sky130_fd_sc_hd__fill_1
XPHY_EDGE_ROW_58_Right_58 vssd1 vssd1 vccd1 vccd1 sky130_fd_sc_hd__decap_3
X_07784_ cell0.SB0.route_sel\[44\] cell0.SB0.route_sel\[45\] vssd1 vssd1 vccd1 vccd1
+ _02829_ sky130_fd_sc_hd__nand2_1
X_09523_ net381 net380 vssd1 vssd1 vccd1 vccd1 _04543_ sky130_fd_sc_hd__nand2b_1
X_06735_ cell3.CB_0.config_dataA\[2\] vssd1 vssd1 vccd1 vccd1 _01805_ sky130_fd_sc_hd__inv_2
XFILLER_43_109 vssd1 vssd1 vccd1 vccd1 sky130_fd_sc_hd__fill_1
XANTENNA__08658__A2 _03486_ vssd1 vssd1 vccd1 vccd1 sky130_fd_sc_hd__diode_2
XFILLER_36_161 vssd1 vssd1 vccd1 vccd1 sky130_fd_sc_hd__fill_1
X_09454_ cell3.SB0.route_sel\[51\] cell3.SB0.route_sel\[50\] vssd1 vssd1 vccd1 vccd1
+ _04476_ sky130_fd_sc_hd__nand2_1
X_06666_ cell3.SB0.route_sel\[97\] vssd1 vssd1 vccd1 vccd1 _01736_ sky130_fd_sc_hd__inv_2
XTAP_TAPCELL_ROW_35_830 vssd1 vccd1 sky130_fd_sc_hd__tapvpwrvgnd_1
X_09385_ _04408_ net294 _04407_ vssd1 vssd1 vccd1 vccd1 _04409_ sky130_fd_sc_hd__mux2_1
X_08405_ net500 _01877_ _03442_ net499 vssd1 vssd1 vccd1 vccd1 _03443_ sky130_fd_sc_hd__o211a_1
X_06597_ net488 vssd1 vssd1 vccd1 vccd1 _01667_ sky130_fd_sc_hd__inv_2
X_08336_ net509 _02211_ _03373_ net508 vssd1 vssd1 vccd1 vccd1 _03374_ sky130_fd_sc_hd__o211a_1
XANTENNA__09083__A2 _03885_ vssd1 vssd1 vccd1 vccd1 sky130_fd_sc_hd__diode_2
XFILLER_124_7 vccd1 vssd1 vccd1 vssd1 sky130_ef_sc_hd__decap_40_12
X_08267_ cell0.LE_1A.config_data\[11\] cell0.LE_1A.config_data\[10\] _03198_ vssd1
+ vssd1 vccd1 vccd1 _03307_ sky130_fd_sc_hd__mux2_1
XPHY_EDGE_ROW_67_Right_67 vssd1 vssd1 vccd1 vccd1 sky130_fd_sc_hd__decap_3
X_08198_ net539 _02277_ vssd1 vssd1 vccd1 vccd1 _03238_ sky130_fd_sc_hd__nand2_1
X_07218_ _02258_ _02274_ _02276_ _02259_ vssd1 vssd1 vccd1 vccd1 _02278_ sky130_fd_sc_hd__o31a_1
XANTENNA__08043__A0 net344 vssd1 vssd1 vccd1 vccd1 sky130_fd_sc_hd__diode_2
XFILLER_3_205 vccd1 vssd1 vccd1 vssd1 sky130_ef_sc_hd__decap_40_12
X_07149_ net341 _02210_ vssd1 vssd1 vccd1 vccd1 _02211_ sky130_fd_sc_hd__nand2_4
XFILLER_126_21 vssd1 vssd1 vccd1 vccd1 sky130_fd_sc_hd__fill_4
XANTENNA__08594__A1 net27 vssd1 vssd1 vccd1 vccd1 sky130_fd_sc_hd__diode_2
XFILLER_3_249 vccd1 vssd1 vccd1 vssd1 sky130_ef_sc_hd__decap_40_12
X_10160_ cell2.CB_0.config_dataA\[9\] _05160_ vssd1 vssd1 vccd1 vccd1 _05161_ sky130_fd_sc_hd__nor2_1
XPHY_EDGE_ROW_58_Left_201 vssd1 vssd1 vccd1 vccd1 sky130_fd_sc_hd__decap_3
XANTENNA__08594__B2 net28 vssd1 vssd1 vccd1 vccd1 sky130_fd_sc_hd__diode_2
XFILLER_10_65 vccd1 vssd1 vccd1 vssd1 sky130_ef_sc_hd__decap_40_12
XFILLER_126_65 vssd1 vssd1 vccd1 vccd1 sky130_fd_sc_hd__fill_4
XFILLER_86_25 vssd1 vssd1 vccd1 vccd1 sky130_fd_sc_hd__fill_2
X_10091_ net264 _05091_ vssd1 vssd1 vccd1 vccd1 _05092_ sky130_fd_sc_hd__nand2_1
XANTENNA__08111__S _03087_ vssd1 vssd1 vccd1 vccd1 sky130_fd_sc_hd__diode_2
XFILLER_142_31 vssd1 vssd1 vccd1 vccd1 sky130_fd_sc_hd__fill_1
XTAP_TAPCELL_ROW_89_1647 vssd1 vccd1 sky130_fd_sc_hd__tapvpwrvgnd_1
XTAP_TAPCELL_ROW_89_1636 vssd1 vccd1 sky130_fd_sc_hd__tapvpwrvgnd_1
XPHY_EDGE_ROW_76_Right_76 vssd1 vssd1 vccd1 vccd1 sky130_fd_sc_hd__decap_3
XFILLER_74_201 vssd1 vssd1 vccd1 vccd1 sky130_fd_sc_hd__fill_8
X_13850_ clknet_leaf_120_clk _00822_ net596 vssd1 vssd1 vccd1 vccd1 cell1.SB0.config_data_out
+ sky130_fd_sc_hd__dfstp_2
X_10993_ _05901_ _05934_ cell3.CB_0.config_dataA\[7\] vssd1 vssd1 vccd1 vccd1 _05947_
+ sky130_fd_sc_hd__o21ai_1
X_12801_ cell2.SB0.route_sel\[43\] cell2.SB0.route_sel\[42\] net819 vssd1 vssd1 vccd1
+ vccd1 _01230_ sky130_fd_sc_hd__mux2_1
X_13781_ clknet_leaf_109_clk _00753_ net651 vssd1 vssd1 vccd1 vccd1 cell1.SB0.route_sel\[58\]
+ sky130_fd_sc_hd__dfstp_1
X_12732_ cell3.CB_0.config_dataB\[24\] net380 net933 vssd1 vssd1 vccd1 vccd1 _01161_
+ sky130_fd_sc_hd__mux2_1
XANTENNA__09450__B _04471_ vssd1 vssd1 vccd1 vccd1 sky130_fd_sc_hd__diode_2
XANTENNA__12850__A0 cell2.SB0.route_sel\[92\] vssd1 vssd1 vccd1 vccd1 sky130_fd_sc_hd__diode_2
XFILLER_15_312 vccd1 vssd1 vccd1 vssd1 sky130_ef_sc_hd__decap_40_12
XFILLER_35_51 vssd1 vssd1 vccd1 vccd1 sky130_fd_sc_hd__fill_4
XANTENNA_clkbuf_leaf_52_clk_A clknet_4_13_0_clk vssd1 vssd1 vccd1 vccd1 sky130_fd_sc_hd__diode_2
XPHY_EDGE_ROW_67_Left_210 vssd1 vssd1 vccd1 vccd1 sky130_fd_sc_hd__decap_3
X_14402_ clknet_leaf_62_clk _01374_ net739 vssd1 vssd1 vccd1 vccd1 cell3.LE_0B.config_data\[11\]
+ sky130_fd_sc_hd__dfrtp_1
X_12663_ net1260 cell3.LE_0A.reset_mode net957 vssd1 vssd1 vccd1 vccd1 _01092_ sky130_fd_sc_hd__mux2_1
XTAP_TAPCELL_ROW_100_1814 vssd1 vccd1 sky130_fd_sc_hd__tapvpwrvgnd_1
XTAP_TAPCELL_ROW_100_1803 vssd1 vccd1 sky130_fd_sc_hd__tapvpwrvgnd_1
XFILLER_42_197 vssd1 vssd1 vccd1 vccd1 sky130_fd_sc_hd__fill_1
XANTENNA__07872__A3 net338 vssd1 vssd1 vccd1 vccd1 sky130_fd_sc_hd__diode_2
XTAP_TAPCELL_ROW_13_502 vssd1 vccd1 sky130_fd_sc_hd__tapvpwrvgnd_1
XANTENNA__10208__A2 net38 vssd1 vssd1 vccd1 vccd1 sky130_fd_sc_hd__diode_2
X_12594_ cell3.SB0.route_sel\[59\] cell3.SB0.route_sel\[58\] net909 vssd1 vssd1 vccd1
+ vccd1 _01023_ sky130_fd_sc_hd__mux2_1
X_11614_ net528 cell0.CB_0.config_dataB\[9\] net773 vssd1 vssd1 vccd1 vccd1 _00055_
+ sky130_fd_sc_hd__mux2_1
XFILLER_7_500 vssd1 vssd1 vccd1 vccd1 sky130_fd_sc_hd__fill_1
XTAP_TAPCELL_ROW_133_2302 vssd1 vccd1 sky130_fd_sc_hd__tapvpwrvgnd_1
XANTENNA_clkbuf_leaf_67_clk_A clknet_4_15_0_clk vssd1 vssd1 vccd1 vccd1 sky130_fd_sc_hd__diode_2
X_14333_ clknet_leaf_19_clk _01305_ net613 vssd1 vssd1 vccd1 vccd1 cell2.SB0.route_sel\[118\]
+ sky130_fd_sc_hd__dfstp_1
XPHY_EDGE_ROW_85_Right_85 vssd1 vssd1 vccd1 vccd1 sky130_fd_sc_hd__decap_3
X_11545_ _01584_ cell0.SB0.route_sel\[10\] _01585_ cell0.SB0.route_sel\[13\] _06363_
+ vssd1 vssd1 vccd1 vccd1 _06364_ sky130_fd_sc_hd__a221o_1
XANTENNA__08282__A0 bus1_0\[12\] vssd1 vssd1 vccd1 vccd1 sky130_fd_sc_hd__diode_2
Xclkbuf_leaf_131_clk clknet_4_0_0_clk vssd1 vssd1 vccd1 vccd1 clknet_leaf_131_clk
+ sky130_fd_sc_hd__clkbuf_8
X_14264_ clknet_leaf_24_clk _01236_ net607 vssd1 vssd1 vccd1 vccd1 cell2.SB0.route_sel\[49\]
+ sky130_fd_sc_hd__dfstp_1
X_11476_ _01539_ cell1.SB0.route_sel\[96\] _01540_ cell1.SB0.route_sel\[99\] _06317_
+ vssd1 vssd1 vccd1 vccd1 _06318_ sky130_fd_sc_hd__a221o_1
X_10427_ cell2.LE_0B.dff0_out cell2.LE_0B.dff1_out cell2.LE_0B.reset_val vssd1 vssd1
+ vccd1 vccd1 cell2.LE_0B.dff_out sky130_fd_sc_hd__mux2_1
XFILLER_109_461 vssd1 vssd1 vccd1 vccd1 sky130_fd_sc_hd__fill_2
X_13215_ clknet_leaf_13_clk _00187_ net597 vssd1 vssd1 vccd1 vccd1 cell0.LEI0.config_data\[0\]
+ sky130_fd_sc_hd__dfrtp_1
XANTENNA_clkbuf_leaf_110_clk_A clknet_4_8_0_clk vssd1 vssd1 vccd1 vccd1 sky130_fd_sc_hd__diode_2
X_14195_ clknet_leaf_54_clk _01167_ net715 vssd1 vssd1 vccd1 vccd1 cell3.CB_0.config_dataA\[5\]
+ sky130_fd_sc_hd__dfstp_1
X_10358_ net61 net62 net428 vssd1 vssd1 vccd1 vccd1 _05357_ sky130_fd_sc_hd__mux2_1
XANTENNA__10392__A1 _02106_ vssd1 vssd1 vccd1 vccd1 sky130_fd_sc_hd__diode_2
XANTENNA__07129__C net357 vssd1 vssd1 vccd1 vccd1 sky130_fd_sc_hd__diode_2
X_13146_ clknet_leaf_123_clk _00118_ net580 vssd1 vssd1 vccd1 vccd1 cell0.CB_1.config_dataB\[23\]
+ sky130_fd_sc_hd__dfstp_2
X_10289_ _05286_ _05287_ vssd1 vssd1 vccd1 vccd1 _05288_ sky130_fd_sc_hd__or2_1
XANTENNA__10392__B2 _05093_ vssd1 vssd1 vccd1 vccd1 sky130_fd_sc_hd__diode_2
XANTENNA__10931__A3 _05883_ vssd1 vssd1 vccd1 vccd1 sky130_fd_sc_hd__diode_2
X_13077_ clknet_leaf_8_clk _00049_ net572 vssd1 vssd1 vccd1 vccd1 cell0.CB_0.config_dataB\[4\]
+ sky130_fd_sc_hd__dfstp_1
XFILLER_3_783 vssd1 vssd1 vccd1 vccd1 sky130_fd_sc_hd__fill_1
XANTENNA_clkbuf_leaf_125_clk_A clknet_4_2_0_clk vssd1 vssd1 vccd1 vccd1 sky130_fd_sc_hd__diode_2
XTAP_TAPCELL_ROW_111_1976 vssd1 vccd1 sky130_fd_sc_hd__tapvpwrvgnd_1
XPHY_EDGE_ROW_94_Right_94 vssd1 vssd1 vccd1 vccd1 sky130_fd_sc_hd__decap_3
XANTENNA__06968__C _02032_ vssd1 vssd1 vccd1 vccd1 sky130_fd_sc_hd__diode_2
X_12028_ net457 net459 net899 vssd1 vssd1 vccd1 vccd1 _00465_ sky130_fd_sc_hd__mux2_1
XANTENNA__08337__A1 _02037_ vssd1 vssd1 vccd1 vccd1 sky130_fd_sc_hd__diode_2
XFILLER_93_554 vssd1 vssd1 vccd1 vccd1 sky130_fd_sc_hd__fill_4
XFILLER_93_543 vssd1 vssd1 vccd1 vccd1 sky130_fd_sc_hd__fill_1
XANTENNA__08809__X _03841_ vssd1 vssd1 vccd1 vccd1 sky130_fd_sc_hd__diode_2
X_13979_ clknet_leaf_42_clk _00951_ net633 vssd1 vssd1 vccd1 vccd1 cell2.LEI0.config_data\[36\]
+ sky130_fd_sc_hd__dfrtp_1
X_06520_ cell0.SB0.route_sel\[19\] vssd1 vssd1 vccd1 vccd1 _01590_ sky130_fd_sc_hd__inv_2
X_06451_ cell1.SB0.route_sel\[57\] vssd1 vssd1 vccd1 vccd1 _01521_ sky130_fd_sc_hd__inv_2
X_09170_ _04177_ net269 _04196_ _04178_ vssd1 vssd1 vccd1 vccd1 _04198_ sky130_fd_sc_hd__a31oi_2
X_08121_ _03155_ _03162_ _03151_ vssd1 vssd1 vccd1 vccd1 _03163_ sky130_fd_sc_hd__mux2_1
Xclkbuf_leaf_122_clk clknet_4_3_0_clk vssd1 vssd1 vccd1 vccd1 clknet_leaf_122_clk
+ sky130_fd_sc_hd__clkbuf_8
X_08052_ net528 _02585_ vssd1 vssd1 vccd1 vccd1 _03094_ sky130_fd_sc_hd__nand2_1
XANTENNA__08025__A0 bus2_0\[8\] vssd1 vssd1 vccd1 vccd1 sky130_fd_sc_hd__diode_2
X_07003_ cell1.SB0.route_sel\[64\] cell1.SB0.route_sel\[65\] _02056_ _02068_ net869
+ vssd1 vssd1 vccd1 vccd1 _02069_ sky130_fd_sc_hd__a311o_2
XANTENNA__12941__S net933 vssd1 vssd1 vccd1 vccd1 sky130_fd_sc_hd__diode_2
XTAP_TAPCELL_ROW_73_1404 vssd1 vccd1 sky130_fd_sc_hd__tapvpwrvgnd_1
XANTENNA__09375__X _04399_ vssd1 vssd1 vccd1 vccd1 sky130_fd_sc_hd__diode_2
XFILLER_89_827 vssd1 vssd1 vccd1 vccd1 sky130_fd_sc_hd__fill_1
XANTENNA__08040__A3 bus2_0\[3\] vssd1 vssd1 vccd1 vccd1 sky130_fd_sc_hd__diode_2
XFILLER_0_208 vssd1 vssd1 vccd1 vccd1 sky130_fd_sc_hd__fill_4
X_08954_ cell1.CB_0.config_dataA\[17\] _03983_ _03985_ _03976_ vssd1 vssd1 vccd1 vccd1
+ _03986_ sky130_fd_sc_hd__o211a_1
Xinput109 SBwest_in[20] vssd1 vssd1 vccd1 vccd1 net109 sky130_fd_sc_hd__dlymetal6s2s_1
X_07905_ net516 _02897_ vssd1 vssd1 vccd1 vccd1 _02949_ sky130_fd_sc_hd__nand2_1
XFILLER_69_584 vssd1 vssd1 vccd1 vccd1 sky130_fd_sc_hd__fill_1
X_08885_ cell1.CB_0.config_dataA\[3\] _03908_ _03912_ _03916_ vssd1 vssd1 vccd1 vccd1
+ _03917_ sky130_fd_sc_hd__and4_1
X_07836_ _02871_ _02877_ _01571_ vssd1 vssd1 vccd1 vccd1 _02880_ sky130_fd_sc_hd__mux2_1
XANTENNA_fanout641_A net649 vssd1 vssd1 vccd1 vccd1 sky130_fd_sc_hd__diode_2
X_07767_ cell1.SB0.route_sel\[34\] cell1.SB0.route_sel\[35\] _02811_ _02812_ _02788_
+ vssd1 vssd1 vccd1 vccd1 _02813_ sky130_fd_sc_hd__a41o_1
X_06718_ net395 vssd1 vssd1 vccd1 vccd1 _01788_ sky130_fd_sc_hd__inv_2
X_09506_ _04525_ vssd1 vssd1 vccd1 vccd1 _04526_ sky130_fd_sc_hd__inv_2
XTAP_TAPCELL_ROW_84_1566 vssd1 vccd1 sky130_fd_sc_hd__tapvpwrvgnd_1
X_07698_ net348 _01931_ _02606_ vssd1 vssd1 vccd1 vccd1 _02745_ sky130_fd_sc_hd__and3_1
X_09437_ _01825_ _04457_ _04459_ vssd1 vssd1 vccd1 vccd1 _04460_ sky130_fd_sc_hd__a21oi_1
XANTENNA__11305__B _05478_ vssd1 vssd1 vccd1 vccd1 sky130_fd_sc_hd__diode_2
XANTENNA_fanout906_A net907 vssd1 vssd1 vccd1 vccd1 sky130_fd_sc_hd__diode_2
X_06649_ cell3.SB0.route_sel\[66\] vssd1 vssd1 vccd1 vccd1 _01719_ sky130_fd_sc_hd__inv_2
XFILLER_40_624 vssd1 vssd1 vccd1 vccd1 sky130_fd_sc_hd__fill_1
X_09368_ _01923_ _02099_ vssd1 vssd1 vccd1 vccd1 _04392_ sky130_fd_sc_hd__nor2_1
X_09299_ _02775_ _02780_ _03861_ _02776_ vssd1 vssd1 vccd1 vccd1 _04324_ sky130_fd_sc_hd__a31o_1
X_08319_ bus1_0\[5\] _03350_ _03351_ bus1_0\[4\] cell0.CB_1.config_dataB\[3\] vssd1
+ vssd1 vccd1 vccd1 _03357_ sky130_fd_sc_hd__a221o_1
Xclkbuf_leaf_113_clk clknet_4_8_0_clk vssd1 vssd1 vccd1 vccd1 clknet_leaf_113_clk
+ sky130_fd_sc_hd__clkbuf_8
X_11330_ _06230_ net285 _04268_ vssd1 vssd1 vccd1 vccd1 net174 sky130_fd_sc_hd__mux2_1
XANTENNA__08803__A2 bus3_1\[10\] vssd1 vssd1 vccd1 vccd1 sky130_fd_sc_hd__diode_2
XFILLER_20_392 vssd1 vssd1 vccd1 vccd1 sky130_fd_sc_hd__fill_1
XTAP_TAPCELL_ROW_115_2032 vssd1 vccd1 sky130_fd_sc_hd__tapvpwrvgnd_1
XFILLER_115_3 vccd1 vssd1 vccd1 vssd1 sky130_ef_sc_hd__decap_40_12
X_11261_ _05136_ net307 _04437_ vssd1 vssd1 vccd1 vccd1 _06198_ sky130_fd_sc_hd__mux2_1
XANTENNA__08567__A1 _02444_ vssd1 vssd1 vccd1 vccd1 sky130_fd_sc_hd__diode_2
XFILLER_21_86 vssd1 vssd1 vccd1 vccd1 sky130_fd_sc_hd__fill_2
XFILLER_21_97 vssd1 vssd1 vccd1 vccd1 sky130_fd_sc_hd__fill_2
X_11192_ net48 _01802_ net382 _06143_ vssd1 vssd1 vccd1 vccd1 _06144_ sky130_fd_sc_hd__o211a_1
X_13000_ cell3.LEI0.config_data\[21\] net1536 net947 vssd1 vssd1 vccd1 vccd1 _01428_
+ sky130_fd_sc_hd__mux2_1
X_10212_ _05152_ _05200_ _05201_ _05156_ cell2.CB_0.config_dataA\[12\] vssd1 vssd1
+ vccd1 vccd1 _05213_ sky130_fd_sc_hd__a221o_1
XFILLER_106_475 vssd1 vssd1 vccd1 vccd1 sky130_fd_sc_hd__fill_1
XFILLER_4_569 vccd1 vssd1 vccd1 vssd1 sky130_ef_sc_hd__decap_40_12
XFILLER_97_57 vssd1 vssd1 vccd1 vccd1 sky130_fd_sc_hd__fill_2
X_10143_ _04345_ _05143_ vssd1 vssd1 vccd1 vccd1 _05144_ sky130_fd_sc_hd__nand2_4
XANTENNA__07246__A net116 vssd1 vssd1 vccd1 vccd1 sky130_fd_sc_hd__diode_2
Xclkbuf_1_1__f_cell1.LE_0A.sel_clk clknet_0_cell1.LE_0A.sel_clk vssd1 vssd1 vccd1
+ vccd1 clknet_1_1__leaf_cell1.LE_0A.sel_clk sky130_fd_sc_hd__clkbuf_16
XFILLER_0_753 vssd1 vssd1 vccd1 vccd1 sky130_fd_sc_hd__fill_1
XANTENNA__12115__A2 net550 vssd1 vssd1 vccd1 vccd1 sky130_fd_sc_hd__diode_2
XANTENNA__08319__B2 bus1_0\[4\] vssd1 vssd1 vccd1 vccd1 sky130_fd_sc_hd__diode_2
XANTENNA__08319__A1 bus1_0\[5\] vssd1 vssd1 vccd1 vccd1 sky130_fd_sc_hd__diode_2
XANTENNA_input35_A CBnorth_in[11] vssd1 vssd1 vccd1 vccd1 sky130_fd_sc_hd__diode_2
X_10074_ _05077_ _05070_ _05066_ vssd1 vssd1 vccd1 vccd1 _05078_ sky130_fd_sc_hd__mux2_1
X_13902_ clknet_leaf_36_clk net1162 net639 vssd1 vssd1 vccd1 vccd1 cell2.LE_0B.config_data\[3\]
+ sky130_fd_sc_hd__dfrtp_1
XANTENNA__09819__A1 net308 vssd1 vssd1 vccd1 vccd1 sky130_fd_sc_hd__diode_2
X_13833_ clknet_leaf_115_clk _00805_ net655 vssd1 vssd1 vccd1 vccd1 cell1.SB0.route_sel\[110\]
+ sky130_fd_sc_hd__dfstp_1
XFILLER_35_407 vssd1 vssd1 vccd1 vccd1 sky130_fd_sc_hd__fill_1
XTAP_TAPCELL_ROW_126_2194 vssd1 vccd1 sky130_fd_sc_hd__tapvpwrvgnd_1
XFILLER_16_610 vssd1 vssd1 vccd1 vccd1 sky130_fd_sc_hd__fill_1
XFILLER_16_643 vssd1 vssd1 vccd1 vccd1 sky130_fd_sc_hd__fill_1
X_10976_ _01807_ _05887_ _05927_ _05929_ vssd1 vssd1 vccd1 vccd1 _05930_ sky130_fd_sc_hd__a31o_4
X_13764_ clknet_leaf_110_clk _00736_ net654 vssd1 vssd1 vccd1 vccd1 cell1.SB0.route_sel\[41\]
+ sky130_fd_sc_hd__dfstp_1
X_12715_ cell3.CB_0.config_dataB\[7\] cell3.CB_0.config_dataB\[6\] net931 vssd1 vssd1
+ vccd1 vccd1 _01144_ sky130_fd_sc_hd__mux2_1
X_13695_ clknet_leaf_33_clk _00667_ net621 vssd1 vssd1 vccd1 vccd1 cell2.CB_0.config_dataB\[22\]
+ sky130_fd_sc_hd__dfstp_2
X_12646_ cell3.SB0.route_sel\[111\] cell3.SB0.route_sel\[110\] net921 vssd1 vssd1
+ vccd1 vccd1 _01075_ sky130_fd_sc_hd__mux2_1
XTAP_TAPCELL_ROW_26_693 vssd1 vccd1 sky130_fd_sc_hd__tapvpwrvgnd_1
Xclkbuf_leaf_104_clk clknet_4_8_0_clk vssd1 vssd1 vccd1 vccd1 clknet_leaf_104_clk
+ sky130_fd_sc_hd__clkbuf_8
XFILLER_30_156 vssd1 vssd1 vccd1 vccd1 sky130_fd_sc_hd__fill_1
X_12577_ cell3.SB0.route_sel\[42\] cell3.SB0.route_sel\[41\] net914 vssd1 vssd1 vccd1
+ vccd1 _01006_ sky130_fd_sc_hd__mux2_1
X_14316_ clknet_leaf_18_clk _01288_ net615 vssd1 vssd1 vccd1 vccd1 cell2.SB0.route_sel\[101\]
+ sky130_fd_sc_hd__dfstp_1
XANTENNA__09452__C1 _04467_ vssd1 vssd1 vccd1 vccd1 sky130_fd_sc_hd__diode_2
XFILLER_7_55 vssd1 vssd1 vccd1 vccd1 sky130_fd_sc_hd__fill_1
XFILLER_30_189 vssd1 vssd1 vccd1 vccd1 sky130_fd_sc_hd__fill_1
Xhold308 cell2.LE_1B.config_data\[15\] vssd1 vssd1 vccd1 vccd1 net1267 sky130_fd_sc_hd__dlygate4sd3_1
X_11528_ _02469_ _06352_ vssd1 vssd1 vccd1 vccd1 net251 sky130_fd_sc_hd__nor2_1
XFILLER_7_363 vssd1 vssd1 vccd1 vccd1 sky130_fd_sc_hd__fill_1
X_14247_ clknet_leaf_19_clk _01219_ net614 vssd1 vssd1 vccd1 vccd1 cell2.SB0.route_sel\[32\]
+ sky130_fd_sc_hd__dfstp_1
Xhold319 cell1.LE_0A.config_data\[10\] vssd1 vssd1 vccd1 vccd1 net1278 sky130_fd_sc_hd__dlygate4sd3_1
X_11459_ _01897_ _06306_ vssd1 vssd1 vccd1 vccd1 net212 sky130_fd_sc_hd__nor2_1
X_14178_ clknet_leaf_56_clk _01150_ net722 vssd1 vssd1 vccd1 vccd1 cell3.CB_0.config_dataB\[13\]
+ sky130_fd_sc_hd__dfstp_1
XFILLER_125_762 vssd1 vssd1 vccd1 vccd1 sky130_fd_sc_hd__fill_1
XTAP_TAPCELL_ROW_55_1134 vssd1 vccd1 sky130_fd_sc_hd__tapvpwrvgnd_1
XANTENNA__08558__A1 net12 vssd1 vssd1 vccd1 vccd1 sky130_fd_sc_hd__diode_2
XFILLER_140_743 vccd1 vssd1 vccd1 vssd1 sky130_ef_sc_hd__decap_40_12
X_13129_ clknet_leaf_128_clk _00101_ net577 vssd1 vssd1 vccd1 vccd1 cell0.CB_1.config_dataB\[6\]
+ sky130_fd_sc_hd__dfstp_1
XANTENNA__10117__A1 net37 vssd1 vssd1 vccd1 vccd1 sky130_fd_sc_hd__diode_2
XANTENNA__10668__A2 _05501_ vssd1 vssd1 vccd1 vccd1 sky130_fd_sc_hd__diode_2
XFILLER_66_543 vssd1 vssd1 vccd1 vccd1 sky130_fd_sc_hd__fill_1
X_08670_ _03703_ vssd1 vssd1 vccd1 vccd1 _03704_ sky130_fd_sc_hd__inv_2
X_07621_ net354 _02624_ vssd1 vssd1 vccd1 vccd1 _02670_ sky130_fd_sc_hd__nor2_1
XANTENNA__08191__C1 _03230_ vssd1 vssd1 vccd1 vccd1 sky130_fd_sc_hd__diode_2
X_07552_ _02589_ _02597_ _02602_ net551 vssd1 vssd1 vccd1 vccd1 _02603_ sky130_fd_sc_hd__o211a_2
XFILLER_81_546 vssd1 vssd1 vccd1 vccd1 sky130_fd_sc_hd__fill_2
X_06503_ cell0.CB_0.config_dataA\[12\] vssd1 vssd1 vccd1 vccd1 _01573_ sky130_fd_sc_hd__inv_2
XANTENNA__11093__A2 _05847_ vssd1 vssd1 vccd1 vccd1 sky130_fd_sc_hd__diode_2
X_07483_ cell2.SB0.route_sel\[112\] cell2.SB0.route_sel\[113\] _02535_ vssd1 vssd1
+ vccd1 vccd1 _02536_ sky130_fd_sc_hd__a21oi_1
XTAP_TAPCELL_ROW_66_1296 vssd1 vccd1 sky130_fd_sc_hd__tapvpwrvgnd_1
XTAP_TAPCELL_ROW_45_980 vssd1 vccd1 sky130_fd_sc_hd__tapvpwrvgnd_1
XANTENNA__07297__A1 net85 vssd1 vssd1 vccd1 vccd1 sky130_fd_sc_hd__diode_2
X_09222_ net317 _04241_ vssd1 vssd1 vccd1 vccd1 _04249_ sky130_fd_sc_hd__nor2_2
XANTENNA__09038__A2 _03817_ vssd1 vssd1 vccd1 vccd1 sky130_fd_sc_hd__diode_2
XANTENNA__08274__X cell0.CB_1.le_outA vssd1 vssd1 vccd1 vccd1 sky130_fd_sc_hd__diode_2
X_06434_ cell1.SB0.route_sel\[15\] vssd1 vssd1 vccd1 vccd1 _01504_ sky130_fd_sc_hd__inv_2
X_09153_ cell2.SB0.route_sel\[3\] cell2.SB0.route_sel\[2\] _04180_ vssd1 vssd1 vccd1
+ vccd1 _04181_ sky130_fd_sc_hd__a21oi_1
XANTENNA__08246__A0 bus1_0\[6\] vssd1 vssd1 vccd1 vccd1 sky130_fd_sc_hd__diode_2
X_08104_ _03140_ _03141_ _03143_ _03145_ vssd1 vssd1 vccd1 vccd1 _03146_ sky130_fd_sc_hd__o22a_1
X_09084_ _03894_ _04090_ _04091_ _03890_ vssd1 vssd1 vccd1 vccd1 _04114_ sky130_fd_sc_hd__a22o_1
X_08035_ _03072_ _03073_ _03075_ _03076_ vssd1 vssd1 vccd1 vccd1 _03077_ sky130_fd_sc_hd__o22a_1
Xinput91 SBsouth_in[4] vssd1 vssd1 vccd1 vccd1 net91 sky130_fd_sc_hd__clkbuf_2
Xinput80 SBsouth_in[23] vssd1 vssd1 vccd1 vccd1 net80 sky130_fd_sc_hd__dlymetal6s2s_1
XFILLER_1_517 vccd1 vssd1 vccd1 vssd1 sky130_ef_sc_hd__decap_40_12
XANTENNA_fanout591_A net592 vssd1 vssd1 vccd1 vccd1 sky130_fd_sc_hd__diode_2
XANTENNA__08013__A3 net338 vssd1 vssd1 vccd1 vccd1 sky130_fd_sc_hd__diode_2
XANTENNA__07221__A1 _02257_ vssd1 vssd1 vccd1 vccd1 sky130_fd_sc_hd__diode_2
X_09986_ cell2.LEI0.config_data\[23\] _04989_ vssd1 vssd1 vccd1 vccd1 _04990_ sky130_fd_sc_hd__nor2_1
XFILLER_103_467 vssd1 vssd1 vccd1 vccd1 sky130_fd_sc_hd__fill_4
XFILLER_77_808 vssd1 vssd1 vccd1 vccd1 sky130_fd_sc_hd__fill_1
XANTENNA__06840__A1_N net314 vssd1 vssd1 vccd1 vccd1 sky130_fd_sc_hd__diode_2
X_08937_ cell1.LE_0A.config_data\[7\] cell1.LE_0A.config_data\[6\] _03936_ vssd1 vssd1
+ vccd1 vccd1 _03969_ sky130_fd_sc_hd__mux2_1
XANTENNA_fanout856_A net863 vssd1 vssd1 vccd1 vccd1 sky130_fd_sc_hd__diode_2
XFILLER_85_841 vssd1 vssd1 vccd1 vccd1 sky130_fd_sc_hd__fill_1
X_08868_ net331 net326 net336 net324 cell1.LEI0.config_data\[12\] cell1.LEI0.config_data\[13\]
+ vssd1 vssd1 vccd1 vccd1 _03900_ sky130_fd_sc_hd__mux4_1
XTAP_TAPCELL_ROW_4_366 vssd1 vccd1 sky130_fd_sc_hd__tapvpwrvgnd_1
XFILLER_123_55 vssd1 vssd1 vccd1 vccd1 sky130_fd_sc_hd__fill_1
XFILLER_84_351 vssd1 vssd1 vccd1 vccd1 sky130_fd_sc_hd__fill_2
XFILLER_83_15 vccd1 vssd1 vccd1 vssd1 sky130_ef_sc_hd__decap_40_12
XFILLER_57_587 vssd1 vssd1 vccd1 vccd1 sky130_fd_sc_hd__fill_1
XFILLER_57_565 vssd1 vssd1 vccd1 vccd1 sky130_fd_sc_hd__fill_1
X_07819_ _02862_ _02863_ _02860_ vssd1 vssd1 vccd1 vccd1 _02864_ sky130_fd_sc_hd__a21oi_1
XANTENNA__08721__A1 net32 vssd1 vssd1 vccd1 vccd1 sky130_fd_sc_hd__diode_2
XANTENNA__07353__X _02409_ vssd1 vssd1 vccd1 vccd1 sky130_fd_sc_hd__diode_2
XFILLER_83_37 vssd1 vssd1 vccd1 vccd1 sky130_fd_sc_hd__fill_1
X_08799_ net470 net469 vssd1 vssd1 vccd1 vccd1 _03831_ sky130_fd_sc_hd__nor2_1
X_10830_ _05779_ _05782_ _05785_ cell3.CB_1.config_dataB\[13\] vssd1 vssd1 vccd1 vccd1
+ _05786_ sky130_fd_sc_hd__and4bb_1
XFILLER_16_53 vccd1 vssd1 vccd1 vssd1 sky130_ef_sc_hd__decap_40_12
X_10761_ _05510_ _05693_ _05715_ _05716_ vssd1 vssd1 vccd1 vccd1 _05717_ sky130_fd_sc_hd__a211o_1
XANTENNA__07827__A3 bus2_0\[15\] vssd1 vssd1 vccd1 vccd1 sky130_fd_sc_hd__diode_2
XANTENNA__08485__A0 net1 vssd1 vssd1 vccd1 vccd1 sky130_fd_sc_hd__diode_2
X_12500_ cell2.LEI0.config_data\[14\] net1370 net840 vssd1 vssd1 vccd1 vccd1 _00929_
+ sky130_fd_sc_hd__mux2_1
X_10692_ cell3.CB_1.config_dataA\[17\] _05649_ cell3.CB_1.config_dataA\[18\] vssd1
+ vssd1 vccd1 vccd1 _05650_ sky130_fd_sc_hd__a21bo_1
X_13480_ clknet_leaf_10_clk _00452_ net569 vssd1 vssd1 vccd1 vccd1 cell0.SB0.route_sel\[121\]
+ sky130_fd_sc_hd__dfstp_1
XFILLER_139_821 vccd1 vssd1 vccd1 vssd1 sky130_ef_sc_hd__decap_40_12
X_12431_ net1315 net1284 net848 vssd1 vssd1 vccd1 vccd1 _00863_ sky130_fd_sc_hd__mux2_1
XFILLER_9_639 vccd1 vssd1 vccd1 vssd1 sky130_ef_sc_hd__decap_40_12
XFILLER_13_679 vssd1 vssd1 vccd1 vccd1 sky130_fd_sc_hd__fill_1
XTAP_TAPCELL_ROW_23_652 vssd1 vccd1 sky130_fd_sc_hd__tapvpwrvgnd_1
XANTENNA__08237__B1 _02136_ vssd1 vssd1 vccd1 vccd1 sky130_fd_sc_hd__diode_2
XANTENNA__10044__A0 bus3_2\[6\] vssd1 vssd1 vccd1 vccd1 sky130_fd_sc_hd__diode_2
XFILLER_32_41 vccd1 vssd1 vccd1 vssd1 sky130_ef_sc_hd__decap_40_12
XFILLER_32_63 vssd1 vssd1 vccd1 vccd1 sky130_fd_sc_hd__fill_1
XTAP_TAPCELL_ROW_97_1757 vssd1 vccd1 sky130_fd_sc_hd__tapvpwrvgnd_1
XFILLER_32_85 vssd1 vssd1 vccd1 vccd1 sky130_fd_sc_hd__fill_1
X_12362_ cell1.SB0.route_sel\[100\] cell1.SB0.route_sel\[99\] net870 vssd1 vssd1 vccd1
+ vccd1 _00795_ sky130_fd_sc_hd__mux2_1
X_14101_ clknet_leaf_50_clk _01073_ net712 vssd1 vssd1 vccd1 vccd1 cell3.SB0.route_sel\[109\]
+ sky130_fd_sc_hd__dfstp_1
XTAP_TAPCELL_ROW_97_1768 vssd1 vccd1 sky130_fd_sc_hd__tapvpwrvgnd_1
X_11313_ net293 _06221_ _04565_ vssd1 vssd1 vccd1 vccd1 net151 sky130_fd_sc_hd__mux2_1
X_12293_ cell1.SB0.route_sel\[31\] cell1.SB0.route_sel\[30\] net857 vssd1 vssd1 vccd1
+ vccd1 _00726_ sky130_fd_sc_hd__mux2_1
X_14032_ clknet_leaf_49_clk _01004_ net706 vssd1 vssd1 vccd1 vccd1 cell3.SB0.route_sel\[40\]
+ sky130_fd_sc_hd__dfstp_2
X_11244_ net698 cell1.LE_1B.reset_mode vssd1 vssd1 vccd1 vccd1 _11244_/X sky130_fd_sc_hd__xor2_2
Xclkbuf_1_1__f_cell3.LE_0B.sel_clk clknet_0_cell3.LE_0B.sel_clk vssd1 vssd1 vccd1
+ vccd1 clknet_1_1__leaf_cell3.LE_0B.sel_clk sky130_fd_sc_hd__clkbuf_16
X_11175_ net45 _06108_ _06110_ net46 cell3.CB_0.config_dataB\[13\] vssd1 vssd1 vccd1
+ vccd1 _06127_ sky130_fd_sc_hd__a221o_1
XFILLER_121_242 vssd1 vssd1 vccd1 vccd1 sky130_fd_sc_hd__fill_1
XFILLER_121_231 vssd1 vssd1 vccd1 vccd1 sky130_fd_sc_hd__fill_1
XANTENNA_input38_X net38 vssd1 vssd1 vccd1 vccd1 sky130_fd_sc_hd__diode_2
XTAP_TAPCELL_ROW_128_2234 vssd1 vccd1 sky130_fd_sc_hd__tapvpwrvgnd_1
XTAP_TAPCELL_ROW_128_2223 vssd1 vccd1 sky130_fd_sc_hd__tapvpwrvgnd_1
XFILLER_79_167 vssd1 vssd1 vccd1 vccd1 sky130_fd_sc_hd__fill_1
X_10126_ _01617_ cell2.SB0.route_sel\[63\] cell2.SB0.route_sel\[60\] _01619_ _05126_
+ vssd1 vssd1 vccd1 vccd1 _05127_ sky130_fd_sc_hd__a221o_1
XANTENNA__08960__A1 bus3_1\[9\] vssd1 vssd1 vccd1 vccd1 sky130_fd_sc_hd__diode_2
XANTENNA_output141_A net141 vssd1 vssd1 vccd1 vccd1 sky130_fd_sc_hd__diode_2
XFILLER_0_561 vssd1 vssd1 vccd1 vccd1 sky130_fd_sc_hd__fill_1
XANTENNA_output239_A net239 vssd1 vssd1 vccd1 vccd1 sky130_fd_sc_hd__diode_2
X_10057_ cell2.CB_1.config_dataB\[17\] _05059_ _05060_ _05051_ vssd1 vssd1 vccd1 vccd1
+ _05061_ sky130_fd_sc_hd__o211a_1
XFILLER_57_60 vssd1 vssd1 vccd1 vccd1 sky130_fd_sc_hd__fill_1
XTAP_TAPCELL_ROW_50_1064 vssd1 vccd1 sky130_fd_sc_hd__tapvpwrvgnd_1
XTAP_TAPCELL_ROW_50_1053 vssd1 vccd1 sky130_fd_sc_hd__tapvpwrvgnd_1
XFILLER_48_587 vssd1 vssd1 vccd1 vccd1 sky130_fd_sc_hd__fill_1
XTAP_TAPCELL_ROW_141_2423 vssd1 vccd1 sky130_fd_sc_hd__tapvpwrvgnd_1
XANTENNA_clkload0_A clknet_4_0_0_clk vssd1 vssd1 vccd1 vccd1 sky130_fd_sc_hd__diode_2
XFILLER_63_568 vssd1 vssd1 vccd1 vccd1 sky130_fd_sc_hd__fill_1
X_13816_ clknet_leaf_104_clk _00788_ net661 vssd1 vssd1 vccd1 vccd1 cell1.SB0.route_sel\[93\]
+ sky130_fd_sc_hd__dfstp_1
XFILLER_35_259 vssd1 vssd1 vccd1 vccd1 sky130_fd_sc_hd__fill_1
X_10959_ _05912_ vssd1 vssd1 vccd1 vccd1 _05913_ sky130_fd_sc_hd__inv_2
XANTENNA__12756__S net933 vssd1 vssd1 vccd1 vccd1 sky130_fd_sc_hd__diode_2
XTAP_TAPCELL_ROW_106_1897 vssd1 vccd1 sky130_fd_sc_hd__tapvpwrvgnd_1
X_13747_ clknet_leaf_107_clk _00719_ net658 vssd1 vssd1 vccd1 vccd1 cell1.SB0.route_sel\[24\]
+ sky130_fd_sc_hd__dfstp_2
X_13678_ clknet_leaf_30_clk _00650_ net622 vssd1 vssd1 vccd1 vccd1 cell2.CB_0.config_dataB\[5\]
+ sky130_fd_sc_hd__dfstp_1
XTAP_TAPCELL_ROW_139_2396 vssd1 vccd1 sky130_fd_sc_hd__tapvpwrvgnd_1
XANTENNA__09425__C1 cell3.SB0.route_sel\[45\] vssd1 vssd1 vccd1 vccd1 sky130_fd_sc_hd__diode_2
X_12629_ cell3.SB0.route_sel\[94\] cell3.SB0.route_sel\[93\] net918 vssd1 vssd1 vccd1
+ vccd1 _01058_ sky130_fd_sc_hd__mux2_1
XFILLER_117_559 vssd1 vssd1 vccd1 vccd1 sky130_fd_sc_hd__fill_1
Xhold105 cell1.LEI0.config_data\[17\] vssd1 vssd1 vccd1 vccd1 net1064 sky130_fd_sc_hd__dlygate4sd3_1
Xhold116 _00583_ vssd1 vssd1 vccd1 vccd1 net1075 sky130_fd_sc_hd__dlygate4sd3_1
Xhold149 _01395_ vssd1 vssd1 vccd1 vccd1 net1108 sky130_fd_sc_hd__dlygate4sd3_1
Xhold138 cell1.LE_0B.config_data\[11\] vssd1 vssd1 vccd1 vccd1 net1097 sky130_fd_sc_hd__dlygate4sd3_1
Xhold127 cell0.LE_0A.config_data\[4\] vssd1 vssd1 vccd1 vccd1 net1086 sky130_fd_sc_hd__dlygate4sd3_1
XANTENNA__08400__A0 bus1_0\[6\] vssd1 vssd1 vccd1 vccd1 sky130_fd_sc_hd__diode_2
Xfanout618 net619 vssd1 vssd1 vccd1 vccd1 net618 sky130_fd_sc_hd__clkbuf_2
Xfanout607 net608 vssd1 vssd1 vccd1 vccd1 net607 sky130_fd_sc_hd__clkbuf_4
X_09840_ _04527_ _04837_ _04555_ _04835_ vssd1 vssd1 vccd1 vccd1 _04846_ sky130_fd_sc_hd__a2bb2o_1
Xfanout629 net631 vssd1 vssd1 vccd1 vccd1 net629 sky130_fd_sc_hd__clkbuf_4
X_09771_ bus3_2\[0\] bus3_2\[2\] bus3_2\[1\] bus3_2\[3\] net443 net444 vssd1 vssd1
+ vccd1 vccd1 _04777_ sky130_fd_sc_hd__mux4_1
XFILLER_100_404 vssd1 vssd1 vccd1 vccd1 sky130_fd_sc_hd__fill_1
XANTENNA__09653__X _04668_ vssd1 vssd1 vccd1 vccd1 sky130_fd_sc_hd__diode_2
XPHY_EDGE_ROW_13_Left_156 vssd1 vssd1 vccd1 vccd1 sky130_fd_sc_hd__decap_3
X_06983_ net31 _02048_ vssd1 vssd1 vccd1 vccd1 _02049_ sky130_fd_sc_hd__or2_1
XANTENNA__09813__B _04498_ vssd1 vssd1 vccd1 vccd1 sky130_fd_sc_hd__diode_2
X_08722_ net4 net5 net6 net7 net456 net454 vssd1 vssd1 vccd1 vccd1 _03756_ sky130_fd_sc_hd__mux4_1
XTAP_TAPCELL_ROW_1_325 vssd1 vccd1 sky130_fd_sc_hd__tapvpwrvgnd_1
XANTENNA__07173__X _02234_ vssd1 vssd1 vccd1 vccd1 sky130_fd_sc_hd__diode_2
XTAP_TAPCELL_ROW_68_1325 vssd1 vccd1 sky130_fd_sc_hd__tapvpwrvgnd_1
XANTENNA__10510__A1 net335 vssd1 vssd1 vccd1 vccd1 sky130_fd_sc_hd__diode_2
X_08653_ _03473_ _03670_ _03671_ _03477_ cell1.CB_1.config_dataB\[7\] vssd1 vssd1
+ vccd1 vccd1 _03687_ sky130_fd_sc_hd__a221o_1
XANTENNA__09259__A2 _02716_ vssd1 vssd1 vccd1 vccd1 sky130_fd_sc_hd__diode_2
X_08584_ cell1.LE_1A.config_data\[13\] cell1.LE_1A.config_data\[12\] _03546_ vssd1
+ vssd1 vccd1 vccd1 _03620_ sky130_fd_sc_hd__mux2_1
X_07604_ cell1.SB0.route_sel\[0\] cell1.SB0.route_sel\[1\] _02653_ vssd1 vssd1 vccd1
+ vccd1 _02654_ sky130_fd_sc_hd__a21oi_1
XTAP_TAPCELL_ROW_81_1525 vssd1 vccd1 sky130_fd_sc_hd__tapvpwrvgnd_1
X_07535_ _01946_ _02339_ _02557_ _02584_ vssd1 vssd1 vccd1 vccd1 _02586_ sky130_fd_sc_hd__a211o_1
XANTENNA__07901__X _02945_ vssd1 vssd1 vccd1 vccd1 sky130_fd_sc_hd__diode_2
XFILLER_35_793 vssd1 vssd1 vccd1 vccd1 sky130_fd_sc_hd__fill_1
X_07466_ _01903_ _02379_ vssd1 vssd1 vccd1 vccd1 _02519_ sky130_fd_sc_hd__nand2_1
XTAP_TAPCELL_ROW_40_909 vssd1 vccd1 sky130_fd_sc_hd__tapvpwrvgnd_1
XFILLER_22_432 vssd1 vssd1 vccd1 vccd1 sky130_fd_sc_hd__fill_1
X_09205_ net289 net9 _04229_ vssd1 vssd1 vccd1 vccd1 _04232_ sky130_fd_sc_hd__mux2_1
XFILLER_50_774 vssd1 vssd1 vccd1 vccd1 sky130_fd_sc_hd__fill_1
XPHY_EDGE_ROW_22_Left_165 vssd1 vssd1 vccd1 vccd1 sky130_fd_sc_hd__decap_3
XFILLER_22_454 vssd1 vssd1 vccd1 vccd1 sky130_fd_sc_hd__fill_1
X_06417_ cell0.SB0.route_sel\[121\] vssd1 vssd1 vccd1 vccd1 _01487_ sky130_fd_sc_hd__inv_2
X_07397_ cell2.SB0.route_sel\[107\] cell2.SB0.route_sel\[106\] _02451_ vssd1 vssd1
+ vccd1 vccd1 _02452_ sky130_fd_sc_hd__a21oi_1
XTAP_TAPCELL_ROW_20_611 vssd1 vccd1 sky130_fd_sc_hd__tapvpwrvgnd_1
XFILLER_136_813 vccd1 vssd1 vccd1 vssd1 sky130_ef_sc_hd__decap_40_12
XANTENNA__10577__A1 net22 vssd1 vssd1 vccd1 vccd1 sky130_fd_sc_hd__diode_2
X_09136_ _04165_ _04164_ _04051_ vssd1 vssd1 vccd1 vccd1 _04166_ sky130_fd_sc_hd__mux2_1
X_09067_ net480 _03820_ vssd1 vssd1 vccd1 vccd1 _04097_ sky130_fd_sc_hd__nand2_1
XANTENNA__07348__X bus2_0\[12\] vssd1 vssd1 vccd1 vccd1 sky130_fd_sc_hd__diode_2
XTAP_TAPCELL_ROW_79_1498 vssd1 vccd1 sky130_fd_sc_hd__tapvpwrvgnd_1
XTAP_TAPCELL_ROW_79_1487 vssd1 vccd1 sky130_fd_sc_hd__tapvpwrvgnd_1
X_08018_ net532 net533 vssd1 vssd1 vccd1 vccd1 _03060_ sky130_fd_sc_hd__nor2_1
XTAP_TAPCELL_ROW_9_447 vssd1 vccd1 sky130_fd_sc_hd__tapvpwrvgnd_1
XTAP_TAPCELL_ROW_9_436 vssd1 vccd1 sky130_fd_sc_hd__tapvpwrvgnd_1
XTAP_TAPCELL_ROW_92_1687 vssd1 vccd1 sky130_fd_sc_hd__tapvpwrvgnd_1
XPHY_EDGE_ROW_31_Left_174 vssd1 vssd1 vccd1 vccd1 sky130_fd_sc_hd__decap_3
XFILLER_134_21 vssd1 vssd1 vccd1 vccd1 sky130_fd_sc_hd__fill_4
X_09969_ net407 _04696_ cell2.CB_1.config_dataB\[6\] vssd1 vssd1 vccd1 vccd1 _04973_
+ sky130_fd_sc_hd__o21ai_1
XANTENNA__08942__B2 bus3_1\[4\] vssd1 vssd1 vccd1 vccd1 sky130_fd_sc_hd__diode_2
XANTENNA__08942__A1 bus3_1\[5\] vssd1 vssd1 vccd1 vccd1 sky130_fd_sc_hd__diode_2
XFILLER_134_65 vccd1 vssd1 vccd1 vssd1 sky130_ef_sc_hd__decap_40_12
XFILLER_94_25 vssd1 vssd1 vccd1 vccd1 sky130_fd_sc_hd__fill_2
XFILLER_76_148 vssd1 vssd1 vccd1 vccd1 sky130_fd_sc_hd__fill_1
XANTENNA__06953__B1 bus1_0\[8\] vssd1 vssd1 vccd1 vccd1 sky130_fd_sc_hd__diode_2
X_12980_ net1394 cell3.LEI0.config_data\[0\] net945 vssd1 vssd1 vccd1 vccd1 _01408_
+ sky130_fd_sc_hd__mux2_1
XFILLER_85_660 vssd1 vssd1 vccd1 vccd1 sky130_fd_sc_hd__fill_1
XFILLER_85_682 vssd1 vssd1 vccd1 vccd1 sky130_fd_sc_hd__fill_2
XFILLER_45_513 vssd1 vssd1 vccd1 vccd1 sky130_fd_sc_hd__fill_1
XFILLER_18_738 vssd1 vssd1 vccd1 vccd1 sky130_fd_sc_hd__fill_1
XTAP_TAPCELL_ROW_28_722 vssd1 vccd1 sky130_fd_sc_hd__tapvpwrvgnd_1
XTAP_TAPCELL_ROW_28_733 vssd1 vccd1 sky130_fd_sc_hd__tapvpwrvgnd_1
X_11931_ cell0.SB0.route_sel\[37\] cell0.SB0.route_sel\[36\] net758 vssd1 vssd1 vccd1
+ vccd1 _00368_ sky130_fd_sc_hd__mux2_1
XTAP_TAPCELL_ROW_123_2153 vssd1 vccd1 sky130_fd_sc_hd__tapvpwrvgnd_1
XFILLER_72_343 vssd1 vssd1 vccd1 vccd1 sky130_fd_sc_hd__fill_1
X_11862_ cell1.CB_0.config_dataB\[18\] cell1.CB_0.config_dataB\[17\] net892 vssd1
+ vssd1 vccd1 vccd1 _00299_ sky130_fd_sc_hd__mux2_1
X_10813_ net366 _05767_ _05768_ vssd1 vssd1 vccd1 vccd1 _05769_ sky130_fd_sc_hd__a21oi_1
X_13601_ clknet_leaf_94_clk _00573_ net686 vssd1 vssd1 vccd1 vccd1 cell1.LEI0.config_data\[22\]
+ sky130_fd_sc_hd__dfrtp_1
X_13532_ clknet_leaf_91_clk _00504_ net696 vssd1 vssd1 vccd1 vccd1 cell1.LE_1A.reset_mode
+ sky130_fd_sc_hd__dfrtp_1
X_11793_ net1335 cell0.LEI0.config_data\[42\] net792 vssd1 vssd1 vccd1 vccd1 _00230_
+ sky130_fd_sc_hd__mux2_1
XPHY_EDGE_ROW_40_Left_183 vssd1 vssd1 vccd1 vccd1 sky130_fd_sc_hd__decap_3
XFILLER_13_432 vssd1 vssd1 vccd1 vccd1 sky130_fd_sc_hd__fill_1
X_10744_ net273 _05548_ _05692_ vssd1 vssd1 vccd1 vccd1 _05700_ sky130_fd_sc_hd__a21oi_1
XFILLER_40_251 vssd1 vssd1 vccd1 vccd1 sky130_fd_sc_hd__fill_1
X_10675_ net285 net280 cell3.LEI0.config_data\[30\] vssd1 vssd1 vccd1 vccd1 _05633_
+ sky130_fd_sc_hd__mux2_1
XFILLER_9_447 vssd1 vssd1 vccd1 vccd1 sky130_fd_sc_hd__fill_1
X_13463_ clknet_leaf_1_clk _00435_ net560 vssd1 vssd1 vccd1 vccd1 cell0.SB0.route_sel\[104\]
+ sky130_fd_sc_hd__dfstp_2
X_12414_ cell2.CB_1.config_dataB\[24\] cell2.CB_1.config_dataB\[23\] net830 vssd1
+ vssd1 vccd1 vccd1 _00847_ sky130_fd_sc_hd__mux2_1
X_13394_ clknet_leaf_1_clk _00366_ net553 vssd1 vssd1 vccd1 vccd1 cell0.SB0.route_sel\[35\]
+ sky130_fd_sc_hd__dfstp_1
XANTENNA_output189_A net189 vssd1 vssd1 vccd1 vccd1 sky130_fd_sc_hd__diode_2
XANTENNA__10032__A3 bus3_2\[11\] vssd1 vssd1 vccd1 vccd1 sky130_fd_sc_hd__diode_2
XANTENNA__10568__B2 cell3.SB0.route_sel\[100\] vssd1 vssd1 vccd1 vccd1 sky130_fd_sc_hd__diode_2
X_12345_ cell1.SB0.route_sel\[83\] cell1.SB0.route_sel\[82\] net862 vssd1 vssd1 vccd1
+ vccd1 _00778_ sky130_fd_sc_hd__mux2_1
XANTENNA__09973__A3 bus3_2\[15\] vssd1 vssd1 vccd1 vccd1 sky130_fd_sc_hd__diode_2
XANTENNA__07984__A2 _03024_ vssd1 vssd1 vccd1 vccd1 sky130_fd_sc_hd__diode_2
XFILLER_5_653 vccd1 vssd1 vccd1 vssd1 sky130_ef_sc_hd__decap_40_12
XFILLER_4_141 vssd1 vssd1 vccd1 vccd1 sky130_fd_sc_hd__fill_2
XFILLER_142_838 vssd1 vssd1 vccd1 vccd1 sky130_fd_sc_hd__fill_2
X_12276_ cell1.SB0.route_sel\[14\] cell1.SB0.route_sel\[13\] net864 vssd1 vssd1 vccd1
+ vccd1 _00709_ sky130_fd_sc_hd__mux2_1
XFILLER_5_697 vccd1 vssd1 vccd1 vssd1 sky130_ef_sc_hd__decap_40_12
X_11227_ cell3.LE_0B.config_data\[10\] cell3.LE_0B.config_data\[11\] _06076_ vssd1
+ vssd1 vccd1 vccd1 _06179_ sky130_fd_sc_hd__mux2_1
X_14015_ clknet_leaf_80_clk _00987_ net707 vssd1 vssd1 vccd1 vccd1 cell3.SB0.route_sel\[23\]
+ sky130_fd_sc_hd__dfstp_1
X_11158_ net384 net385 vssd1 vssd1 vccd1 vccd1 _06110_ sky130_fd_sc_hd__and2b_1
XFILLER_95_424 vssd1 vssd1 vccd1 vccd1 sky130_fd_sc_hd__fill_1
XANTENNA__09473__X bus3_1\[6\] vssd1 vssd1 vccd1 vccd1 sky130_fd_sc_hd__diode_2
XFILLER_110_757 vssd1 vssd1 vccd1 vccd1 sky130_fd_sc_hd__fill_1
XANTENNA__10740__A1 net22 vssd1 vssd1 vccd1 vccd1 sky130_fd_sc_hd__diode_2
X_10109_ cell2.SB0.route_sel\[107\] cell2.SB0.route_sel\[106\] cell2.SB0.route_sel\[110\]
+ _01643_ _05109_ vssd1 vssd1 vccd1 vccd1 _05110_ sky130_fd_sc_hd__o221a_1
XANTENNA__13209__Q cell0.LE_0A.config_data\[16\] vssd1 vssd1 vccd1 vccd1 sky130_fd_sc_hd__diode_2
XFILLER_49_841 vssd1 vssd1 vccd1 vccd1 sky130_fd_sc_hd__fill_1
XFILLER_0_380 vssd1 vssd1 vccd1 vccd1 sky130_fd_sc_hd__fill_2
X_11089_ cell3.LE_0A.dff0_out cell3.LE_0A.dff1_out cell3.LE_0A.reset_val vssd1 vssd1
+ vccd1 vccd1 cell3.LE_0A.dff_out sky130_fd_sc_hd__mux2_1
XANTENNA__07434__A cell0.CB_0.le_outB vssd1 vssd1 vccd1 vccd1 sky130_fd_sc_hd__diode_2
XTAP_TAPCELL_ROW_108_1926 vssd1 vccd1 sky130_fd_sc_hd__tapvpwrvgnd_1
XFILLER_91_696 vssd1 vssd1 vccd1 vccd1 sky130_fd_sc_hd__fill_2
X_07320_ _02087_ _02376_ vssd1 vssd1 vccd1 vccd1 _02377_ sky130_fd_sc_hd__or2_2
XANTENNA__07440__Y _02494_ vssd1 vssd1 vccd1 vccd1 sky130_fd_sc_hd__diode_2
XANTENNA__09661__A2 _04674_ vssd1 vssd1 vccd1 vccd1 sky130_fd_sc_hd__diode_2
XTAP_TAPCELL_ROW_63_1255 vssd1 vccd1 sky130_fd_sc_hd__tapvpwrvgnd_1
X_07251_ _01993_ _02084_ bus3_2\[11\] vssd1 vssd1 vccd1 vccd1 _02310_ sky130_fd_sc_hd__o21a_1
XANTENNA__07672__A1 net361 vssd1 vssd1 vccd1 vccd1 sky130_fd_sc_hd__diode_2
Xclkbuf_0_cell2.LE_0A.sel_clk cell2.LE_0A.sel_clk vssd1 vssd1 vccd1 vccd1 clknet_0_cell2.LE_0A.sel_clk
+ sky130_fd_sc_hd__clkbuf_16
X_07182_ net303 _01903_ _02083_ _02242_ vssd1 vssd1 vccd1 vccd1 _02243_ sky130_fd_sc_hd__a31o_1
XFILLER_129_172 vssd1 vssd1 vccd1 vccd1 sky130_fd_sc_hd__fill_1
XANTENNA__09964__A3 _04399_ vssd1 vssd1 vccd1 vccd1 sky130_fd_sc_hd__diode_2
XANTENNA__14351__SET_B net727 vssd1 vssd1 vccd1 vccd1 sky130_fd_sc_hd__diode_2
XANTENNA__08712__B _03529_ vssd1 vssd1 vccd1 vccd1 sky130_fd_sc_hd__diode_2
Xfanout404 cell2.CB_1.config_dataB\[10\] vssd1 vssd1 vccd1 vccd1 net404 sky130_fd_sc_hd__dlymetal6s2s_1
Xfanout426 cell2.CB_0.config_dataB\[11\] vssd1 vssd1 vccd1 vccd1 net426 sky130_fd_sc_hd__clkbuf_2
X_09823_ cell2.LEI0.config_data\[8\] _04826_ _04828_ vssd1 vssd1 vccd1 vccd1 _04829_
+ sky130_fd_sc_hd__or3_1
Xfanout448 cell2.CB_1.config_dataA\[0\] vssd1 vssd1 vccd1 vccd1 net448 sky130_fd_sc_hd__buf_1
Xfanout415 net416 vssd1 vssd1 vccd1 vccd1 net415 sky130_fd_sc_hd__clkbuf_2
Xfanout437 cell2.CB_1.config_dataA\[16\] vssd1 vssd1 vccd1 vccd1 net437 sky130_fd_sc_hd__buf_2
XANTENNA__08924__B2 _03830_ vssd1 vssd1 vccd1 vccd1 sky130_fd_sc_hd__diode_2
XANTENNA__08924__A1 _03826_ vssd1 vssd1 vccd1 vccd1 sky130_fd_sc_hd__diode_2
Xfanout459 cell1.CB_1.config_dataB\[5\] vssd1 vssd1 vccd1 vccd1 net459 sky130_fd_sc_hd__clkbuf_2
X_09754_ _04555_ _04757_ cell2.CB_1.config_dataA\[7\] vssd1 vssd1 vccd1 vccd1 _04760_
+ sky130_fd_sc_hd__a21oi_1
X_06966_ cell0.CB_0.config_dataB\[22\] cell0.CB_0.config_dataB\[23\] vssd1 vssd1 vccd1
+ vccd1 _02032_ sky130_fd_sc_hd__nand2b_2
X_09685_ _02518_ _04697_ _04698_ vssd1 vssd1 vccd1 vccd1 _04699_ sky130_fd_sc_hd__o21ai_1
X_06897_ _01842_ _01964_ vssd1 vssd1 vccd1 vccd1 _01965_ sky130_fd_sc_hd__nor2_1
X_08705_ net1 net12 net23 net26 net456 net454 vssd1 vssd1 vccd1 vccd1 _03739_ sky130_fd_sc_hd__mux4_1
XPHY_EDGE_ROW_126_Right_126 vssd1 vssd1 vccd1 vccd1 sky130_fd_sc_hd__decap_3
Xclkbuf_leaf_93_clk clknet_4_11_0_clk vssd1 vssd1 vccd1 vccd1 clknet_leaf_93_clk sky130_fd_sc_hd__clkbuf_8
X_08636_ net457 net459 vssd1 vssd1 vccd1 vccd1 _03670_ sky130_fd_sc_hd__and2b_1
XFILLER_82_696 vssd1 vssd1 vccd1 vccd1 sky130_fd_sc_hd__fill_1
XFILLER_54_365 vssd1 vssd1 vccd1 vccd1 sky130_fd_sc_hd__fill_1
XANTENNA__10247__A0 net33 vssd1 vssd1 vccd1 vccd1 sky130_fd_sc_hd__diode_2
XANTENNA_fanout342_X net342 vssd1 vssd1 vccd1 vccd1 sky130_fd_sc_hd__diode_2
XANTENNA__09101__A1 bus3_1\[1\] vssd1 vssd1 vccd1 vccd1 sky130_fd_sc_hd__diode_2
X_08567_ _02444_ _03493_ _03588_ vssd1 vssd1 vccd1 vccd1 _03603_ sky130_fd_sc_hd__o21ai_1
X_07518_ _02569_ net336 _02568_ vssd1 vssd1 vccd1 vccd1 _02570_ sky130_fd_sc_hd__mux2_1
X_08498_ net497 _03533_ _03530_ net496 vssd1 vssd1 vccd1 vccd1 _03534_ sky130_fd_sc_hd__o211a_1
X_07449_ _01841_ _02358_ vssd1 vssd1 vccd1 vccd1 _02503_ sky130_fd_sc_hd__nor2_1
XANTENNA__10808__A2_N _05489_ vssd1 vssd1 vccd1 vccd1 sky130_fd_sc_hd__diode_2
X_10460_ _01733_ cell3.SB0.route_sel\[90\] vssd1 vssd1 vccd1 vccd1 _05447_ sky130_fd_sc_hd__nand2_1
X_09119_ bus3_1\[12\] bus3_1\[13\] bus3_1\[14\] bus3_1\[15\] net476 net475 vssd1 vssd1
+ vccd1 vccd1 _04149_ sky130_fd_sc_hd__mux4_1
X_10391_ net424 _05088_ _05389_ net423 vssd1 vssd1 vccd1 vccd1 _05390_ sky130_fd_sc_hd__o211a_1
XANTENNA__11211__A2 net56 vssd1 vssd1 vccd1 vccd1 sky130_fd_sc_hd__diode_2
XANTENNA__09955__A3 bus3_2\[3\] vssd1 vssd1 vccd1 vccd1 sky130_fd_sc_hd__diode_2
XTAP_TAPCELL_ROW_94_1716 vssd1 vccd1 sky130_fd_sc_hd__tapvpwrvgnd_1
XANTENNA__08114__S _03087_ vssd1 vssd1 vccd1 vccd1 sky130_fd_sc_hd__diode_2
X_12130_ net1541 cell1.LEI0.config_data\[11\] net903 vssd1 vssd1 vccd1 vccd1 _00563_
+ sky130_fd_sc_hd__mux2_1
XANTENNA__07966__A2 cell0.CB_1.le_outA vssd1 vssd1 vccd1 vccd1 sky130_fd_sc_hd__diode_2
XFILLER_2_601 vccd1 vssd1 vccd1 vssd1 sky130_ef_sc_hd__decap_40_12
Xhold480 cell2.LEI0.config_data\[16\] vssd1 vssd1 vccd1 vccd1 net1439 sky130_fd_sc_hd__dlygate4sd3_1
XFILLER_8_3 vccd1 vssd1 vccd1 vssd1 sky130_ef_sc_hd__decap_40_12
XFILLER_2_645 vccd1 vssd1 vccd1 vssd1 sky130_ef_sc_hd__decap_40_12
XFILLER_1_111 vssd1 vssd1 vccd1 vccd1 sky130_fd_sc_hd__fill_1
X_12061_ net1005 cell1.LE_1A.config_data\[11\] net888 vssd1 vssd1 vccd1 vccd1 _00497_
+ sky130_fd_sc_hd__mux2_1
X_11012_ _05856_ _05963_ _05965_ _05861_ _01810_ vssd1 vssd1 vccd1 vccd1 _05966_ sky130_fd_sc_hd__a221o_1
XFILLER_104_584 vssd1 vssd1 vccd1 vccd1 sky130_fd_sc_hd__fill_4
Xhold491 cell0.LEI0.config_data\[25\] vssd1 vssd1 vccd1 vccd1 net1450 sky130_fd_sc_hd__dlygate4sd3_1
XANTENNA__08915__B2 bus3_1\[4\] vssd1 vssd1 vccd1 vccd1 sky130_fd_sc_hd__diode_2
XANTENNA__08915__A1 bus3_1\[5\] vssd1 vssd1 vccd1 vccd1 sky130_fd_sc_hd__diode_2
XANTENNA__08391__A2 _02277_ vssd1 vssd1 vccd1 vccd1 sky130_fd_sc_hd__diode_2
X_12963_ cell3.LE_0A.config_data\[6\] net986 net927 vssd1 vssd1 vccd1 vccd1 _01391_
+ sky130_fd_sc_hd__mux2_1
XANTENNA__08679__A0 net4 vssd1 vssd1 vccd1 vccd1 sky130_fd_sc_hd__diode_2
XFILLER_18_535 vssd1 vssd1 vccd1 vccd1 sky130_fd_sc_hd__fill_2
Xclkbuf_leaf_84_clk clknet_4_9_0_clk vssd1 vssd1 vccd1 vccd1 clknet_leaf_84_clk sky130_fd_sc_hd__clkbuf_8
X_11914_ cell0.SB0.route_sel\[20\] cell0.SB0.route_sel\[19\] net763 vssd1 vssd1 vccd1
+ vccd1 _00351_ sky130_fd_sc_hd__mux2_1
X_12894_ cell3.CB_1.config_dataB\[8\] cell3.CB_1.config_dataB\[7\] net943 vssd1 vssd1
+ vccd1 vccd1 _01323_ sky130_fd_sc_hd__mux2_1
XANTENNA__09628__C1 cell3.SB0.route_sel\[100\] vssd1 vssd1 vccd1 vccd1 sky130_fd_sc_hd__diode_2
X_11845_ net484 net486 net883 vssd1 vssd1 vccd1 vccd1 _00282_ sky130_fd_sc_hd__mux2_1
XTAP_TAPCELL_ROW_103_1856 vssd1 vccd1 sky130_fd_sc_hd__tapvpwrvgnd_1
X_11776_ net1441 net1450 net794 vssd1 vssd1 vccd1 vccd1 _00213_ sky130_fd_sc_hd__mux2_1
XANTENNA__08446__A3 net3 vssd1 vssd1 vccd1 vccd1 sky130_fd_sc_hd__diode_2
X_10727_ _05683_ _05684_ _05562_ vssd1 vssd1 vccd1 vccd1 _05685_ sky130_fd_sc_hd__mux2_1
X_13515_ clknet_leaf_99_clk net1094 net681 vssd1 vssd1 vccd1 vccd1 cell1.LE_1A.config_data\[2\]
+ sky130_fd_sc_hd__dfrtp_1
XTAP_TAPCELL_ROW_136_2355 vssd1 vccd1 sky130_fd_sc_hd__tapvpwrvgnd_1
XTAP_TAPCELL_ROW_136_2344 vssd1 vccd1 sky130_fd_sc_hd__tapvpwrvgnd_1
X_13446_ clknet_leaf_123_clk _00418_ net580 vssd1 vssd1 vccd1 vccd1 cell0.SB0.route_sel\[87\]
+ sky130_fd_sc_hd__dfstp_2
Xclkload14 clknet_4_15_0_clk vssd1 vssd1 vccd1 vccd1 clkload14/X sky130_fd_sc_hd__clkbuf_8
X_10658_ net392 _05615_ vssd1 vssd1 vccd1 vccd1 _05616_ sky130_fd_sc_hd__nand2_1
Xclkload25 clknet_leaf_7_clk vssd1 vssd1 vccd1 vccd1 clkload25/Y sky130_fd_sc_hd__inv_8
XTAP_TAPCELL_ROW_11_474 vssd1 vccd1 sky130_fd_sc_hd__tapvpwrvgnd_1
XANTENNA__11202__A2 _05916_ vssd1 vssd1 vccd1 vccd1 sky130_fd_sc_hd__diode_2
Xclkload58 clknet_leaf_42_clk vssd1 vssd1 vccd1 vccd1 clkload58/Y sky130_fd_sc_hd__clkinv_8
Xclkload69 clknet_leaf_41_clk vssd1 vssd1 vccd1 vccd1 clkload69/Y sky130_fd_sc_hd__clkinv_8
Xclkload47 clknet_leaf_23_clk vssd1 vssd1 vccd1 vccd1 clkload47/Y sky130_fd_sc_hd__clkinv_1
X_10589_ cell3.SB0.route_sel\[64\] _01717_ cell3.SB0.route_sel\[69\] cell3.SB0.route_sel\[68\]
+ vssd1 vssd1 vccd1 vccd1 _05547_ sky130_fd_sc_hd__o22a_1
Xclkload36 clknet_leaf_12_clk vssd1 vssd1 vccd1 vccd1 clkload36/Y sky130_fd_sc_hd__inv_8
XANTENNA__13338__SET_B net674 vssd1 vssd1 vccd1 vccd1 sky130_fd_sc_hd__diode_2
X_13377_ clknet_leaf_131_clk _00349_ net558 vssd1 vssd1 vccd1 vccd1 cell0.SB0.route_sel\[18\]
+ sky130_fd_sc_hd__dfstp_1
X_12328_ cell1.SB0.route_sel\[66\] cell1.SB0.route_sel\[65\] net869 vssd1 vssd1 vccd1
+ vccd1 _00761_ sky130_fd_sc_hd__mux2_1
X_12259_ cell2.CB_0.config_dataA\[22\] cell2.CB_0.config_dataA\[21\] net841 vssd1
+ vssd1 vccd1 vccd1 _00692_ sky130_fd_sc_hd__mux2_1
XFILLER_68_479 vssd1 vssd1 vccd1 vccd1 sky130_fd_sc_hd__fill_1
X_06820_ cell1.CB_0.config_dataB\[23\] cell1.CB_0.config_dataB\[22\] vssd1 vssd1 vccd1
+ vccd1 _01890_ sky130_fd_sc_hd__nand2b_1
XANTENNA__12070__A net550 vssd1 vssd1 vccd1 vccd1 sky130_fd_sc_hd__diode_2
XFILLER_110_587 vssd1 vssd1 vccd1 vccd1 sky130_fd_sc_hd__fill_1
XFILLER_83_449 vssd1 vssd1 vccd1 vccd1 sky130_fd_sc_hd__fill_1
X_06751_ net335 vssd1 vssd1 vccd1 vccd1 _01821_ sky130_fd_sc_hd__inv_2
X_06682_ cell2.LE_1B.config_data\[16\] vssd1 vssd1 vccd1 vccd1 _01752_ sky130_fd_sc_hd__inv_2
X_09470_ _04477_ _04484_ _04491_ vssd1 vssd1 vccd1 vccd1 _04492_ sky130_fd_sc_hd__a21oi_1
Xclkbuf_leaf_75_clk clknet_4_14_0_clk vssd1 vssd1 vccd1 vccd1 clknet_leaf_75_clk sky130_fd_sc_hd__clkbuf_8
XFILLER_52_825 vssd1 vssd1 vccd1 vccd1 sky130_fd_sc_hd__fill_1
X_08421_ _03457_ _03458_ _03347_ vssd1 vssd1 vccd1 vccd1 _03459_ sky130_fd_sc_hd__mux2_1
XTAP_TAPCELL_ROW_19_596 vssd1 vccd1 sky130_fd_sc_hd__tapvpwrvgnd_1
XANTENNA__07611__B net355 vssd1 vssd1 vccd1 vccd1 sky130_fd_sc_hd__diode_2
X_08352_ _03388_ _03389_ cell0.CB_1.config_dataB\[12\] vssd1 vssd1 vccd1 vccd1 _03390_
+ sky130_fd_sc_hd__mux2_1
X_08283_ _03319_ _03320_ cell0.CB_1.config_dataB\[7\] vssd1 vssd1 vccd1 vccd1 _03321_
+ sky130_fd_sc_hd__mux2_1
XANTENNA__06957__B1_N net95 vssd1 vssd1 vccd1 vccd1 sky130_fd_sc_hd__diode_2
X_07303_ net322 _02046_ _02356_ vssd1 vssd1 vccd1 vccd1 _02361_ sky130_fd_sc_hd__or3_1
XFILLER_50_19 vssd1 vssd1 vccd1 vccd1 sky130_fd_sc_hd__fill_1
Xclkload8 clknet_4_8_0_clk vssd1 vssd1 vccd1 vccd1 clkload8/X sky130_fd_sc_hd__clkbuf_8
X_07234_ _02256_ _02293_ vssd1 vssd1 vccd1 vccd1 _02294_ sky130_fd_sc_hd__nor2_1
XANTENNA__13689__SET_B net619 vssd1 vssd1 vccd1 vccd1 sky130_fd_sc_hd__diode_2
XTAP_TAPCELL_ROW_30_761 vssd1 vccd1 sky130_fd_sc_hd__tapvpwrvgnd_1
X_07165_ net325 _01888_ _02063_ _02058_ _01884_ vssd1 vssd1 vccd1 vccd1 _02227_ sky130_fd_sc_hd__o32a_1
XFILLER_117_175 vssd1 vssd1 vccd1 vccd1 sky130_fd_sc_hd__fill_1
XANTENNA__07339__A net36 vssd1 vssd1 vccd1 vccd1 sky130_fd_sc_hd__diode_2
XTAP_TAPCELL_ROW_76_1446 vssd1 vccd1 sky130_fd_sc_hd__tapvpwrvgnd_1
XANTENNA__08070__B2 bus2_0\[5\] vssd1 vssd1 vccd1 vccd1 sky130_fd_sc_hd__diode_2
XANTENNA__08070__A1 bus2_0\[4\] vssd1 vssd1 vccd1 vccd1 sky130_fd_sc_hd__diode_2
X_07096_ cell1.SB0.route_sel\[72\] cell1.SB0.route_sel\[73\] vssd1 vssd1 vccd1 vccd1
+ _02160_ sky130_fd_sc_hd__nor2_1
XANTENNA__10952__B2 net46 vssd1 vssd1 vccd1 vccd1 sky130_fd_sc_hd__diode_2
XANTENNA__10952__A1 net45 vssd1 vssd1 vccd1 vccd1 sky130_fd_sc_hd__diode_2
XANTENNA__07626__X _02675_ vssd1 vssd1 vccd1 vccd1 sky130_fd_sc_hd__diode_2
XFILLER_113_370 vssd1 vssd1 vccd1 vccd1 sky130_fd_sc_hd__fill_1
XANTENNA__10704__A1 net9 vssd1 vssd1 vccd1 vccd1 sky130_fd_sc_hd__diode_2
XANTENNA_fanout671_A net672 vssd1 vssd1 vccd1 vccd1 sky130_fd_sc_hd__diode_2
XANTENNA_fanout769_A net780 vssd1 vssd1 vccd1 vccd1 sky130_fd_sc_hd__diode_2
Xfanout278 cell3.CB_0.le_outB vssd1 vssd1 vccd1 vccd1 net278 sky130_fd_sc_hd__clkbuf_2
X_09806_ _04260_ _04792_ _04793_ _04197_ vssd1 vssd1 vccd1 vccd1 _04812_ sky130_fd_sc_hd__a22o_1
Xfanout289 cell3.CB_1.le_outB vssd1 vssd1 vccd1 vccd1 net289 sky130_fd_sc_hd__clkbuf_2
XFILLER_86_243 vssd1 vssd1 vccd1 vccd1 sky130_fd_sc_hd__fill_2
X_07998_ net530 _01986_ vssd1 vssd1 vccd1 vccd1 _03040_ sky130_fd_sc_hd__nand2_1
X_09737_ cell2.SB0.route_sel\[19\] _01587_ vssd1 vssd1 vccd1 vccd1 _04747_ sky130_fd_sc_hd__nand2_1
X_06949_ cell0.CB_1.config_dataB\[22\] cell0.CB_1.config_dataB\[23\] vssd1 vssd1 vccd1
+ vccd1 _02015_ sky130_fd_sc_hd__nand2b_1
Xclkbuf_leaf_66_clk clknet_4_15_0_clk vssd1 vssd1 vccd1 vccd1 clknet_leaf_66_clk sky130_fd_sc_hd__clkbuf_8
XANTENNA_fanout936_A net944 vssd1 vssd1 vccd1 vccd1 sky130_fd_sc_hd__diode_2
XFILLER_131_55 vssd1 vssd1 vccd1 vccd1 sky130_fd_sc_hd__fill_1
XTAP_TAPCELL_ROW_120_2112 vssd1 vccd1 sky130_fd_sc_hd__tapvpwrvgnd_1
XTAP_TAPCELL_ROW_120_2101 vssd1 vccd1 sky130_fd_sc_hd__tapvpwrvgnd_1
X_09668_ _04265_ _04654_ net54 vssd1 vssd1 vccd1 vccd1 _04683_ sky130_fd_sc_hd__o21bai_1
XANTENNA__09873__A2 bus3_2\[13\] vssd1 vssd1 vccd1 vccd1 sky130_fd_sc_hd__diode_2
XFILLER_91_15 vccd1 vssd1 vccd1 vssd1 sky130_ef_sc_hd__decap_40_12
XTAP_TAPCELL_ROW_38_883 vssd1 vccd1 sky130_fd_sc_hd__tapvpwrvgnd_1
XANTENNA__08457__X _03493_ vssd1 vssd1 vccd1 vccd1 sky130_fd_sc_hd__diode_2
XTAP_TAPCELL_ROW_38_872 vssd1 vccd1 sky130_fd_sc_hd__tapvpwrvgnd_1
XFILLER_15_505 vssd1 vssd1 vccd1 vccd1 sky130_fd_sc_hd__fill_2
XANTENNA_fanout724_X net724 vssd1 vssd1 vccd1 vccd1 sky130_fd_sc_hd__diode_2
X_09599_ cell3.SB0.route_sel\[91\] cell3.SB0.route_sel\[90\] vssd1 vssd1 vccd1 vccd1
+ _04616_ sky130_fd_sc_hd__nand2_1
XANTENNA__11680__A2 net548 vssd1 vssd1 vccd1 vccd1 sky130_fd_sc_hd__diode_2
XANTENNA__07884__A1 bus2_0\[7\] vssd1 vssd1 vccd1 vccd1 sky130_fd_sc_hd__diode_2
X_08619_ cell1.LE_1A.config_data\[9\] cell1.LE_1A.config_data\[8\] _03546_ vssd1 vssd1
+ vccd1 vccd1 _03655_ sky130_fd_sc_hd__mux2_1
X_11630_ net520 net521 net769 vssd1 vssd1 vccd1 vccd1 _00071_ sky130_fd_sc_hd__mux2_1
XFILLER_24_20 vssd1 vssd1 vccd1 vccd1 sky130_fd_sc_hd__fill_8
X_11561_ net1296 net1204 net801 vssd1 vssd1 vccd1 vccd1 _00002_ sky130_fd_sc_hd__mux2_1
XFILLER_24_53 vssd1 vssd1 vccd1 vccd1 sky130_fd_sc_hd__fill_4
X_13300_ clknet_leaf_98_clk _00272_ net680 vssd1 vssd1 vccd1 vccd1 cell1.CB_1.config_dataA\[16\]
+ sky130_fd_sc_hd__dfstp_1
X_10512_ net337 _02503_ _02504_ _05471_ vssd1 vssd1 vccd1 vccd1 net139 sky130_fd_sc_hd__a22o_1
XTAP_TAPCELL_ROW_118_2074 vssd1 vccd1 sky130_fd_sc_hd__tapvpwrvgnd_1
X_11492_ _04257_ _06328_ vssd1 vssd1 vccd1 vccd1 net238 sky130_fd_sc_hd__and2_1
X_14280_ clknet_leaf_21_clk _01252_ net610 vssd1 vssd1 vccd1 vccd1 cell2.SB0.route_sel\[65\]
+ sky130_fd_sc_hd__dfstp_1
XFILLER_7_748 vssd1 vssd1 vccd1 vccd1 sky130_fd_sc_hd__fill_4
XTAP_TAPCELL_ROW_118_2085 vssd1 vccd1 sky130_fd_sc_hd__tapvpwrvgnd_1
X_10443_ _01705_ cell3.SB0.route_sel\[42\] _01708_ cell3.SB0.route_sel\[45\] _05435_
+ vssd1 vssd1 vccd1 vccd1 _05436_ sky130_fd_sc_hd__a221o_1
X_13231_ clknet_leaf_2_clk _00203_ net569 vssd1 vssd1 vccd1 vccd1 cell0.LEI0.config_data\[16\]
+ sky130_fd_sc_hd__dfrtp_1
XFILLER_40_41 vccd1 vssd1 vccd1 vssd1 sky130_ef_sc_hd__decap_40_12
X_10374_ cell2.CB_0.config_dataB\[12\] _05372_ vssd1 vssd1 vccd1 vccd1 _05373_ sky130_fd_sc_hd__nand2_1
XFILLER_124_635 vssd1 vssd1 vccd1 vccd1 sky130_fd_sc_hd__fill_1
XFILLER_124_613 vssd1 vssd1 vccd1 vccd1 sky130_fd_sc_hd__fill_1
XFILLER_109_687 vssd1 vssd1 vccd1 vccd1 sky130_fd_sc_hd__fill_1
X_13162_ clknet_leaf_116_clk net1123 net667 vssd1 vssd1 vccd1 vccd1 cell0.LE_1A.config_data\[13\]
+ sky130_fd_sc_hd__dfrtp_1
XANTENNA_input65_A SBsouth_in[0] vssd1 vssd1 vccd1 vccd1 sky130_fd_sc_hd__diode_2
XTAP_TAPCELL_ROW_131_2274 vssd1 vccd1 sky130_fd_sc_hd__tapvpwrvgnd_1
XFILLER_123_123 vssd1 vssd1 vccd1 vccd1 sky130_fd_sc_hd__fill_1
X_12113_ net1552 cell1.LE_0A.edge_mode net879 vssd1 vssd1 vccd1 vccd1 _00547_ sky130_fd_sc_hd__mux2_1
XANTENNA__09464__A net47 vssd1 vssd1 vccd1 vccd1 sky130_fd_sc_hd__diode_2
XANTENNA__08779__S cell1.LE_1B.reset_val vssd1 vssd1 vccd1 vccd1 sky130_fd_sc_hd__diode_2
XANTENNA__09010__A0 bus3_1\[12\] vssd1 vssd1 vccd1 vccd1 sky130_fd_sc_hd__diode_2
X_13093_ clknet_leaf_9_clk _00065_ net570 vssd1 vssd1 vccd1 vccd1 cell0.CB_0.config_dataB\[20\]
+ sky130_fd_sc_hd__dfstp_2
XFILLER_2_475 vssd1 vssd1 vccd1 vccd1 sky130_fd_sc_hd__fill_1
XFILLER_78_755 vssd1 vssd1 vccd1 vccd1 sky130_fd_sc_hd__fill_1
X_12044_ net450 cell1.CB_1.config_dataB\[21\] net885 vssd1 vssd1 vccd1 vccd1 _00481_
+ sky130_fd_sc_hd__mux2_1
XANTENNA_input20_X net20 vssd1 vssd1 vccd1 vccd1 sky130_fd_sc_hd__diode_2
Xfanout790 net807 vssd1 vssd1 vccd1 vccd1 net790 sky130_fd_sc_hd__buf_2
XANTENNA_output221_A net221 vssd1 vssd1 vccd1 vccd1 sky130_fd_sc_hd__diode_2
Xclkbuf_leaf_57_clk clknet_4_13_0_clk vssd1 vssd1 vccd1 vccd1 clknet_leaf_57_clk sky130_fd_sc_hd__clkbuf_8
XANTENNA__09313__A1 net317 vssd1 vssd1 vccd1 vccd1 sky130_fd_sc_hd__diode_2
X_13995_ clknet_leaf_74_clk _00967_ net725 vssd1 vssd1 vccd1 vccd1 cell3.SB0.route_sel\[3\]
+ sky130_fd_sc_hd__dfstp_1
XFILLER_1_57 vccd1 vssd1 vccd1 vssd1 sky130_ef_sc_hd__decap_40_12
XFILLER_18_332 vssd1 vssd1 vccd1 vccd1 sky130_fd_sc_hd__fill_2
X_12946_ net1070 net1250 net950 vssd1 vssd1 vccd1 vccd1 _01374_ sky130_fd_sc_hd__mux2_1
XANTENNA__11120__A1 _05921_ vssd1 vssd1 vccd1 vccd1 sky130_fd_sc_hd__diode_2
XFILLER_80_419 vssd1 vssd1 vccd1 vccd1 sky130_fd_sc_hd__fill_1
XTAP_TAPCELL_ROW_47_1014 vssd1 vccd1 sky130_fd_sc_hd__tapvpwrvgnd_1
X_12877_ cell2.SB0.route_sel\[119\] cell2.SB0.route_sel\[118\] net818 vssd1 vssd1
+ vccd1 vccd1 _01306_ sky130_fd_sc_hd__mux2_1
XFILLER_18_387 vssd1 vssd1 vccd1 vccd1 sky130_fd_sc_hd__fill_4
XFILLER_33_324 vssd1 vssd1 vccd1 vccd1 sky130_fd_sc_hd__fill_1
XTAP_TAPCELL_ROW_16_544 vssd1 vccd1 sky130_fd_sc_hd__tapvpwrvgnd_1
XTAP_TAPCELL_ROW_16_555 vssd1 vccd1 sky130_fd_sc_hd__tapvpwrvgnd_1
X_11828_ cell1.CB_1.config_dataA\[9\] cell1.CB_1.config_dataA\[8\] net888 vssd1 vssd1
+ vccd1 vccd1 _00265_ sky130_fd_sc_hd__mux2_1
XTAP_TAPCELL_ROW_60_1214 vssd1 vccd1 sky130_fd_sc_hd__tapvpwrvgnd_1
XTAP_TAPCELL_ROW_60_1203 vssd1 vccd1 sky130_fd_sc_hd__tapvpwrvgnd_1
XANTENNA__10631__A0 net8 vssd1 vssd1 vccd1 vccd1 sky130_fd_sc_hd__diode_2
X_11759_ cell0.LEI0.config_data\[9\] cell0.LEI0.config_data\[8\] net799 vssd1 vssd1
+ vccd1 vccd1 _00196_ sky130_fd_sc_hd__mux2_1
X_14478_ clknet_leaf_60_clk _01450_ net737 vssd1 vssd1 vccd1 vccd1 cell3.LEI0.config_data\[43\]
+ sky130_fd_sc_hd__dfrtp_1
Xclkload103 clknet_leaf_47_clk vssd1 vssd1 vccd1 vccd1 clkload103/Y sky130_fd_sc_hd__clkinv_2
Xclkload114 clknet_leaf_57_clk vssd1 vssd1 vccd1 vccd1 clkload114/Y sky130_fd_sc_hd__clkinv_4
Xclkload136 clknet_1_1__leaf_cell3.LE_1B.sel_clk vssd1 vssd1 vccd1 vccd1 clkload136/X
+ sky130_fd_sc_hd__clkbuf_4
Xclkload125 clknet_leaf_60_clk vssd1 vssd1 vccd1 vccd1 clkload125/Y sky130_fd_sc_hd__clkinv_4
X_13429_ clknet_leaf_131_clk _00401_ net560 vssd1 vssd1 vccd1 vccd1 cell0.SB0.route_sel\[70\]
+ sky130_fd_sc_hd__dfstp_1
XFILLER_115_624 vssd1 vssd1 vccd1 vccd1 sky130_fd_sc_hd__fill_1
Xclkload147 clknet_1_1__leaf_cell0.LE_1A.sel_clk vssd1 vssd1 vccd1 vccd1 clkload147/X
+ sky130_fd_sc_hd__clkbuf_4
XANTENNA__07159__A _01821_ vssd1 vssd1 vccd1 vccd1 sky130_fd_sc_hd__diode_2
XTAP_TAPCELL_ROW_58_1176 vssd1 vccd1 sky130_fd_sc_hd__tapvpwrvgnd_1
XFILLER_102_307 vssd1 vssd1 vccd1 vccd1 sky130_fd_sc_hd__fill_1
X_08970_ cell1.LEI0.config_data\[36\] net324 vssd1 vssd1 vccd1 vccd1 _04002_ sky130_fd_sc_hd__nand2_1
X_07921_ net515 _02585_ vssd1 vssd1 vccd1 vccd1 _02965_ sky130_fd_sc_hd__nand2_1
XTAP_TAPCELL_ROW_71_1376 vssd1 vccd1 sky130_fd_sc_hd__tapvpwrvgnd_1
X_07852_ cell0.SB0.route_sel\[27\] cell0.SB0.route_sel\[26\] _01598_ cell0.SB0.route_sel\[30\]
+ _02895_ vssd1 vssd1 vccd1 vccd1 _02896_ sky130_fd_sc_hd__o221ai_4
Xinput1 CBeast_in[0] vssd1 vssd1 vccd1 vccd1 net1 sky130_fd_sc_hd__clkbuf_4
XANTENNA__07563__B1 bus1_0\[0\] vssd1 vssd1 vccd1 vccd1 sky130_fd_sc_hd__diode_2
X_06803_ cell0.SB0.route_sel\[48\] cell0.SB0.route_sel\[49\] _01872_ vssd1 vssd1 vccd1
+ vccd1 _01873_ sky130_fd_sc_hd__a21oi_1
Xclkbuf_leaf_48_clk clknet_4_12_0_clk vssd1 vssd1 vccd1 vccd1 clknet_leaf_48_clk sky130_fd_sc_hd__clkbuf_8
XANTENNA__09304__A1 net303 vssd1 vssd1 vccd1 vccd1 sky130_fd_sc_hd__diode_2
XFILLER_83_246 vssd1 vssd1 vccd1 vccd1 sky130_fd_sc_hd__fill_1
X_09522_ _04530_ _04531_ _04533_ _04541_ vssd1 vssd1 vccd1 vccd1 _04542_ sky130_fd_sc_hd__a31o_1
XANTENNA__08107__A2 net350 vssd1 vssd1 vccd1 vccd1 sky130_fd_sc_hd__diode_2
X_07783_ cell0.SB0.route_sel\[43\] cell0.SB0.route_sel\[42\] vssd1 vssd1 vccd1 vccd1
+ _02828_ sky130_fd_sc_hd__nand2_1
XANTENNA__09821__B net303 vssd1 vssd1 vccd1 vccd1 sky130_fd_sc_hd__diode_2
X_06734_ cell3.LEI0.config_data\[2\] vssd1 vssd1 vccd1 vccd1 _01804_ sky130_fd_sc_hd__inv_2
X_09453_ _01908_ _04473_ _04474_ vssd1 vssd1 vccd1 vccd1 _04475_ sky130_fd_sc_hd__o21ai_1
X_06665_ cell3.SB0.route_sel\[93\] vssd1 vssd1 vccd1 vccd1 _01735_ sky130_fd_sc_hd__inv_2
XANTENNA__07866__A1 bus2_0\[4\] vssd1 vssd1 vccd1 vccd1 sky130_fd_sc_hd__diode_2
XANTENNA__07866__B2 bus2_0\[5\] vssd1 vssd1 vccd1 vccd1 sky130_fd_sc_hd__diode_2
XTAP_TAPCELL_ROW_35_831 vssd1 vccd1 sky130_fd_sc_hd__tapvpwrvgnd_1
X_09384_ net13 net288 _04405_ vssd1 vssd1 vccd1 vccd1 _04408_ sky130_fd_sc_hd__mux2_1
X_08404_ net500 _01956_ vssd1 vssd1 vccd1 vccd1 _03442_ sky130_fd_sc_hd__nand2_1
X_06596_ cell1.CB_1.config_dataA\[17\] vssd1 vssd1 vccd1 vccd1 _01666_ sky130_fd_sc_hd__inv_2
X_08335_ net509 _02277_ vssd1 vssd1 vccd1 vccd1 _03373_ sky130_fd_sc_hd__nand2_1
XANTENNA__10217__A3 _05139_ vssd1 vssd1 vccd1 vccd1 sky130_fd_sc_hd__diode_2
X_08266_ _03305_ _03304_ _03231_ vssd1 vssd1 vccd1 vccd1 _03306_ sky130_fd_sc_hd__mux2_1
XANTENNA_fanout305_X net305 vssd1 vssd1 vccd1 vccd1 sky130_fd_sc_hd__diode_2
X_08197_ _03235_ _03236_ cell0.CB_1.config_dataA\[12\] vssd1 vssd1 vccd1 vccd1 _03237_
+ sky130_fd_sc_hd__o21ai_1
XFILLER_20_596 vssd1 vssd1 vccd1 vccd1 sky130_fd_sc_hd__fill_1
X_07217_ _02274_ _02276_ vssd1 vssd1 vccd1 vccd1 _02277_ sky130_fd_sc_hd__nor2_4
XANTENNA__08043__A1 net347 vssd1 vssd1 vccd1 vccd1 sky130_fd_sc_hd__diode_2
XFILLER_3_217 vssd1 vssd1 vccd1 vccd1 sky130_fd_sc_hd__fill_4
X_07148_ cell0.SB0.route_sel\[85\] cell0.SB0.route_sel\[84\] _01472_ cell0.SB0.route_sel\[87\]
+ _02209_ vssd1 vssd1 vccd1 vccd1 _02210_ sky130_fd_sc_hd__o221ai_4
XFILLER_105_134 vssd1 vssd1 vccd1 vccd1 sky130_fd_sc_hd__fill_1
XFILLER_105_123 vssd1 vssd1 vccd1 vccd1 sky130_fd_sc_hd__fill_1
XPHY_EDGE_ROW_5_Left_148 vssd1 vssd1 vccd1 vccd1 sky130_fd_sc_hd__decap_3
XFILLER_10_77 vssd1 vssd1 vccd1 vccd1 sky130_fd_sc_hd__fill_4
X_07079_ cell1.CB_1.config_dataB\[24\] cell1.CB_1.config_dataB\[21\] cell1.CB_1.config_dataB\[20\]
+ vssd1 vssd1 vccd1 vccd1 _02143_ sky130_fd_sc_hd__or3b_2
XFILLER_121_638 vssd1 vssd1 vccd1 vccd1 sky130_fd_sc_hd__fill_1
X_10090_ cell2.SB0.route_sel\[79\] _01627_ _01628_ cell2.SB0.route_sel\[76\] _05090_
+ vssd1 vssd1 vccd1 vccd1 _05091_ sky130_fd_sc_hd__a221o_1
XANTENNA_fanout674_X net674 vssd1 vssd1 vccd1 vccd1 sky130_fd_sc_hd__diode_2
XFILLER_101_340 vssd1 vssd1 vccd1 vccd1 sky130_fd_sc_hd__fill_1
XTAP_TAPCELL_ROW_89_1648 vssd1 vccd1 sky130_fd_sc_hd__tapvpwrvgnd_1
XTAP_TAPCELL_ROW_89_1637 vssd1 vccd1 sky130_fd_sc_hd__tapvpwrvgnd_1
XFILLER_142_76 vssd1 vssd1 vccd1 vccd1 sky130_fd_sc_hd__fill_4
XFILLER_142_65 vssd1 vssd1 vccd1 vccd1 sky130_fd_sc_hd__fill_2
Xclkbuf_leaf_39_clk clknet_4_7_0_clk vssd1 vssd1 vccd1 vccd1 clknet_leaf_39_clk sky130_fd_sc_hd__clkbuf_8
X_12800_ cell2.SB0.route_sel\[42\] cell2.SB0.route_sel\[41\] net819 vssd1 vssd1 vccd1
+ vccd1 _01229_ sky130_fd_sc_hd__mux2_1
X_10992_ _05898_ _05935_ vssd1 vssd1 vccd1 vccd1 _05946_ sky130_fd_sc_hd__and2_1
X_13780_ clknet_leaf_109_clk _00752_ net651 vssd1 vssd1 vccd1 vccd1 cell1.SB0.route_sel\[57\]
+ sky130_fd_sc_hd__dfstp_2
X_12731_ net380 net381 net933 vssd1 vssd1 vccd1 vccd1 _01160_ sky130_fd_sc_hd__mux2_1
XANTENNA__06940__A_N _02006_ vssd1 vssd1 vccd1 vccd1 sky130_fd_sc_hd__diode_2
XFILLER_15_324 vssd1 vssd1 vccd1 vccd1 sky130_fd_sc_hd__fill_8
X_12662_ net262 cell3.SB0.route_sel\[126\] net913 vssd1 vssd1 vccd1 vccd1 _01091_
+ sky130_fd_sc_hd__mux2_1
XANTENNA__10861__A0 net8 vssd1 vssd1 vccd1 vccd1 sky130_fd_sc_hd__diode_2
XFILLER_43_677 vssd1 vssd1 vccd1 vccd1 sky130_fd_sc_hd__fill_1
XFILLER_15_346 vssd1 vssd1 vccd1 vccd1 sky130_fd_sc_hd__fill_1
X_14401_ clknet_leaf_61_clk net977 net738 vssd1 vssd1 vccd1 vccd1 cell3.LE_0B.config_data\[10\]
+ sky130_fd_sc_hd__dfrtp_1
XTAP_TAPCELL_ROW_100_1815 vssd1 vccd1 sky130_fd_sc_hd__tapvpwrvgnd_1
XTAP_TAPCELL_ROW_100_1804 vssd1 vccd1 sky130_fd_sc_hd__tapvpwrvgnd_1
X_11613_ cell0.CB_0.config_dataB\[9\] cell0.CB_0.config_dataB\[8\] net773 vssd1 vssd1
+ vccd1 vccd1 _00054_ sky130_fd_sc_hd__mux2_1
XTAP_TAPCELL_ROW_13_503 vssd1 vccd1 sky130_fd_sc_hd__tapvpwrvgnd_1
XANTENNA__10208__A3 net39 vssd1 vssd1 vccd1 vccd1 sky130_fd_sc_hd__diode_2
X_12593_ cell3.SB0.route_sel\[58\] cell3.SB0.route_sel\[57\] net912 vssd1 vssd1 vccd1
+ vccd1 _01022_ sky130_fd_sc_hd__mux2_1
X_14332_ clknet_leaf_26_clk _01304_ net613 vssd1 vssd1 vccd1 vccd1 cell2.SB0.route_sel\[117\]
+ sky130_fd_sc_hd__dfstp_1
X_11544_ cell0.SB0.route_sel\[9\] cell0.SB0.route_sel\[8\] vssd1 vssd1 vccd1 vccd1
+ _06363_ sky130_fd_sc_hd__nor2_1
XANTENNA__08282__A1 bus1_0\[13\] vssd1 vssd1 vccd1 vccd1 sky130_fd_sc_hd__diode_2
XTAP_TAPCELL_ROW_133_2303 vssd1 vccd1 sky130_fd_sc_hd__tapvpwrvgnd_1
X_14263_ clknet_leaf_26_clk _01235_ net607 vssd1 vssd1 vccd1 vccd1 cell2.SB0.route_sel\[48\]
+ sky130_fd_sc_hd__dfstp_1
XFILLER_7_567 vssd1 vssd1 vccd1 vccd1 sky130_fd_sc_hd__fill_1
X_11475_ cell1.SB0.route_sel\[103\] cell1.SB0.route_sel\[102\] vssd1 vssd1 vccd1 vccd1
+ _06317_ sky130_fd_sc_hd__nor2_1
XFILLER_137_771 vccd1 vssd1 vccd1 vssd1 sky130_ef_sc_hd__decap_40_12
X_10426_ _05417_ _05424_ _05413_ vssd1 vssd1 vccd1 vccd1 _05425_ sky130_fd_sc_hd__mux2_1
XANTENNA__08034__A1 _02902_ vssd1 vssd1 vccd1 vccd1 sky130_fd_sc_hd__diode_2
X_13214_ clknet_1_0__leaf_cell0.LE_0A.sel_clk _00186_ net751 vssd1 vssd1 vccd1 vccd1
+ cell0.LE_0A.dff0_out sky130_fd_sc_hd__dfrtp_1
XANTENNA_output171_A net171 vssd1 vssd1 vccd1 vccd1 sky130_fd_sc_hd__diode_2
X_14194_ clknet_leaf_53_clk _01166_ net715 vssd1 vssd1 vccd1 vccd1 cell3.CB_0.config_dataA\[4\]
+ sky130_fd_sc_hd__dfstp_1
XFILLER_109_495 vssd1 vssd1 vccd1 vccd1 sky130_fd_sc_hd__fill_1
XANTENNA__08034__B2 _02905_ vssd1 vssd1 vccd1 vccd1 sky130_fd_sc_hd__diode_2
XANTENNA_input68_X net68 vssd1 vssd1 vccd1 vccd1 sky130_fd_sc_hd__diode_2
X_10357_ cell2.CB_0.config_dataB\[13\] cell2.CB_0.config_dataB\[12\] vssd1 vssd1 vccd1
+ vccd1 _05356_ sky130_fd_sc_hd__nor2_1
XANTENNA__10392__A2 _05096_ vssd1 vssd1 vccd1 vccd1 sky130_fd_sc_hd__diode_2
X_13145_ clknet_leaf_128_clk _00117_ net579 vssd1 vssd1 vccd1 vccd1 cell0.CB_1.config_dataB\[22\]
+ sky130_fd_sc_hd__dfstp_2
X_10288_ _05156_ _05280_ _05282_ _05152_ cell2.CB_0.config_dataB\[7\] vssd1 vssd1
+ vccd1 vccd1 _05287_ sky130_fd_sc_hd__a221o_1
X_13076_ clknet_leaf_8_clk _00048_ net572 vssd1 vssd1 vccd1 vccd1 cell0.CB_0.config_dataB\[3\]
+ sky130_fd_sc_hd__dfstp_1
XTAP_TAPCELL_ROW_111_1977 vssd1 vccd1 sky130_fd_sc_hd__tapvpwrvgnd_1
XTAP_TAPCELL_ROW_111_1966 vssd1 vccd1 sky130_fd_sc_hd__tapvpwrvgnd_1
XFILLER_66_703 vssd1 vssd1 vccd1 vccd1 sky130_fd_sc_hd__fill_1
X_12027_ net459 cell1.CB_1.config_dataB\[4\] net901 vssd1 vssd1 vccd1 vccd1 _00464_
+ sky130_fd_sc_hd__mux2_1
XANTENNA__08337__A2 _02039_ vssd1 vssd1 vccd1 vccd1 sky130_fd_sc_hd__diode_2
XANTENNA__07545__B1 _02595_ vssd1 vssd1 vccd1 vccd1 sky130_fd_sc_hd__diode_2
XANTENNA__13169__SET_B net751 vssd1 vssd1 vccd1 vccd1 sky130_fd_sc_hd__diode_2
XANTENNA__11516__X net247 vssd1 vssd1 vccd1 vccd1 sky130_fd_sc_hd__diode_2
X_13978_ clknet_leaf_42_clk net1530 net633 vssd1 vssd1 vccd1 vccd1 cell2.LEI0.config_data\[35\]
+ sky130_fd_sc_hd__dfrtp_1
X_12929_ cell3.LE_1A.edge_mode cell3.LE_1A.config_data\[16\] net953 vssd1 vssd1 vccd1
+ vccd1 _01358_ sky130_fd_sc_hd__mux2_1
XFILLER_80_238 vssd1 vssd1 vccd1 vccd1 sky130_fd_sc_hd__fill_1
X_06450_ cell1.SB0.route_sel\[54\] vssd1 vssd1 vccd1 vccd1 _01520_ sky130_fd_sc_hd__inv_2
XFILLER_61_485 vssd1 vssd1 vccd1 vccd1 sky130_fd_sc_hd__fill_1
XANTENNA__08825__X _03857_ vssd1 vssd1 vccd1 vccd1 sky130_fd_sc_hd__diode_2
XFILLER_33_165 vssd1 vssd1 vccd1 vccd1 sky130_fd_sc_hd__fill_1
X_08120_ _03158_ _03161_ _03120_ vssd1 vssd1 vccd1 vccd1 _03162_ sky130_fd_sc_hd__mux2_1
XANTENNA__07076__A2 _02137_ vssd1 vssd1 vccd1 vccd1 sky130_fd_sc_hd__diode_2
X_08051_ _02074_ _03091_ _03092_ _02172_ cell0.CB_0.config_dataB\[12\] vssd1 vssd1
+ vccd1 vccd1 _03093_ sky130_fd_sc_hd__a221o_1
XANTENNA__09656__X _04671_ vssd1 vssd1 vccd1 vccd1 sky130_fd_sc_hd__diode_2
XANTENNA__08025__A1 bus2_0\[9\] vssd1 vssd1 vccd1 vccd1 sky130_fd_sc_hd__diode_2
X_07002_ cell1.SB0.route_sel\[64\] cell1.SB0.route_sel\[65\] _02067_ vssd1 vssd1 vccd1
+ vccd1 _02068_ sky130_fd_sc_hd__a21oi_1
XTAP_TAPCELL_ROW_73_1405 vssd1 vccd1 sky130_fd_sc_hd__tapvpwrvgnd_1
XFILLER_142_251 vssd1 vssd1 vccd1 vccd1 sky130_fd_sc_hd__fill_1
X_08953_ _03980_ _03981_ _03984_ _03978_ vssd1 vssd1 vccd1 vccd1 _03985_ sky130_fd_sc_hd__o22a_1
XANTENNA__10474__A_N net272 vssd1 vssd1 vccd1 vccd1 sky130_fd_sc_hd__diode_2
X_07904_ cell0.LE_0A.config_data\[5\] cell0.LE_0A.config_data\[4\] _02947_ vssd1 vssd1
+ vccd1 vccd1 _02948_ sky130_fd_sc_hd__mux2_1
XANTENNA__08328__A2 _02560_ vssd1 vssd1 vccd1 vccd1 sky130_fd_sc_hd__diode_2
X_08884_ _03914_ _03915_ vssd1 vssd1 vccd1 vccd1 _03916_ sky130_fd_sc_hd__or2_1
X_07835_ _02873_ _02874_ _02876_ _02878_ vssd1 vssd1 vccd1 vccd1 _02879_ sky130_fd_sc_hd__o22a_1
XFILLER_29_438 vssd1 vssd1 vccd1 vccd1 sky130_fd_sc_hd__fill_1
XFILLER_29_449 vssd1 vssd1 vccd1 vccd1 sky130_fd_sc_hd__fill_2
XFILLER_72_739 vssd1 vssd1 vccd1 vccd1 sky130_fd_sc_hd__fill_1
XANTENNA__11426__X net234 vssd1 vssd1 vccd1 vccd1 sky130_fd_sc_hd__diode_2
X_07766_ net77 _02809_ vssd1 vssd1 vccd1 vccd1 _02812_ sky130_fd_sc_hd__nand2_1
XFILLER_112_57 vssd1 vssd1 vccd1 vccd1 sky130_fd_sc_hd__fill_2
X_06717_ cell3.CB_1.config_dataA\[7\] vssd1 vssd1 vccd1 vccd1 _01787_ sky130_fd_sc_hd__inv_2
XANTENNA__09828__A2 _04696_ vssd1 vssd1 vccd1 vccd1 sky130_fd_sc_hd__diode_2
X_09505_ _01621_ cell2.SB0.route_sel\[71\] cell2.SB0.route_sel\[69\] cell2.SB0.route_sel\[68\]
+ _04524_ vssd1 vssd1 vccd1 vccd1 _04525_ sky130_fd_sc_hd__o221a_1
XANTENNA_fanout634_A net635 vssd1 vssd1 vccd1 vccd1 sky130_fd_sc_hd__diode_2
X_09436_ _04267_ _04414_ vssd1 vssd1 vccd1 vccd1 _04459_ sky130_fd_sc_hd__nor2_1
XTAP_TAPCELL_ROW_84_1567 vssd1 vccd1 sky130_fd_sc_hd__tapvpwrvgnd_1
X_07697_ cell0.SB0.route_sel\[25\] cell0.SB0.route_sel\[24\] vssd1 vssd1 vccd1 vccd1
+ _02744_ sky130_fd_sc_hd__and2_1
X_06648_ cell3.SB0.route_sel\[67\] vssd1 vssd1 vccd1 vccd1 _01718_ sky130_fd_sc_hd__inv_2
X_09367_ net59 _04390_ vssd1 vssd1 vccd1 vccd1 _04391_ sky130_fd_sc_hd__or2_1
X_06579_ cell2.SB0.route_sel\[117\] vssd1 vssd1 vccd1 vccd1 _01649_ sky130_fd_sc_hd__inv_2
XFILLER_138_535 vssd1 vssd1 vccd1 vccd1 sky130_fd_sc_hd__fill_1
X_09298_ _04323_ _04321_ vssd1 vssd1 vccd1 vccd1 bus3_1\[2\] sky130_fd_sc_hd__and2b_2
XANTENNA_50 net141 vssd1 vssd1 vccd1 vccd1 sky130_fd_sc_hd__diode_2
X_08318_ bus1_0\[6\] bus1_0\[7\] net509 vssd1 vssd1 vccd1 vccd1 _03356_ sky130_fd_sc_hd__mux2_1
XANTENNA__08803__A3 bus3_1\[11\] vssd1 vssd1 vccd1 vccd1 sky130_fd_sc_hd__diode_2
X_08249_ bus1_0\[0\] bus1_0\[1\] bus1_0\[2\] bus1_0\[3\] net536 net535 vssd1 vssd1
+ vccd1 vccd1 _03289_ sky130_fd_sc_hd__mux4_1
XTAP_TAPCELL_ROW_115_2033 vssd1 vccd1 sky130_fd_sc_hd__tapvpwrvgnd_1
X_11260_ net309 _04392_ _04393_ _06197_ vssd1 vssd1 vccd1 vccd1 net192 sky130_fd_sc_hd__a22o_1
XFILLER_134_774 vssd1 vssd1 vccd1 vccd1 sky130_fd_sc_hd__fill_4
X_11191_ net47 net383 vssd1 vssd1 vccd1 vccd1 _06143_ sky130_fd_sc_hd__or2_1
XFILLER_106_443 vssd1 vssd1 vccd1 vccd1 sky130_fd_sc_hd__fill_2
X_10211_ net415 _05148_ vssd1 vssd1 vccd1 vccd1 _05212_ sky130_fd_sc_hd__or2_1
XFILLER_97_47 vssd1 vssd1 vccd1 vccd1 sky130_fd_sc_hd__fill_1
XANTENNA__08567__A2 _03493_ vssd1 vssd1 vccd1 vccd1 sky130_fd_sc_hd__diode_2
XFILLER_97_69 vssd1 vssd1 vccd1 vccd1 sky130_fd_sc_hd__fill_4
X_10142_ cell2.SB0.route_sel\[31\] _01595_ _01596_ cell2.SB0.route_sel\[28\] _05142_
+ vssd1 vssd1 vccd1 vccd1 _05143_ sky130_fd_sc_hd__a221o_1
Xoutput190 net190 vssd1 vssd1 vccd1 vccd1 CBnorth_out[31] sky130_fd_sc_hd__buf_2
X_10073_ _05073_ _05076_ _05030_ vssd1 vssd1 vccd1 vccd1 _05077_ sky130_fd_sc_hd__mux2_1
XANTENNA__07246__B cell2.SB0.route_sel\[92\] vssd1 vssd1 vccd1 vccd1 sky130_fd_sc_hd__diode_2
XFILLER_102_682 vssd1 vssd1 vccd1 vccd1 sky130_fd_sc_hd__fill_1
X_13901_ clknet_leaf_36_clk _00873_ net639 vssd1 vssd1 vccd1 vccd1 cell2.LE_0B.config_data\[2\]
+ sky130_fd_sc_hd__dfrtp_1
XANTENNA_input28_A CBeast_in[5] vssd1 vssd1 vccd1 vccd1 sky130_fd_sc_hd__diode_2
XANTENNA__11336__X net178 vssd1 vssd1 vccd1 vccd1 sky130_fd_sc_hd__diode_2
XFILLER_90_503 vssd1 vssd1 vccd1 vccd1 sky130_fd_sc_hd__fill_1
X_13832_ clknet_leaf_120_clk _00804_ net596 vssd1 vssd1 vccd1 vccd1 cell1.SB0.route_sel\[109\]
+ sky130_fd_sc_hd__dfstp_1
XANTENNA_input122_X net122 vssd1 vssd1 vccd1 vccd1 sky130_fd_sc_hd__diode_2
XTAP_TAPCELL_ROW_126_2195 vssd1 vccd1 sky130_fd_sc_hd__tapvpwrvgnd_1
XFILLER_62_216 vssd1 vssd1 vccd1 vccd1 sky130_fd_sc_hd__fill_1
X_13763_ clknet_leaf_111_clk _00735_ net654 vssd1 vssd1 vccd1 vccd1 cell1.SB0.route_sel\[40\]
+ sky130_fd_sc_hd__dfstp_1
X_12714_ net386 net387 net931 vssd1 vssd1 vccd1 vccd1 _01143_ sky130_fd_sc_hd__mux2_1
X_10975_ cell3.CB_0.config_dataA\[4\] _05862_ _05904_ _05928_ _01804_ vssd1 vssd1
+ vccd1 vccd1 _05929_ sky130_fd_sc_hd__a32o_1
X_13694_ clknet_leaf_32_clk _00666_ net621 vssd1 vssd1 vccd1 vccd1 cell2.CB_0.config_dataB\[21\]
+ sky130_fd_sc_hd__dfstp_1
XFILLER_94_9 vccd1 vssd1 vccd1 vssd1 sky130_ef_sc_hd__decap_40_12
XFILLER_43_463 vssd1 vssd1 vccd1 vccd1 sky130_fd_sc_hd__fill_1
X_12645_ cell3.SB0.route_sel\[110\] cell3.SB0.route_sel\[109\] net921 vssd1 vssd1
+ vccd1 vccd1 _01074_ sky130_fd_sc_hd__mux2_1
XTAP_TAPCELL_ROW_26_694 vssd1 vccd1 sky130_fd_sc_hd__tapvpwrvgnd_1
X_12576_ cell3.SB0.route_sel\[41\] cell3.SB0.route_sel\[40\] net914 vssd1 vssd1 vccd1
+ vccd1 _01005_ sky130_fd_sc_hd__mux2_1
XANTENNA__09452__B1 net314 vssd1 vssd1 vccd1 vccd1 sky130_fd_sc_hd__diode_2
XFILLER_62_94 vssd1 vssd1 vccd1 vccd1 sky130_fd_sc_hd__fill_1
X_14315_ clknet_leaf_18_clk _01287_ net615 vssd1 vssd1 vccd1 vccd1 cell2.SB0.route_sel\[100\]
+ sky130_fd_sc_hd__dfstp_1
X_11527_ cell2.SB0.route_sel\[104\] cell2.SB0.route_sel\[105\] cell2.SB0.route_sel\[107\]
+ _01642_ _06351_ vssd1 vssd1 vccd1 vccd1 _06352_ sky130_fd_sc_hd__o221a_1
Xwire273 _04550_ vssd1 vssd1 vccd1 vccd1 net273 sky130_fd_sc_hd__clkbuf_2
XANTENNA_max_cap265_A _02716_ vssd1 vssd1 vccd1 vccd1 sky130_fd_sc_hd__diode_2
X_14246_ clknet_leaf_19_clk _01218_ net614 vssd1 vssd1 vccd1 vccd1 cell2.SB0.route_sel\[31\]
+ sky130_fd_sc_hd__dfstp_1
Xhold309 cell0.LE_0B.config_data\[13\] vssd1 vssd1 vccd1 vccd1 net1268 sky130_fd_sc_hd__dlygate4sd3_1
XANTENNA__08007__A1 bus2_0\[4\] vssd1 vssd1 vccd1 vccd1 sky130_fd_sc_hd__diode_2
XANTENNA__08007__B2 bus2_0\[5\] vssd1 vssd1 vccd1 vccd1 sky130_fd_sc_hd__diode_2
X_11458_ cell1.SB0.route_sel\[50\] _01518_ cell1.SB0.route_sel\[54\] cell1.SB0.route_sel\[55\]
+ _06305_ vssd1 vssd1 vccd1 vccd1 _06306_ sky130_fd_sc_hd__o221a_1
X_14177_ clknet_leaf_56_clk _01149_ net722 vssd1 vssd1 vccd1 vccd1 cell3.CB_0.config_dataB\[12\]
+ sky130_fd_sc_hd__dfstp_2
X_10409_ net33 net44 net55 net58 net424 net423 vssd1 vssd1 vccd1 vccd1 _05408_ sky130_fd_sc_hd__mux4_1
XANTENNA__09755__A1 _04527_ vssd1 vssd1 vccd1 vccd1 sky130_fd_sc_hd__diode_2
XANTENNA__08558__A2 net23 vssd1 vssd1 vccd1 vccd1 sky130_fd_sc_hd__diode_2
X_11389_ cell0.SB0.route_sel\[56\] cell0.SB0.route_sel\[57\] _01462_ cell0.SB0.route_sel\[60\]
+ _06259_ vssd1 vssd1 vccd1 vccd1 _06260_ sky130_fd_sc_hd__o221a_1
XANTENNA__10365__A2 _05103_ vssd1 vssd1 vccd1 vccd1 sky130_fd_sc_hd__diode_2
XANTENNA__09668__B1_N net54 vssd1 vssd1 vccd1 vccd1 sky130_fd_sc_hd__diode_2
XTAP_TAPCELL_ROW_55_1135 vssd1 vccd1 sky130_fd_sc_hd__tapvpwrvgnd_1
X_13128_ clknet_leaf_124_clk _00100_ net583 vssd1 vssd1 vccd1 vccd1 cell0.CB_1.config_dataB\[5\]
+ sky130_fd_sc_hd__dfstp_1
XFILLER_140_755 vssd1 vssd1 vccd1 vccd1 sky130_fd_sc_hd__fill_1
XFILLER_97_157 vssd1 vssd1 vccd1 vccd1 sky130_fd_sc_hd__fill_1
XANTENNA__10117__A2 net38 vssd1 vssd1 vccd1 vccd1 sky130_fd_sc_hd__diode_2
XFILLER_100_619 vssd1 vssd1 vccd1 vccd1 sky130_fd_sc_hd__fill_4
X_13059_ clknet_leaf_126_clk _00031_ net584 vssd1 vssd1 vccd1 vccd1 cell0.CB_1.config_dataA\[11\]
+ sky130_fd_sc_hd__dfstp_1
XFILLER_23_3 vccd1 vssd1 vccd1 vssd1 sky130_ef_sc_hd__decap_40_12
XFILLER_78_393 vssd1 vssd1 vccd1 vccd1 sky130_fd_sc_hd__fill_1
XFILLER_66_533 vssd1 vssd1 vccd1 vccd1 sky130_fd_sc_hd__fill_1
X_07620_ cell0.CB_0.le_outA _02121_ _02620_ vssd1 vssd1 vccd1 vccd1 _02669_ sky130_fd_sc_hd__nor3_1
X_07551_ _02598_ _02600_ _02601_ vssd1 vssd1 vccd1 vccd1 _02602_ sky130_fd_sc_hd__a21o_1
XANTENNA__10825__A0 net21 vssd1 vssd1 vccd1 vccd1 sky130_fd_sc_hd__diode_2
X_06502_ cell0.CB_0.config_dataA\[13\] vssd1 vssd1 vccd1 vccd1 _01572_ sky130_fd_sc_hd__inv_2
X_07482_ _02534_ net309 _02533_ vssd1 vssd1 vccd1 vccd1 _02535_ sky130_fd_sc_hd__mux2_1
XTAP_TAPCELL_ROW_66_1297 vssd1 vccd1 sky130_fd_sc_hd__tapvpwrvgnd_1
XFILLER_61_271 vssd1 vssd1 vccd1 vccd1 sky130_fd_sc_hd__fill_1
XTAP_TAPCELL_ROW_45_981 vssd1 vccd1 sky130_fd_sc_hd__tapvpwrvgnd_1
X_09221_ _02164_ _04176_ bus3_2\[1\] vssd1 vssd1 vccd1 vccd1 _04248_ sky130_fd_sc_hd__o21ai_1
X_06433_ cell1.SB0.route_sel\[10\] vssd1 vssd1 vccd1 vccd1 _01503_ sky130_fd_sc_hd__inv_2
X_09152_ net317 _04179_ _04174_ vssd1 vssd1 vccd1 vccd1 _04180_ sky130_fd_sc_hd__mux2_1
XANTENNA__10053__B2 _04260_ vssd1 vssd1 vccd1 vccd1 sky130_fd_sc_hd__diode_2
XANTENNA__10053__A1 _04197_ vssd1 vssd1 vccd1 vccd1 sky130_fd_sc_hd__diode_2
XPHY_EDGE_ROW_86_Left_229 vssd1 vssd1 vccd1 vccd1 sky130_fd_sc_hd__decap_3
X_08103_ _02074_ _03125_ _03126_ _02172_ cell0.CB_0.config_dataB\[17\] vssd1 vssd1
+ vccd1 vccd1 _03145_ sky130_fd_sc_hd__a221o_1
X_09083_ net479 _03885_ _04112_ net478 vssd1 vssd1 vccd1 vccd1 _04113_ sky130_fd_sc_hd__o211a_1
X_08034_ _02902_ _03060_ _03061_ _02905_ cell0.CB_0.config_dataB\[2\] vssd1 vssd1
+ vccd1 vccd1 _03076_ sky130_fd_sc_hd__a221o_1
Xinput70 SBsouth_in[14] vssd1 vssd1 vccd1 vccd1 net70 sky130_fd_sc_hd__buf_2
Xinput81 SBsouth_in[24] vssd1 vssd1 vccd1 vccd1 net81 sky130_fd_sc_hd__buf_1
Xinput92 SBsouth_in[5] vssd1 vssd1 vccd1 vccd1 net92 sky130_fd_sc_hd__clkbuf_2
XANTENNA_clkbuf_leaf_51_clk_A clknet_4_13_0_clk vssd1 vssd1 vccd1 vccd1 sky130_fd_sc_hd__diode_2
XFILLER_1_529 vccd1 vssd1 vccd1 vssd1 sky130_ef_sc_hd__decap_40_12
XANTENNA__07221__A2 _02278_ vssd1 vssd1 vccd1 vccd1 sky130_fd_sc_hd__diode_2
X_09985_ cell2.LEI0.config_data\[21\] net316 _04988_ cell2.LEI0.config_data\[22\]
+ vssd1 vssd1 vccd1 vccd1 _04989_ sky130_fd_sc_hd__o211a_1
XANTENNA_fanout584_A net602 vssd1 vssd1 vccd1 vccd1 sky130_fd_sc_hd__diode_2
XPHY_EDGE_ROW_95_Left_238 vssd1 vssd1 vccd1 vccd1 sky130_fd_sc_hd__decap_3
X_08936_ _01682_ _03953_ _03965_ _03967_ vssd1 vssd1 vccd1 vccd1 _03968_ sky130_fd_sc_hd__a31o_1
X_08867_ cell1.CB_0.config_dataA\[8\] cell1.CB_0.config_dataA\[7\] cell1.CB_0.config_dataA\[9\]
+ _03827_ vssd1 vssd1 vccd1 vccd1 _03899_ sky130_fd_sc_hd__or4bb_1
XANTENNA_fanout751_A net754 vssd1 vssd1 vccd1 vccd1 sky130_fd_sc_hd__diode_2
XTAP_TAPCELL_ROW_4_367 vssd1 vccd1 sky130_fd_sc_hd__tapvpwrvgnd_1
XANTENNA_fanout849_A net854 vssd1 vssd1 vccd1 vccd1 sky130_fd_sc_hd__diode_2
XFILLER_123_67 vssd1 vssd1 vccd1 vccd1 sky130_fd_sc_hd__fill_1
XANTENNA_clkbuf_leaf_66_clk_A clknet_4_15_0_clk vssd1 vssd1 vccd1 vccd1 sky130_fd_sc_hd__diode_2
X_07818_ net325 _01890_ _02153_ _02859_ vssd1 vssd1 vccd1 vccd1 _02863_ sky130_fd_sc_hd__o31a_1
XANTENNA__08721__A2 net2 vssd1 vssd1 vccd1 vccd1 sky130_fd_sc_hd__diode_2
XFILLER_17_419 vssd1 vssd1 vccd1 vccd1 sky130_fd_sc_hd__fill_1
XFILLER_83_27 vssd1 vssd1 vccd1 vccd1 sky130_fd_sc_hd__fill_8
XFILLER_16_10 vccd1 vssd1 vccd1 vssd1 sky130_ef_sc_hd__decap_40_12
X_08798_ _02373_ _03829_ vssd1 vssd1 vccd1 vccd1 _03830_ sky130_fd_sc_hd__nand2_4
XFILLER_25_430 vccd1 vssd1 vccd1 vssd1 sky130_ef_sc_hd__decap_40_12
X_07749_ cell0.SB0.route_sel\[36\] cell0.SB0.route_sel\[37\] vssd1 vssd1 vccd1 vccd1
+ _02795_ sky130_fd_sc_hd__nand2_1
X_10760_ _05513_ _05692_ _01777_ vssd1 vssd1 vccd1 vccd1 _05716_ sky130_fd_sc_hd__o21ai_1
XFILLER_53_783 vssd1 vssd1 vccd1 vccd1 sky130_fd_sc_hd__fill_1
XFILLER_13_614 vssd1 vssd1 vccd1 vccd1 sky130_fd_sc_hd__fill_2
XFILLER_16_65 vssd1 vssd1 vccd1 vccd1 sky130_fd_sc_hd__fill_8
XANTENNA__08485__A1 net12 vssd1 vssd1 vccd1 vccd1 sky130_fd_sc_hd__diode_2
XANTENNA__10292__A1 net59 vssd1 vssd1 vccd1 vccd1 sky130_fd_sc_hd__diode_2
XANTENNA__10292__B2 net60 vssd1 vssd1 vccd1 vccd1 sky130_fd_sc_hd__diode_2
X_09419_ _04428_ _04436_ _04441_ vssd1 vssd1 vccd1 vccd1 _04442_ sky130_fd_sc_hd__a21oi_2
X_10691_ net21 net22 net24 net25 cell3.CB_1.config_dataA\[15\] net390 vssd1 vssd1
+ vccd1 vccd1 _05649_ sky130_fd_sc_hd__mux4_1
XFILLER_139_833 vssd1 vssd1 vccd1 vccd1 sky130_fd_sc_hd__fill_4
X_12430_ net1284 net1251 net848 vssd1 vssd1 vccd1 vccd1 _00862_ sky130_fd_sc_hd__mux2_1
XANTENNA_clkbuf_leaf_124_clk_A clknet_4_2_0_clk vssd1 vssd1 vccd1 vccd1 sky130_fd_sc_hd__diode_2
XTAP_TAPCELL_ROW_23_653 vssd1 vccd1 sky130_fd_sc_hd__tapvpwrvgnd_1
XANTENNA__10044__A1 bus3_2\[7\] vssd1 vssd1 vccd1 vccd1 sky130_fd_sc_hd__diode_2
XANTENNA__08117__S _03087_ vssd1 vssd1 vccd1 vccd1 sky130_fd_sc_hd__diode_2
XFILLER_8_139 vssd1 vssd1 vccd1 vccd1 sky130_fd_sc_hd__fill_1
XFILLER_32_53 vssd1 vssd1 vccd1 vccd1 sky130_fd_sc_hd__fill_8
X_14100_ clknet_leaf_50_clk _01072_ net712 vssd1 vssd1 vccd1 vccd1 cell3.SB0.route_sel\[108\]
+ sky130_fd_sc_hd__dfstp_1
XTAP_TAPCELL_ROW_97_1758 vssd1 vccd1 sky130_fd_sc_hd__tapvpwrvgnd_1
XFILLER_5_824 vssd1 vssd1 vccd1 vccd1 sky130_fd_sc_hd__fill_1
X_12361_ cell1.SB0.route_sel\[99\] cell1.SB0.route_sel\[98\] net887 vssd1 vssd1 vccd1
+ vccd1 _00794_ sky130_fd_sc_hd__mux2_1
XTAP_TAPCELL_ROW_97_1769 vssd1 vccd1 sky130_fd_sc_hd__tapvpwrvgnd_1
X_11312_ _05553_ net287 _04566_ vssd1 vssd1 vccd1 vccd1 _06221_ sky130_fd_sc_hd__mux2_1
X_12292_ cell1.SB0.route_sel\[30\] cell1.SB0.route_sel\[29\] net857 vssd1 vssd1 vccd1
+ vccd1 _00725_ sky130_fd_sc_hd__mux2_1
XFILLER_4_301 vssd1 vssd1 vccd1 vccd1 sky130_fd_sc_hd__fill_4
X_14031_ clknet_leaf_47_clk _01003_ net701 vssd1 vssd1 vccd1 vccd1 cell3.SB0.route_sel\[39\]
+ sky130_fd_sc_hd__dfstp_1
X_11243_ clknet_leaf_91_clk cell1.LE_1B.edge_mode vssd1 vssd1 vccd1 vccd1 cell1.LE_1B.sel_clk
+ sky130_fd_sc_hd__xnor2_2
XANTENNA__10347__A2 _05131_ vssd1 vssd1 vccd1 vccd1 sky130_fd_sc_hd__diode_2
XANTENNA_clkbuf_leaf_19_clk_A clknet_4_4_0_clk vssd1 vssd1 vccd1 vccd1 sky130_fd_sc_hd__diode_2
XFILLER_79_113 vssd1 vssd1 vccd1 vccd1 sky130_fd_sc_hd__fill_4
X_11174_ net47 net48 cell3.CB_0.config_dataB\[10\] vssd1 vssd1 vccd1 vccd1 _06126_
+ sky130_fd_sc_hd__mux2_1
XTAP_TAPCELL_ROW_128_2235 vssd1 vccd1 sky130_fd_sc_hd__tapvpwrvgnd_1
XTAP_TAPCELL_ROW_128_2224 vssd1 vccd1 sky130_fd_sc_hd__tapvpwrvgnd_1
XFILLER_95_639 vssd1 vssd1 vccd1 vccd1 sky130_fd_sc_hd__fill_1
X_10125_ cell2.SB0.route_sel\[59\] cell2.SB0.route_sel\[58\] vssd1 vssd1 vccd1 vccd1
+ _05126_ sky130_fd_sc_hd__nor2_1
XANTENNA__08960__A2 bus3_1\[10\] vssd1 vssd1 vccd1 vccd1 sky130_fd_sc_hd__diode_2
X_10056_ _01751_ _05055_ _05056_ _05057_ _05053_ vssd1 vssd1 vccd1 vccd1 _05060_ sky130_fd_sc_hd__o32a_1
XANTENNA__07544__X _02595_ vssd1 vssd1 vccd1 vccd1 sky130_fd_sc_hd__diode_2
XTAP_TAPCELL_ROW_50_1054 vssd1 vccd1 sky130_fd_sc_hd__tapvpwrvgnd_1
XFILLER_48_533 vssd1 vssd1 vccd1 vccd1 sky130_fd_sc_hd__fill_1
XFILLER_63_503 vssd1 vssd1 vccd1 vccd1 sky130_fd_sc_hd__fill_1
XTAP_TAPCELL_ROW_50_1065 vssd1 vccd1 sky130_fd_sc_hd__tapvpwrvgnd_1
XTAP_TAPCELL_ROW_141_2424 vssd1 vccd1 sky130_fd_sc_hd__tapvpwrvgnd_1
XFILLER_75_396 vssd1 vssd1 vccd1 vccd1 sky130_fd_sc_hd__fill_2
X_13815_ clknet_leaf_112_clk _00787_ net661 vssd1 vssd1 vccd1 vccd1 cell1.SB0.route_sel\[92\]
+ sky130_fd_sc_hd__dfstp_1
XTAP_TAPCELL_ROW_106_1898 vssd1 vccd1 sky130_fd_sc_hd__tapvpwrvgnd_1
X_10958_ _04303_ _04312_ _04320_ _05911_ vssd1 vssd1 vccd1 vccd1 _05912_ sky130_fd_sc_hd__a211o_4
X_13746_ clknet_leaf_107_clk _00718_ net658 vssd1 vssd1 vccd1 vccd1 cell1.SB0.route_sel\[23\]
+ sky130_fd_sc_hd__dfstp_1
X_13677_ clknet_leaf_30_clk _00649_ net620 vssd1 vssd1 vccd1 vccd1 cell2.CB_0.config_dataB\[4\]
+ sky130_fd_sc_hd__dfstp_1
XTAP_TAPCELL_ROW_42_940 vssd1 vccd1 sky130_fd_sc_hd__tapvpwrvgnd_1
X_10889_ _01783_ cell3.LE_1B.dff_out vssd1 vssd1 vccd1 vccd1 _05844_ sky130_fd_sc_hd__or2_1
X_12628_ cell3.SB0.route_sel\[93\] cell3.SB0.route_sel\[92\] net883 vssd1 vssd1 vccd1
+ vccd1 _01057_ sky130_fd_sc_hd__mux2_1
XANTENNA__08535__B _03468_ vssd1 vssd1 vccd1 vccd1 sky130_fd_sc_hd__diode_2
XTAP_TAPCELL_ROW_139_2397 vssd1 vccd1 sky130_fd_sc_hd__tapvpwrvgnd_1
XTAP_TAPCELL_ROW_139_2386 vssd1 vccd1 sky130_fd_sc_hd__tapvpwrvgnd_1
XANTENNA__10035__B2 _04555_ vssd1 vssd1 vccd1 vccd1 sky130_fd_sc_hd__diode_2
X_12559_ cell3.SB0.route_sel\[24\] cell3.SB0.route_sel\[23\] net917 vssd1 vssd1 vccd1
+ vccd1 _00988_ sky130_fd_sc_hd__mux2_1
XANTENNA_max_cap268_X net268 vssd1 vssd1 vccd1 vccd1 sky130_fd_sc_hd__diode_2
Xhold117 cell2.LE_0A.config_data\[10\] vssd1 vssd1 vccd1 vccd1 net1076 sky130_fd_sc_hd__dlygate4sd3_1
Xhold106 cell0.LE_0A.config_data\[11\] vssd1 vssd1 vccd1 vccd1 net1065 sky130_fd_sc_hd__dlygate4sd3_1
Xhold128 cell2.LE_0A.config_data\[2\] vssd1 vssd1 vccd1 vccd1 net1087 sky130_fd_sc_hd__dlygate4sd3_1
X_14229_ clknet_leaf_16_clk _01201_ net624 vssd1 vssd1 vccd1 vccd1 cell2.SB0.route_sel\[14\]
+ sky130_fd_sc_hd__dfstp_1
Xhold139 _00519_ vssd1 vssd1 vccd1 vccd1 net1098 sky130_fd_sc_hd__dlygate4sd3_1
XPHY_EDGE_ROW_9_Right_9 vssd1 vssd1 vccd1 vccd1 sky130_fd_sc_hd__decap_3
XFILLER_98_400 vssd1 vssd1 vccd1 vccd1 sky130_fd_sc_hd__fill_1
Xfanout619 net622 vssd1 vssd1 vccd1 vccd1 net619 sky130_fd_sc_hd__clkbuf_4
Xfanout608 net609 vssd1 vssd1 vccd1 vccd1 net608 sky130_fd_sc_hd__buf_2
XANTENNA__14061__Q cell3.SB0.route_sel\[69\] vssd1 vssd1 vccd1 vccd1 sky130_fd_sc_hd__diode_2
XPHY_EDGE_ROW_107_Right_107 vssd1 vssd1 vccd1 vccd1 sky130_fd_sc_hd__decap_3
X_09770_ net443 _04774_ _04775_ vssd1 vssd1 vccd1 vccd1 _04776_ sky130_fd_sc_hd__a21oi_1
XFILLER_85_105 vssd1 vssd1 vccd1 vccd1 sky130_fd_sc_hd__fill_4
X_06982_ _02046_ _02047_ vssd1 vssd1 vccd1 vccd1 _02048_ sky130_fd_sc_hd__nor2_1
X_08721_ net31 net32 net2 net3 net456 cell1.CB_1.config_dataB\[11\] vssd1 vssd1 vccd1
+ vccd1 _03755_ sky130_fd_sc_hd__mux4_1
XANTENNA__09900__A1 net305 vssd1 vssd1 vccd1 vccd1 sky130_fd_sc_hd__diode_2
X_08652_ net458 _03465_ _03685_ net457 vssd1 vssd1 vccd1 vccd1 _03686_ sky130_fd_sc_hd__o211a_1
XFILLER_94_683 vssd1 vssd1 vccd1 vccd1 sky130_fd_sc_hd__fill_1
XTAP_TAPCELL_ROW_68_1326 vssd1 vccd1 sky130_fd_sc_hd__tapvpwrvgnd_1
X_07603_ _02651_ _02652_ _02648_ vssd1 vssd1 vccd1 vccd1 _02653_ sky130_fd_sc_hd__a21oi_1
XTAP_TAPCELL_ROW_1_326 vssd1 vccd1 sky130_fd_sc_hd__tapvpwrvgnd_1
XANTENNA__09259__A3 _02893_ vssd1 vssd1 vccd1 vccd1 sky130_fd_sc_hd__diode_2
X_08583_ _03618_ vssd1 vssd1 vccd1 vccd1 _03619_ sky130_fd_sc_hd__inv_2
XTAP_TAPCELL_ROW_81_1526 vssd1 vccd1 sky130_fd_sc_hd__tapvpwrvgnd_1
X_07534_ _02557_ _02584_ vssd1 vssd1 vccd1 vccd1 _02585_ sky130_fd_sc_hd__or2_4
X_07465_ _01900_ _02376_ vssd1 vssd1 vccd1 vccd1 _02518_ sky130_fd_sc_hd__nor2_2
XANTENNA__09416__A0 net60 vssd1 vssd1 vccd1 vccd1 sky130_fd_sc_hd__diode_2
X_09204_ _04208_ _04230_ vssd1 vssd1 vccd1 vccd1 _04231_ sky130_fd_sc_hd__nor2_1
XANTENNA_fanout332_A cell1.CB_0.le_outA vssd1 vssd1 vccd1 vccd1 sky130_fd_sc_hd__diode_2
XFILLER_22_466 vssd1 vssd1 vccd1 vccd1 sky130_fd_sc_hd__fill_1
X_06416_ cell0.SB0.route_sel\[115\] vssd1 vssd1 vccd1 vccd1 _01486_ sky130_fd_sc_hd__inv_2
X_07396_ net314 _02447_ _02449_ _02450_ vssd1 vssd1 vccd1 vccd1 _02451_ sky130_fd_sc_hd__a22oi_2
XTAP_TAPCELL_ROW_20_601 vssd1 vccd1 sky130_fd_sc_hd__tapvpwrvgnd_1
XTAP_TAPCELL_ROW_20_612 vssd1 vccd1 sky130_fd_sc_hd__tapvpwrvgnd_1
XFILLER_136_825 vssd1 vssd1 vccd1 vccd1 sky130_fd_sc_hd__fill_4
XANTENNA__09967__B2 _04260_ vssd1 vssd1 vccd1 vccd1 sky130_fd_sc_hd__diode_2
XANTENNA__09967__A1 _04197_ vssd1 vssd1 vccd1 vccd1 sky130_fd_sc_hd__diode_2
X_09135_ cell1.LE_0B.config_data\[15\] cell1.LE_0B.config_data\[14\] _04086_ vssd1
+ vssd1 vccd1 vccd1 _04165_ sky130_fd_sc_hd__mux2_1
XFILLER_5_109 vssd1 vssd1 vccd1 vccd1 sky130_fd_sc_hd__fill_2
XANTENNA__10577__A2 net24 vssd1 vssd1 vccd1 vccd1 sky130_fd_sc_hd__diode_2
X_09066_ _04095_ vssd1 vssd1 vccd1 vccd1 _04096_ sky130_fd_sc_hd__inv_2
XTAP_TAPCELL_ROW_79_1499 vssd1 vccd1 sky130_fd_sc_hd__tapvpwrvgnd_1
XTAP_TAPCELL_ROW_79_1488 vssd1 vccd1 sky130_fd_sc_hd__tapvpwrvgnd_1
X_08017_ net533 _02235_ _03058_ net532 vssd1 vssd1 vccd1 vccd1 _03059_ sky130_fd_sc_hd__o211a_1
XANTENNA_fanout799_A net806 vssd1 vssd1 vccd1 vccd1 sky130_fd_sc_hd__diode_2
XFILLER_2_805 vssd1 vssd1 vccd1 vccd1 sky130_fd_sc_hd__fill_4
XANTENNA__10329__A2 _05103_ vssd1 vssd1 vccd1 vccd1 sky130_fd_sc_hd__diode_2
XTAP_TAPCELL_ROW_9_448 vssd1 vccd1 sky130_fd_sc_hd__tapvpwrvgnd_1
XTAP_TAPCELL_ROW_9_437 vssd1 vccd1 sky130_fd_sc_hd__tapvpwrvgnd_1
XTAP_TAPCELL_ROW_92_1688 vssd1 vccd1 sky130_fd_sc_hd__tapvpwrvgnd_1
XFILLER_1_337 vccd1 vssd1 vccd1 vssd1 sky130_ef_sc_hd__decap_40_12
X_09968_ _04962_ _04965_ _04971_ _04961_ vssd1 vssd1 vccd1 vccd1 _04972_ sky130_fd_sc_hd__o22a_1
XFILLER_134_77 vssd1 vssd1 vccd1 vccd1 sky130_fd_sc_hd__fill_4
X_08919_ net467 _03858_ _03950_ net466 vssd1 vssd1 vccd1 vccd1 _03951_ sky130_fd_sc_hd__o211a_1
XANTENNA__06953__A1 net358 vssd1 vssd1 vccd1 vccd1 sky130_fd_sc_hd__diode_2
X_09899_ cell2.LEI0.config_data\[42\] net315 _04904_ cell2.LEI0.config_data\[43\]
+ vssd1 vssd1 vccd1 vccd1 _04905_ sky130_fd_sc_hd__o211a_1
XANTENNA__09352__C1 _02815_ vssd1 vssd1 vccd1 vccd1 sky130_fd_sc_hd__diode_2
XFILLER_45_503 vssd1 vssd1 vccd1 vccd1 sky130_fd_sc_hd__fill_1
XANTENNA_fanout754_X net754 vssd1 vssd1 vccd1 vccd1 sky130_fd_sc_hd__diode_2
X_11930_ cell0.SB0.route_sel\[36\] cell0.SB0.route_sel\[35\] net758 vssd1 vssd1 vccd1
+ vccd1 _00367_ sky130_fd_sc_hd__mux2_1
XANTENNA__07902__B1 _02945_ vssd1 vssd1 vccd1 vccd1 sky130_fd_sc_hd__diode_2
XTAP_TAPCELL_ROW_28_723 vssd1 vccd1 sky130_fd_sc_hd__tapvpwrvgnd_1
XTAP_TAPCELL_ROW_123_2154 vssd1 vccd1 sky130_fd_sc_hd__tapvpwrvgnd_1
X_11861_ cell1.CB_0.config_dataB\[17\] net475 net892 vssd1 vssd1 vccd1 vccd1 _00298_
+ sky130_fd_sc_hd__mux2_1
XTAP_TAPCELL_ROW_28_734 vssd1 vccd1 sky130_fd_sc_hd__tapvpwrvgnd_1
X_10812_ net14 _05761_ _05762_ net13 cell3.CB_1.config_dataB\[13\] vssd1 vssd1 vccd1
+ vccd1 _05768_ sky130_fd_sc_hd__a221o_1
X_13600_ clknet_leaf_89_clk _00572_ net696 vssd1 vssd1 vccd1 vccd1 cell1.LEI0.config_data\[21\]
+ sky130_fd_sc_hd__dfrtp_1
X_11792_ cell0.LEI0.config_data\[42\] net1405 net776 vssd1 vssd1 vccd1 vccd1 _00229_
+ sky130_fd_sc_hd__mux2_1
XANTENNA__10265__A1 cell2.LE_0A.config_data\[0\] vssd1 vssd1 vccd1 vccd1 sky130_fd_sc_hd__diode_2
X_10743_ _05540_ _05543_ net371 vssd1 vssd1 vccd1 vccd1 _05699_ sky130_fd_sc_hd__mux2_1
XANTENNA__07395__B1_N _02447_ vssd1 vssd1 vccd1 vccd1 sky130_fd_sc_hd__diode_2
X_13531_ clknet_leaf_89_clk _00503_ net696 vssd1 vssd1 vccd1 vccd1 cell1.LE_1A.reset_val
+ sky130_fd_sc_hd__dfrtp_1
XANTENNA__14159__SET_B net733 vssd1 vssd1 vccd1 vccd1 sky130_fd_sc_hd__diode_2
X_10674_ _05631_ vssd1 vssd1 vccd1 vccd1 _05632_ sky130_fd_sc_hd__inv_2
XANTENNA__10017__A1 _04399_ vssd1 vssd1 vccd1 vccd1 sky130_fd_sc_hd__diode_2
XANTENNA_input95_A SBsouth_in[8] vssd1 vssd1 vccd1 vccd1 sky130_fd_sc_hd__diode_2
X_13462_ clknet_leaf_2_clk _00434_ net563 vssd1 vssd1 vccd1 vccd1 cell0.SB0.route_sel\[103\]
+ sky130_fd_sc_hd__dfstp_1
X_12413_ cell2.CB_1.config_dataB\[23\] cell2.CB_1.config_dataB\[22\] net830 vssd1
+ vssd1 vccd1 vccd1 _00846_ sky130_fd_sc_hd__mux2_1
X_13393_ clknet_leaf_1_clk _00365_ net553 vssd1 vssd1 vccd1 vccd1 cell0.SB0.route_sel\[34\]
+ sky130_fd_sc_hd__dfstp_1
XANTENNA__11765__A1 cell0.LEI0.config_data\[14\] vssd1 vssd1 vccd1 vccd1 sky130_fd_sc_hd__diode_2
X_12344_ cell1.SB0.route_sel\[82\] cell1.SB0.route_sel\[81\] net862 vssd1 vssd1 vccd1
+ vccd1 _00777_ sky130_fd_sc_hd__mux2_1
XFILLER_142_806 vssd1 vssd1 vccd1 vccd1 sky130_fd_sc_hd__fill_4
XFILLER_99_208 vssd1 vssd1 vccd1 vccd1 sky130_fd_sc_hd__fill_1
XFILLER_5_665 vssd1 vssd1 vccd1 vccd1 sky130_fd_sc_hd__fill_4
XANTENNA_input50_X net50 vssd1 vssd1 vccd1 vccd1 sky130_fd_sc_hd__diode_2
X_14014_ clknet_leaf_79_clk _00986_ net707 vssd1 vssd1 vccd1 vccd1 cell3.SB0.route_sel\[22\]
+ sky130_fd_sc_hd__dfstp_1
X_12275_ cell1.SB0.route_sel\[13\] cell1.SB0.route_sel\[12\] net864 vssd1 vssd1 vccd1
+ vccd1 _00708_ sky130_fd_sc_hd__mux2_1
XFILLER_4_153 vccd1 vssd1 vccd1 vssd1 sky130_ef_sc_hd__decap_40_12
X_11226_ _06176_ _06177_ _06107_ vssd1 vssd1 vccd1 vccd1 _06178_ sky130_fd_sc_hd__mux2_1
XANTENNA_output251_A net251 vssd1 vssd1 vccd1 vccd1 sky130_fd_sc_hd__diode_2
XFILLER_4_197 vssd1 vssd1 vccd1 vccd1 sky130_fd_sc_hd__fill_4
X_11157_ net385 net384 vssd1 vssd1 vccd1 vccd1 _06109_ sky130_fd_sc_hd__or2_1
XFILLER_110_725 vssd1 vssd1 vccd1 vccd1 sky130_fd_sc_hd__fill_1
XFILLER_95_447 vssd1 vssd1 vccd1 vccd1 sky130_fd_sc_hd__fill_1
XANTENNA__10740__A2 net24 vssd1 vssd1 vccd1 vccd1 sky130_fd_sc_hd__diode_2
X_10108_ cell2.SB0.route_sel\[109\] cell2.SB0.route_sel\[108\] vssd1 vssd1 vccd1 vccd1
+ _05109_ sky130_fd_sc_hd__nand2b_1
X_11088_ _06041_ _06040_ _06033_ _06026_ vssd1 vssd1 vccd1 vccd1 _06042_ sky130_fd_sc_hd__a2bb2o_1
XTAP_TAPCELL_ROW_108_1927 vssd1 vccd1 sky130_fd_sc_hd__tapvpwrvgnd_1
X_10039_ _04641_ _05034_ _05042_ vssd1 vssd1 vccd1 vccd1 _05043_ sky130_fd_sc_hd__o21ba_1
XFILLER_76_694 vssd1 vssd1 vccd1 vccd1 sky130_fd_sc_hd__fill_2
XFILLER_48_363 vssd1 vssd1 vccd1 vccd1 sky130_fd_sc_hd__fill_1
XFILLER_91_642 vssd1 vssd1 vccd1 vccd1 sky130_fd_sc_hd__fill_2
XANTENNA__11524__X _06350_ vssd1 vssd1 vccd1 vccd1 sky130_fd_sc_hd__diode_2
XANTENNA__08817__Y _03849_ vssd1 vssd1 vccd1 vccd1 sky130_fd_sc_hd__diode_2
XFILLER_16_260 vssd1 vssd1 vccd1 vccd1 sky130_fd_sc_hd__fill_1
XTAP_TAPCELL_ROW_63_1256 vssd1 vccd1 sky130_fd_sc_hd__tapvpwrvgnd_1
X_13729_ clknet_leaf_106_clk _00701_ net660 vssd1 vssd1 vccd1 vccd1 cell1.SB0.route_sel\[6\]
+ sky130_fd_sc_hd__dfstp_1
X_07250_ cell2.SB0.route_sel\[88\] cell2.SB0.route_sel\[89\] vssd1 vssd1 vccd1 vccd1
+ _02309_ sky130_fd_sc_hd__nand2_1
XANTENNA__07672__A2 net353 vssd1 vssd1 vccd1 vccd1 sky130_fd_sc_hd__diode_2
X_07181_ _01900_ _02088_ vssd1 vssd1 vccd1 vccd1 _02242_ sky130_fd_sc_hd__nor2_1
XFILLER_117_335 vssd1 vssd1 vccd1 vccd1 sky130_fd_sc_hd__fill_1
XFILLER_117_357 vssd1 vssd1 vccd1 vccd1 sky130_fd_sc_hd__fill_1
Xfanout405 cell2.CB_1.config_dataB\[6\] vssd1 vssd1 vccd1 vccd1 net405 sky130_fd_sc_hd__buf_2
XFILLER_99_764 vssd1 vssd1 vccd1 vccd1 sky130_fd_sc_hd__fill_1
Xfanout427 cell2.CB_0.config_dataB\[11\] vssd1 vssd1 vccd1 vccd1 net427 sky130_fd_sc_hd__buf_1
X_09822_ cell2.LEI0.config_data\[6\] net315 _04827_ cell2.LEI0.config_data\[7\] vssd1
+ vssd1 vccd1 vccd1 _04828_ sky130_fd_sc_hd__o211a_1
Xfanout416 cell2.CB_0.config_dataA\[10\] vssd1 vssd1 vccd1 vccd1 net416 sky130_fd_sc_hd__clkbuf_2
Xfanout438 net439 vssd1 vssd1 vccd1 vccd1 net438 sky130_fd_sc_hd__buf_2
X_09753_ net445 net443 vssd1 vssd1 vccd1 vccd1 _04759_ sky130_fd_sc_hd__or2_1
XFILLER_98_296 vssd1 vssd1 vccd1 vccd1 sky130_fd_sc_hd__fill_1
Xfanout449 cell1.CB_1.config_dataB\[23\] vssd1 vssd1 vccd1 vccd1 net449 sky130_fd_sc_hd__buf_2
X_06965_ cell0.CB_0.config_dataB\[24\] cell0.CB_0.config_dataB\[20\] cell0.CB_0.config_dataB\[21\]
+ vssd1 vssd1 vccd1 vccd1 _02031_ sky130_fd_sc_hd__or3_2
X_08704_ net454 _01658_ vssd1 vssd1 vccd1 vccd1 _03738_ sky130_fd_sc_hd__nor2_1
X_09684_ cell3.SB0.route_sel\[118\] cell3.SB0.route_sel\[119\] net316 _02518_ _04692_
+ vssd1 vssd1 vccd1 vccd1 _04698_ sky130_fd_sc_hd__a221oi_1
XANTENNA__09885__A0 bus3_2\[0\] vssd1 vssd1 vccd1 vccd1 sky130_fd_sc_hd__diode_2
XFILLER_73_119 vssd1 vssd1 vccd1 vccd1 sky130_fd_sc_hd__fill_2
X_06896_ cell1.CB_1.config_dataA\[24\] cell1.CB_1.config_dataA\[21\] cell1.CB_1.config_dataA\[20\]
+ vssd1 vssd1 vccd1 vccd1 _01964_ sky130_fd_sc_hd__nand3b_2
XFILLER_27_503 vssd1 vssd1 vccd1 vccd1 sky130_fd_sc_hd__fill_1
XFILLER_27_558 vssd1 vssd1 vccd1 vccd1 sky130_fd_sc_hd__fill_2
X_08635_ net458 _03533_ _03668_ net457 vssd1 vssd1 vccd1 vccd1 _03669_ sky130_fd_sc_hd__o211a_1
XFILLER_82_686 vssd1 vssd1 vccd1 vccd1 sky130_fd_sc_hd__fill_8
X_08566_ net491 _03486_ _03601_ net490 vssd1 vssd1 vccd1 vccd1 _03602_ sky130_fd_sc_hd__o211ai_1
XANTENNA__10247__A1 net44 vssd1 vssd1 vccd1 vccd1 sky130_fd_sc_hd__diode_2
X_07517_ net7 net322 _02567_ vssd1 vssd1 vccd1 vccd1 _02569_ sky130_fd_sc_hd__mux2_1
XANTENNA__09101__A2 bus3_1\[2\] vssd1 vssd1 vccd1 vccd1 sky130_fd_sc_hd__diode_2
XFILLER_80_17 vssd1 vssd1 vccd1 vccd1 sky130_fd_sc_hd__fill_2
XFILLER_50_561 vssd1 vssd1 vccd1 vccd1 sky130_fd_sc_hd__fill_1
XANTENNA_fanout335_X net335 vssd1 vssd1 vccd1 vccd1 sky130_fd_sc_hd__diode_2
X_08497_ _01897_ _03532_ vssd1 vssd1 vccd1 vccd1 _03533_ sky130_fd_sc_hd__or2_4
X_07448_ net6 _02501_ vssd1 vssd1 vccd1 vccd1 _02502_ sky130_fd_sc_hd__or2_1
XFILLER_10_469 vssd1 vssd1 vccd1 vccd1 sky130_fd_sc_hd__fill_4
XFILLER_13_55 vssd1 vssd1 vccd1 vccd1 sky130_fd_sc_hd__fill_1
X_07379_ _02434_ net335 _02433_ vssd1 vssd1 vccd1 vccd1 _02435_ sky130_fd_sc_hd__mux2_1
XFILLER_129_55 vssd1 vssd1 vccd1 vccd1 sky130_fd_sc_hd__fill_1
X_09118_ _03830_ _04128_ _04146_ _04147_ vssd1 vssd1 vccd1 vccd1 _04148_ sky130_fd_sc_hd__a211o_1
XFILLER_6_418 vssd1 vssd1 vccd1 vccd1 sky130_fd_sc_hd__fill_2
XFILLER_13_77 vssd1 vssd1 vccd1 vccd1 sky130_fd_sc_hd__fill_2
XANTENNA__08462__Y _03498_ vssd1 vssd1 vccd1 vccd1 sky130_fd_sc_hd__diode_2
X_10390_ net425 _05084_ vssd1 vssd1 vccd1 vccd1 _05389_ sky130_fd_sc_hd__nand2_1
XANTENNA__11211__A3 net57 vssd1 vssd1 vccd1 vccd1 sky130_fd_sc_hd__diode_2
XTAP_TAPCELL_ROW_94_1717 vssd1 vccd1 sky130_fd_sc_hd__tapvpwrvgnd_1
XFILLER_136_699 vssd1 vssd1 vccd1 vccd1 sky130_fd_sc_hd__fill_1
XFILLER_123_327 vssd1 vssd1 vccd1 vccd1 sky130_fd_sc_hd__fill_1
X_09049_ _04062_ _04066_ _04078_ cell1.CB_0.config_dataB\[4\] vssd1 vssd1 vccd1 vccd1
+ _04079_ sky130_fd_sc_hd__a211o_1
XANTENNA__07966__A3 cell0.CB_1.le_outB vssd1 vssd1 vccd1 vccd1 sky130_fd_sc_hd__diode_2
XANTENNA__07519__B _02570_ vssd1 vssd1 vccd1 vccd1 sky130_fd_sc_hd__diode_2
XFILLER_2_613 vccd1 vssd1 vccd1 vssd1 sky130_ef_sc_hd__decap_40_12
Xhold481 _00931_ vssd1 vssd1 vccd1 vccd1 net1440 sky130_fd_sc_hd__dlygate4sd3_1
Xhold470 _00919_ vssd1 vssd1 vccd1 vccd1 net1429 sky130_fd_sc_hd__dlygate4sd3_1
X_12060_ net1051 cell1.LE_1A.config_data\[10\] net888 vssd1 vssd1 vccd1 vccd1 _00496_
+ sky130_fd_sc_hd__mux2_1
XFILLER_2_657 vccd1 vssd1 vccd1 vssd1 sky130_ef_sc_hd__decap_40_12
X_11011_ net374 net375 vssd1 vssd1 vccd1 vccd1 _05965_ sky130_fd_sc_hd__and2b_1
Xhold492 _00212_ vssd1 vssd1 vccd1 vccd1 net1451 sky130_fd_sc_hd__dlygate4sd3_1
XFILLER_1_167 vssd1 vssd1 vccd1 vccd1 sky130_fd_sc_hd__fill_1
Xfanout950 net952 vssd1 vssd1 vccd1 vccd1 net950 sky130_fd_sc_hd__buf_2
XFILLER_131_393 vssd1 vssd1 vccd1 vccd1 sky130_fd_sc_hd__fill_2
XFILLER_77_458 vssd1 vssd1 vccd1 vccd1 sky130_fd_sc_hd__fill_4
XFILLER_38_41 vccd1 vssd1 vccd1 vssd1 sky130_ef_sc_hd__decap_40_12
X_12962_ net986 net1134 net927 vssd1 vssd1 vccd1 vccd1 _01390_ sky130_fd_sc_hd__mux2_1
XFILLER_92_428 vssd1 vssd1 vccd1 vccd1 sky130_fd_sc_hd__fill_1
XANTENNA__08679__A1 net5 vssd1 vssd1 vccd1 vccd1 sky130_fd_sc_hd__diode_2
XANTENNA_input10_A CBeast_in[18] vssd1 vssd1 vccd1 vccd1 sky130_fd_sc_hd__diode_2
XANTENNA__10896__A net272 vssd1 vssd1 vccd1 vccd1 sky130_fd_sc_hd__diode_2
X_12893_ cell3.CB_1.config_dataB\[7\] cell3.CB_1.config_dataB\[6\] net947 vssd1 vssd1
+ vccd1 vccd1 _01322_ sky130_fd_sc_hd__mux2_1
X_11913_ cell0.SB0.route_sel\[19\] cell0.SB0.route_sel\[18\] net763 vssd1 vssd1 vccd1
+ vccd1 _00350_ sky130_fd_sc_hd__mux2_1
XANTENNA__11344__X net182 vssd1 vssd1 vccd1 vccd1 sky130_fd_sc_hd__diode_2
XANTENNA__07541__Y _02592_ vssd1 vssd1 vccd1 vccd1 sky130_fd_sc_hd__diode_2
XFILLER_72_141 vssd1 vssd1 vccd1 vccd1 sky130_fd_sc_hd__fill_2
X_11844_ cell1.CB_0.config_dataB\[0\] cell1.CB_0.config_dataA\[24\] net878 vssd1 vssd1
+ vccd1 vccd1 _00281_ sky130_fd_sc_hd__mux2_1
XFILLER_33_517 vssd1 vssd1 vccd1 vccd1 sky130_fd_sc_hd__fill_4
XANTENNA__07351__A1 net340 vssd1 vssd1 vccd1 vccd1 sky130_fd_sc_hd__diode_2
XFILLER_54_62 vssd1 vssd1 vccd1 vccd1 sky130_fd_sc_hd__fill_1
XFILLER_26_580 vssd1 vssd1 vccd1 vccd1 sky130_fd_sc_hd__fill_2
XTAP_TAPCELL_ROW_103_1857 vssd1 vccd1 sky130_fd_sc_hd__tapvpwrvgnd_1
XTAP_TAPCELL_ROW_103_1846 vssd1 vccd1 sky130_fd_sc_hd__tapvpwrvgnd_1
XANTENNA__11504__B _04442_ vssd1 vssd1 vccd1 vccd1 sky130_fd_sc_hd__diode_2
X_11775_ net1450 cell0.LEI0.config_data\[24\] net791 vssd1 vssd1 vccd1 vccd1 _00212_
+ sky130_fd_sc_hd__mux2_1
X_10726_ cell3.LE_1A.config_data\[10\] cell3.LE_1A.config_data\[11\] _05600_ vssd1
+ vssd1 vccd1 vccd1 _05684_ sky130_fd_sc_hd__mux2_1
X_13514_ clknet_leaf_99_clk net1201 net681 vssd1 vssd1 vccd1 vccd1 cell1.LE_1A.config_data\[1\]
+ sky130_fd_sc_hd__dfrtp_1
XANTENNA_input98_X net98 vssd1 vssd1 vccd1 vccd1 sky130_fd_sc_hd__diode_2
XTAP_TAPCELL_ROW_136_2345 vssd1 vccd1 sky130_fd_sc_hd__tapvpwrvgnd_1
X_10657_ _05475_ _05478_ _01791_ vssd1 vssd1 vccd1 vccd1 _05615_ sky130_fd_sc_hd__mux2_1
X_13445_ clknet_leaf_129_clk _00417_ net578 vssd1 vssd1 vccd1 vccd1 cell0.SB0.route_sel\[86\]
+ sky130_fd_sc_hd__dfstp_1
Xclkload26 clknet_leaf_8_clk vssd1 vssd1 vccd1 vccd1 clkload26/X sky130_fd_sc_hd__clkbuf_4
Xclkload15 clknet_leaf_0_clk vssd1 vssd1 vccd1 vccd1 clkload15/Y sky130_fd_sc_hd__inv_8
Xclkload59 clknet_leaf_44_clk vssd1 vssd1 vccd1 vccd1 clkload59/Y sky130_fd_sc_hd__clkinv_16
X_10588_ net395 _05540_ _05545_ net394 vssd1 vssd1 vccd1 vccd1 _05546_ sky130_fd_sc_hd__o211ai_1
Xclkload48 clknet_leaf_24_clk vssd1 vssd1 vccd1 vccd1 clkload48/Y sky130_fd_sc_hd__clkinv_2
Xclkload37 clknet_leaf_13_clk vssd1 vssd1 vccd1 vccd1 clkload37/X sky130_fd_sc_hd__clkbuf_4
XTAP_TAPCELL_ROW_11_475 vssd1 vccd1 sky130_fd_sc_hd__tapvpwrvgnd_1
X_13376_ clknet_leaf_130_clk _00348_ net558 vssd1 vssd1 vccd1 vccd1 cell0.SB0.route_sel\[17\]
+ sky130_fd_sc_hd__dfstp_2
X_12327_ cell1.SB0.route_sel\[65\] cell1.SB0.route_sel\[64\] net867 vssd1 vssd1 vccd1
+ vccd1 _00760_ sky130_fd_sc_hd__mux2_1
XANTENNA__07272__B1_N _02328_ vssd1 vssd1 vccd1 vccd1 sky130_fd_sc_hd__diode_2
XFILLER_141_113 vssd1 vssd1 vccd1 vccd1 sky130_fd_sc_hd__fill_1
X_12258_ cell2.CB_0.config_dataA\[21\] cell2.CB_0.config_dataA\[20\] net841 vssd1
+ vssd1 vccd1 vccd1 _00691_ sky130_fd_sc_hd__mux2_1
X_11209_ _05856_ _06145_ _06147_ _05861_ _01801_ vssd1 vssd1 vccd1 vccd1 _06161_ sky130_fd_sc_hd__a221o_1
XANTENNA__11519__X net248 vssd1 vssd1 vccd1 vccd1 sky130_fd_sc_hd__diode_2
X_12189_ cell2.CB_1.config_dataA\[2\] cell2.CB_1.config_dataA\[1\] net846 vssd1 vssd1
+ vccd1 vccd1 _00622_ sky130_fd_sc_hd__mux2_1
XFILLER_49_650 vssd1 vssd1 vccd1 vccd1 sky130_fd_sc_hd__fill_1
XANTENNA__12070__B _03666_ vssd1 vssd1 vccd1 vccd1 sky130_fd_sc_hd__diode_2
XANTENNA_max_cap300_X net300 vssd1 vssd1 vccd1 vccd1 sky130_fd_sc_hd__diode_2
X_06750_ net756 vssd1 vssd1 vccd1 vccd1 _01820_ sky130_fd_sc_hd__inv_2
X_06681_ cell2.CB_1.config_dataB\[17\] vssd1 vssd1 vccd1 vccd1 _01751_ sky130_fd_sc_hd__inv_2
XANTENNA__11254__X net177 vssd1 vssd1 vccd1 vccd1 sky130_fd_sc_hd__diode_2
XANTENNA__07342__A1 net305 vssd1 vssd1 vccd1 vccd1 sky130_fd_sc_hd__diode_2
XFILLER_91_472 vssd1 vssd1 vccd1 vccd1 sky130_fd_sc_hd__fill_1
XFILLER_63_152 vssd1 vssd1 vccd1 vccd1 sky130_fd_sc_hd__fill_1
XFILLER_52_815 vssd1 vssd1 vccd1 vccd1 sky130_fd_sc_hd__fill_1
X_08420_ cell0.LE_1B.config_data\[15\] cell0.LE_1B.config_data\[14\] _03380_ vssd1
+ vssd1 vccd1 vccd1 _03458_ sky130_fd_sc_hd__mux2_1
XANTENNA__07893__A2 _02235_ vssd1 vssd1 vccd1 vccd1 sky130_fd_sc_hd__diode_2
XTAP_TAPCELL_ROW_19_586 vssd1 vccd1 sky130_fd_sc_hd__tapvpwrvgnd_1
XTAP_TAPCELL_ROW_19_597 vssd1 vccd1 sky130_fd_sc_hd__tapvpwrvgnd_1
XANTENNA__07611__C net353 vssd1 vssd1 vccd1 vccd1 sky130_fd_sc_hd__diode_2
X_08351_ bus1_0\[12\] bus1_0\[13\] bus1_0\[14\] bus1_0\[15\] net504 cell0.CB_1.config_dataB\[11\]
+ vssd1 vssd1 vccd1 vccd1 _03389_ sky130_fd_sc_hd__mux4_1
XANTENNA__09659__X _04674_ vssd1 vssd1 vccd1 vccd1 sky130_fd_sc_hd__diode_2
XANTENNA__08842__A1 bus3_1\[5\] vssd1 vssd1 vccd1 vccd1 sky130_fd_sc_hd__diode_2
X_08282_ bus1_0\[12\] bus1_0\[13\] bus1_0\[14\] bus1_0\[15\] net507 net505 vssd1 vssd1
+ vccd1 vccd1 _03320_ sky130_fd_sc_hd__mux4_1
X_07302_ _02050_ _02358_ vssd1 vssd1 vccd1 vccd1 _02360_ sky130_fd_sc_hd__or2_1
XANTENNA__08842__B2 bus3_1\[4\] vssd1 vssd1 vccd1 vccd1 sky130_fd_sc_hd__diode_2
X_07233_ net330 _02292_ _02289_ vssd1 vssd1 vccd1 vccd1 _02293_ sky130_fd_sc_hd__mux2_1
Xclkload9 clknet_4_9_0_clk vssd1 vssd1 vccd1 vccd1 clkload9/Y sky130_fd_sc_hd__inv_8
XTAP_TAPCELL_ROW_30_751 vssd1 vccd1 sky130_fd_sc_hd__tapvpwrvgnd_1
XTAP_TAPCELL_ROW_30_762 vssd1 vccd1 sky130_fd_sc_hd__tapvpwrvgnd_1
XFILLER_117_121 vssd1 vssd1 vccd1 vccd1 sky130_fd_sc_hd__fill_1
X_07164_ _01888_ _02063_ bus3_1\[10\] vssd1 vssd1 vccd1 vccd1 _02226_ sky130_fd_sc_hd__o21ai_1
XFILLER_117_165 vssd1 vssd1 vccd1 vccd1 sky130_fd_sc_hd__fill_1
XTAP_TAPCELL_ROW_76_1447 vssd1 vccd1 sky130_fd_sc_hd__tapvpwrvgnd_1
X_07095_ cell1.SB0.route_sel\[72\] cell1.SB0.route_sel\[73\] _02150_ _02158_ net868
+ vssd1 vssd1 vccd1 vccd1 _02159_ sky130_fd_sc_hd__a311oi_4
XFILLER_99_561 vssd1 vssd1 vccd1 vccd1 sky130_fd_sc_hd__fill_1
XANTENNA__11429__X net203 vssd1 vssd1 vccd1 vccd1 sky130_fd_sc_hd__diode_2
XANTENNA__10704__A2 net10 vssd1 vssd1 vccd1 vccd1 sky130_fd_sc_hd__diode_2
XFILLER_59_447 vssd1 vssd1 vccd1 vccd1 sky130_fd_sc_hd__fill_1
Xfanout279 cell3.CB_0.le_outB vssd1 vssd1 vccd1 vccd1 net279 sky130_fd_sc_hd__clkbuf_2
XANTENNA_input2_A CBeast_in[10] vssd1 vssd1 vccd1 vccd1 sky130_fd_sc_hd__diode_2
X_09805_ net447 _04348_ vssd1 vssd1 vccd1 vccd1 _04811_ sky130_fd_sc_hd__nand2_1
X_07997_ _03035_ _03038_ cell0.CB_0.config_dataB\[8\] vssd1 vssd1 vccd1 vccd1 _03039_
+ sky130_fd_sc_hd__or3b_1
XANTENNA_fanout664_A net675 vssd1 vssd1 vccd1 vccd1 sky130_fd_sc_hd__diode_2
XFILLER_101_577 vssd1 vssd1 vccd1 vccd1 sky130_fd_sc_hd__fill_2
XFILLER_86_288 vccd1 vssd1 vccd1 vssd1 sky130_ef_sc_hd__decap_40_12
X_09736_ _04746_ _04257_ vssd1 vssd1 vccd1 vccd1 bus2_0\[1\] sky130_fd_sc_hd__and2b_2
XANTENNA__09307__C1 _02896_ vssd1 vssd1 vccd1 vccd1 sky130_fd_sc_hd__diode_2
X_06948_ cell0.CB_1.config_dataB\[24\] cell0.CB_1.config_dataB\[20\] cell0.CB_1.config_dataB\[21\]
+ vssd1 vssd1 vccd1 vccd1 _02014_ sky130_fd_sc_hd__or3_2
X_09667_ _04675_ _04681_ _04677_ vssd1 vssd1 vccd1 vccd1 _04682_ sky130_fd_sc_hd__a21boi_2
XANTENNA_fanout929_A net934 vssd1 vssd1 vccd1 vccd1 sky130_fd_sc_hd__diode_2
XTAP_TAPCELL_ROW_120_2113 vssd1 vccd1 sky130_fd_sc_hd__tapvpwrvgnd_1
XTAP_TAPCELL_ROW_120_2102 vssd1 vccd1 sky130_fd_sc_hd__tapvpwrvgnd_1
XANTENNA__09873__A3 bus3_2\[15\] vssd1 vssd1 vccd1 vccd1 sky130_fd_sc_hd__diode_2
XANTENNA_fanout831_A net837 vssd1 vssd1 vccd1 vccd1 sky130_fd_sc_hd__diode_2
X_06879_ cell0.CB_0.config_dataB\[24\] cell0.CB_0.config_dataB\[20\] cell0.CB_0.config_dataB\[21\]
+ vssd1 vssd1 vccd1 vccd1 _01947_ sky130_fd_sc_hd__nand3b_4
XTAP_TAPCELL_ROW_38_873 vssd1 vccd1 sky130_fd_sc_hd__tapvpwrvgnd_1
X_08618_ cell1.LE_1A.config_data\[11\] cell1.LE_1A.config_data\[10\] _03546_ vssd1
+ vssd1 vccd1 vccd1 _03654_ sky130_fd_sc_hd__mux2_1
XFILLER_91_27 vccd1 vssd1 vccd1 vssd1 sky130_ef_sc_hd__decap_40_12
X_09598_ _02289_ _04613_ _04614_ vssd1 vssd1 vccd1 vccd1 _04615_ sky130_fd_sc_hd__a21o_1
XTAP_TAPCELL_ROW_38_884 vssd1 vccd1 sky130_fd_sc_hd__tapvpwrvgnd_1
X_08549_ net492 _03529_ vssd1 vssd1 vccd1 vccd1 _03585_ sky130_fd_sc_hd__nand2_1
XANTENNA__12090__A0 cell1.LE_0B.reset_val vssd1 vssd1 vccd1 vccd1 sky130_fd_sc_hd__diode_2
X_11560_ net1204 cell0.LE_1B.config_data\[0\] net801 vssd1 vssd1 vccd1 vccd1 _00001_
+ sky130_fd_sc_hd__mux2_1
XANTENNA__08473__X _03509_ vssd1 vssd1 vccd1 vccd1 sky130_fd_sc_hd__diode_2
X_10511_ _02501_ _03486_ vssd1 vssd1 vccd1 vccd1 _05471_ sky130_fd_sc_hd__nand2b_1
X_11491_ _01580_ cell2.SB0.route_sel\[10\] cell2.SB0.route_sel\[13\] _01583_ _06327_
+ vssd1 vssd1 vccd1 vccd1 _06328_ sky130_fd_sc_hd__a221o_1
X_13230_ clknet_leaf_2_clk _00202_ net569 vssd1 vssd1 vccd1 vccd1 cell0.LEI0.config_data\[15\]
+ sky130_fd_sc_hd__dfrtp_1
XFILLER_40_20 vssd1 vssd1 vccd1 vccd1 sky130_fd_sc_hd__fill_8
XFILLER_7_727 vssd1 vssd1 vccd1 vccd1 sky130_fd_sc_hd__fill_1
XTAP_TAPCELL_ROW_118_2075 vssd1 vccd1 sky130_fd_sc_hd__tapvpwrvgnd_1
X_10442_ cell3.SB0.route_sel\[40\] cell3.SB0.route_sel\[41\] vssd1 vssd1 vccd1 vccd1
+ _05435_ sky130_fd_sc_hd__nor2_1
XFILLER_40_53 vssd1 vssd1 vccd1 vccd1 sky130_fd_sc_hd__fill_4
X_10373_ net36 net37 net38 net39 net429 net427 vssd1 vssd1 vccd1 vccd1 _05372_ sky130_fd_sc_hd__mux4_1
XFILLER_123_102 vssd1 vssd1 vccd1 vccd1 sky130_fd_sc_hd__fill_1
X_13161_ clknet_leaf_116_clk _00133_ net667 vssd1 vssd1 vccd1 vccd1 cell0.LE_1A.config_data\[12\]
+ sky130_fd_sc_hd__dfrtp_1
XANTENNA_input58_A CBnorth_in[3] vssd1 vssd1 vccd1 vccd1 sky130_fd_sc_hd__diode_2
XTAP_TAPCELL_ROW_131_2275 vssd1 vccd1 sky130_fd_sc_hd__tapvpwrvgnd_1
X_12112_ cell1.LE_0A.edge_mode cell1.LE_0A.config_data\[16\] net877 vssd1 vssd1 vccd1
+ vccd1 _00546_ sky130_fd_sc_hd__mux2_1
X_13092_ clknet_leaf_10_clk _00064_ net570 vssd1 vssd1 vccd1 vccd1 cell0.CB_0.config_dataB\[19\]
+ sky130_fd_sc_hd__dfstp_1
XFILLER_2_421 vccd1 vssd1 vccd1 vssd1 sky130_ef_sc_hd__decap_40_12
X_12043_ cell1.CB_1.config_dataB\[21\] cell1.CB_1.config_dataB\[20\] net887 vssd1
+ vssd1 vccd1 vccd1 _00480_ sky130_fd_sc_hd__mux2_1
XANTENNA__10156__A0 net55 vssd1 vssd1 vccd1 vccd1 sky130_fd_sc_hd__diode_2
XANTENNA__09010__A1 bus3_1\[13\] vssd1 vssd1 vccd1 vccd1 sky130_fd_sc_hd__diode_2
XFILLER_49_84 vssd1 vssd1 vccd1 vccd1 sky130_fd_sc_hd__fill_1
XANTENNA__13935__RESET_B net619 vssd1 vssd1 vccd1 vccd1 sky130_fd_sc_hd__diode_2
Xfanout780 net807 vssd1 vssd1 vccd1 vccd1 net780 sky130_fd_sc_hd__buf_2
Xfanout791 net794 vssd1 vssd1 vccd1 vccd1 net791 sky130_fd_sc_hd__clkbuf_4
XANTENNA_input13_X net13 vssd1 vssd1 vccd1 vccd1 sky130_fd_sc_hd__diode_2
X_13994_ clknet_leaf_74_clk _00966_ net725 vssd1 vssd1 vccd1 vccd1 cell3.SB0.route_sel\[2\]
+ sky130_fd_sc_hd__dfstp_1
XFILLER_1_69 vccd1 vssd1 vccd1 vssd1 sky130_ef_sc_hd__decap_40_12
X_12945_ cell3.LE_0B.config_data\[10\] net976 net950 vssd1 vssd1 vccd1 vccd1 _01373_
+ sky130_fd_sc_hd__mux2_1
XANTENNA__13695__SET_B net621 vssd1 vssd1 vccd1 vccd1 sky130_fd_sc_hd__diode_2
XTAP_TAPCELL_ROW_47_1015 vssd1 vccd1 sky130_fd_sc_hd__tapvpwrvgnd_1
XANTENNA_output214_A net214 vssd1 vssd1 vccd1 vccd1 sky130_fd_sc_hd__diode_2
X_12876_ cell2.SB0.route_sel\[118\] cell2.SB0.route_sel\[117\] net818 vssd1 vssd1
+ vccd1 vccd1 _01305_ sky130_fd_sc_hd__mux2_1
XANTENNA__11140__A1_N _05901_ vssd1 vssd1 vccd1 vccd1 sky130_fd_sc_hd__diode_2
XTAP_TAPCELL_ROW_16_545 vssd1 vccd1 sky130_fd_sc_hd__tapvpwrvgnd_1
X_11827_ cell1.CB_1.config_dataA\[8\] cell1.CB_1.config_dataA\[7\] net888 vssd1 vssd1
+ vccd1 vccd1 _00264_ sky130_fd_sc_hd__mux2_1
XTAP_TAPCELL_ROW_60_1215 vssd1 vccd1 sky130_fd_sc_hd__tapvpwrvgnd_1
XTAP_TAPCELL_ROW_60_1204 vssd1 vccd1 sky130_fd_sc_hd__tapvpwrvgnd_1
X_11758_ cell0.LEI0.config_data\[8\] net1297 net799 vssd1 vssd1 vccd1 vccd1 _00195_
+ sky130_fd_sc_hd__mux2_1
XANTENNA__10631__A1 net9 vssd1 vssd1 vccd1 vccd1 sky130_fd_sc_hd__diode_2
X_10709_ _05513_ _05643_ _05644_ _05510_ vssd1 vssd1 vccd1 vccd1 _05667_ sky130_fd_sc_hd__a2bb2o_1
X_14477_ clknet_leaf_60_clk _01449_ net740 vssd1 vssd1 vccd1 vccd1 cell3.LEI0.config_data\[42\]
+ sky130_fd_sc_hd__dfrtp_1
Xclkload104 clknet_leaf_48_clk vssd1 vssd1 vccd1 vccd1 clkload104/Y sky130_fd_sc_hd__clkinv_8
XANTENNA__08543__B net323 vssd1 vssd1 vccd1 vccd1 sky130_fd_sc_hd__diode_2
X_11689_ net1147 net1083 net872 vssd1 vssd1 vccd1 vccd1 _00129_ sky130_fd_sc_hd__mux2_1
Xclkload126 clknet_leaf_61_clk vssd1 vssd1 vccd1 vccd1 clkload126/Y sky130_fd_sc_hd__inv_6
Xclkload115 clknet_leaf_58_clk vssd1 vssd1 vccd1 vccd1 clkload115/Y sky130_fd_sc_hd__clkinv_4
Xclkload137 clknet_1_1__leaf_cell2.LE_0A.sel_clk vssd1 vssd1 vccd1 vccd1 clkload137/X
+ sky130_fd_sc_hd__clkbuf_4
X_13428_ clknet_leaf_1_clk _00400_ net560 vssd1 vssd1 vccd1 vccd1 cell0.SB0.route_sel\[69\]
+ sky130_fd_sc_hd__dfstp_1
XANTENNA__10395__A0 net63 vssd1 vssd1 vccd1 vccd1 sky130_fd_sc_hd__diode_2
XANTENNA__09785__C1 _04790_ vssd1 vssd1 vccd1 vccd1 sky130_fd_sc_hd__diode_2
Xclkload148 clknet_1_1__leaf_cell0.LE_1B.sel_clk vssd1 vssd1 vccd1 vccd1 clkload148/X
+ sky130_fd_sc_hd__clkbuf_4
X_13359_ clknet_leaf_128_clk _00331_ net576 vssd1 vssd1 vccd1 vccd1 cell0.SB0.route_sel\[0\]
+ sky130_fd_sc_hd__dfstp_1
XTAP_TAPCELL_ROW_58_1177 vssd1 vccd1 sky130_fd_sc_hd__tapvpwrvgnd_1
XFILLER_5_281 vccd1 vssd1 vccd1 vssd1 sky130_ef_sc_hd__decap_40_12
X_07920_ _02959_ _02962_ _02963_ _01573_ _02957_ vssd1 vssd1 vccd1 vccd1 _02964_ sky130_fd_sc_hd__a221o_1
XANTENNA__10698__B2 _05483_ vssd1 vssd1 vccd1 vccd1 sky130_fd_sc_hd__diode_2
XANTENNA__10698__A1 _05489_ vssd1 vssd1 vccd1 vccd1 sky130_fd_sc_hd__diode_2
XTAP_TAPCELL_ROW_71_1377 vssd1 vccd1 sky130_fd_sc_hd__tapvpwrvgnd_1
XTAP_TAPCELL_ROW_71_1366 vssd1 vccd1 sky130_fd_sc_hd__tapvpwrvgnd_1
X_07851_ cell0.SB0.route_sel\[29\] cell0.SB0.route_sel\[28\] vssd1 vssd1 vccd1 vccd1
+ _02895_ sky130_fd_sc_hd__nand2b_1
XFILLER_110_363 vssd1 vssd1 vccd1 vccd1 sky130_fd_sc_hd__fill_1
Xinput2 CBeast_in[10] vssd1 vssd1 vccd1 vccd1 net2 sky130_fd_sc_hd__clkbuf_4
X_06802_ _01864_ _01870_ _01871_ _01865_ vssd1 vssd1 vccd1 vccd1 _01872_ sky130_fd_sc_hd__o31a_1
XANTENNA__07563__A1 net358 vssd1 vssd1 vccd1 vccd1 sky130_fd_sc_hd__diode_2
X_07782_ _02824_ _02826_ _02825_ vssd1 vssd1 vccd1 vccd1 _02827_ sky130_fd_sc_hd__a21o_1
X_06733_ cell3.LE_0B.config_data\[16\] vssd1 vssd1 vccd1 vccd1 _01803_ sky130_fd_sc_hd__inv_2
XANTENNA__12439__A2 net549 vssd1 vssd1 vccd1 vccd1 sky130_fd_sc_hd__diode_2
X_09521_ _04531_ _04540_ vssd1 vssd1 vccd1 vccd1 _04541_ sky130_fd_sc_hd__nor2_1
XANTENNA__08107__A3 net338 vssd1 vssd1 vccd1 vccd1 sky130_fd_sc_hd__diode_2
XFILLER_101_15 vccd1 vssd1 vccd1 vssd1 sky130_ef_sc_hd__decap_40_12
X_09452_ cell3.SB0.route_sel\[55\] cell3.SB0.route_sel\[54\] net314 _01902_ _04467_
+ vssd1 vssd1 vccd1 vccd1 _04474_ sky130_fd_sc_hd__a221oi_2
X_06664_ cell3.SB0.route_sel\[95\] vssd1 vssd1 vccd1 vccd1 _01734_ sky130_fd_sc_hd__inv_2
XTAP_TAPCELL_ROW_35_832 vssd1 vccd1 sky130_fd_sc_hd__tapvpwrvgnd_1
X_09383_ _04207_ _04406_ vssd1 vssd1 vccd1 vccd1 _04407_ sky130_fd_sc_hd__nor2_1
X_08403_ _01493_ _03436_ _03437_ _03440_ vssd1 vssd1 vccd1 vccd1 _03441_ sky130_fd_sc_hd__o2bb2a_1
X_06595_ cell1.CB_1.config_dataA\[12\] vssd1 vssd1 vccd1 vccd1 _01665_ sky130_fd_sc_hd__inv_2
X_08334_ _03370_ _03371_ cell0.CB_1.config_dataB\[2\] vssd1 vssd1 vccd1 vccd1 _03372_
+ sky130_fd_sc_hd__mux2_1
X_08265_ cell0.LE_1A.config_data\[13\] cell0.LE_1A.config_data\[12\] _03198_ vssd1
+ vssd1 vccd1 vccd1 _03305_ sky130_fd_sc_hd__mux2_1
X_08196_ _02350_ _02425_ _02495_ _02560_ net539 net538 vssd1 vssd1 vccd1 vccd1 _03236_
+ sky130_fd_sc_hd__mux4_1
X_07216_ cell0.SB0.route_sel\[88\] _01474_ cell0.SB0.route_sel\[93\] cell0.SB0.route_sel\[92\]
+ _02275_ vssd1 vssd1 vccd1 vccd1 _02276_ sky130_fd_sc_hd__o221a_1
XANTENNA__08043__A2 cell0.CB_1.le_outA vssd1 vssd1 vccd1 vccd1 sky130_fd_sc_hd__diode_2
X_07147_ cell0.SB0.route_sel\[80\] cell0.SB0.route_sel\[81\] vssd1 vssd1 vccd1 vccd1
+ _02209_ sky130_fd_sc_hd__nand2b_1
XFILLER_105_113 vssd1 vssd1 vccd1 vccd1 sky130_fd_sc_hd__fill_1
XANTENNA__07251__B1 bus3_2\[11\] vssd1 vssd1 vccd1 vccd1 sky130_fd_sc_hd__diode_2
XANTENNA__09791__A2 _04724_ vssd1 vssd1 vccd1 vccd1 sky130_fd_sc_hd__diode_2
X_07078_ net82 _02138_ _02141_ vssd1 vssd1 vccd1 vccd1 _02142_ sky130_fd_sc_hd__a21oi_1
XFILLER_86_27 vssd1 vssd1 vccd1 vccd1 sky130_fd_sc_hd__fill_1
XANTENNA_input5_X net5 vssd1 vssd1 vccd1 vccd1 sky130_fd_sc_hd__diode_2
XANTENNA__07554__B2 cell2.SB0.config_data_out vssd1 vssd1 vccd1 vccd1 sky130_fd_sc_hd__diode_2
XTAP_TAPCELL_ROW_89_1638 vssd1 vccd1 sky130_fd_sc_hd__tapvpwrvgnd_1
XTAP_TAPCELL_ROW_89_1649 vssd1 vccd1 sky130_fd_sc_hd__tapvpwrvgnd_1
XANTENNA__08468__X _03504_ vssd1 vssd1 vccd1 vccd1 sky130_fd_sc_hd__diode_2
X_10991_ _05893_ _05890_ cell3.CB_0.config_dataA\[5\] vssd1 vssd1 vccd1 vccd1 _05945_
+ sky130_fd_sc_hd__mux2_1
X_09719_ _04731_ _04720_ vssd1 vssd1 vccd1 vccd1 _04732_ sky130_fd_sc_hd__nand2b_1
XFILLER_27_152 vssd1 vssd1 vccd1 vccd1 sky130_fd_sc_hd__fill_2
X_12730_ net381 cell3.CB_0.config_dataB\[21\] net933 vssd1 vssd1 vccd1 vccd1 _01159_
+ sky130_fd_sc_hd__mux2_1
XANTENNA_input112_A SBwest_in[23] vssd1 vssd1 vccd1 vccd1 sky130_fd_sc_hd__diode_2
XANTENNA__07532__B cell0.SB0.config_data_out vssd1 vssd1 vccd1 vccd1 sky130_fd_sc_hd__diode_2
XPHY_EDGE_ROW_106_Left_249 vssd1 vssd1 vccd1 vccd1 sky130_fd_sc_hd__decap_3
X_12661_ cell3.SB0.route_sel\[126\] cell3.SB0.route_sel\[125\] net913 vssd1 vssd1
+ vccd1 vccd1 _01090_ sky130_fd_sc_hd__mux2_1
XANTENNA__10861__A1 net9 vssd1 vssd1 vccd1 vccd1 sky130_fd_sc_hd__diode_2
X_14400_ clknet_leaf_57_clk _01372_ net738 vssd1 vssd1 vccd1 vccd1 cell3.LE_0B.config_data\[9\]
+ sky130_fd_sc_hd__dfrtp_1
XTAP_TAPCELL_ROW_100_1805 vssd1 vccd1 sky130_fd_sc_hd__tapvpwrvgnd_1
X_11612_ cell0.CB_0.config_dataB\[8\] cell0.CB_0.config_dataB\[7\] net773 vssd1 vssd1
+ vccd1 vccd1 _00053_ sky130_fd_sc_hd__mux2_1
XFILLER_70_464 vssd1 vssd1 vccd1 vccd1 sky130_fd_sc_hd__fill_2
XTAP_TAPCELL_ROW_13_504 vssd1 vccd1 sky130_fd_sc_hd__tapvpwrvgnd_1
XFILLER_30_317 vssd1 vssd1 vccd1 vccd1 sky130_fd_sc_hd__fill_1
X_12592_ cell3.SB0.route_sel\[57\] cell3.SB0.route_sel\[56\] net912 vssd1 vssd1 vccd1
+ vccd1 _01021_ sky130_fd_sc_hd__mux2_1
XFILLER_23_391 vssd1 vssd1 vccd1 vccd1 sky130_fd_sc_hd__fill_1
XFILLER_128_227 vssd1 vssd1 vccd1 vccd1 sky130_fd_sc_hd__fill_1
X_14331_ clknet_leaf_19_clk _01303_ net613 vssd1 vssd1 vccd1 vccd1 cell2.SB0.route_sel\[116\]
+ sky130_fd_sc_hd__dfstp_1
X_11543_ _02675_ _06362_ vssd1 vssd1 vccd1 vccd1 net209 sky130_fd_sc_hd__nor2_1
XANTENNA__08282__A2 bus1_0\[14\] vssd1 vssd1 vccd1 vccd1 sky130_fd_sc_hd__diode_2
XTAP_TAPCELL_ROW_133_2304 vssd1 vccd1 sky130_fd_sc_hd__tapvpwrvgnd_1
X_14262_ clknet_leaf_25_clk _01234_ net607 vssd1 vssd1 vccd1 vccd1 cell2.SB0.route_sel\[47\]
+ sky130_fd_sc_hd__dfstp_1
X_11474_ _02295_ _06316_ vssd1 vssd1 vccd1 vccd1 net217 sky130_fd_sc_hd__nor2_1
XFILLER_137_783 vssd1 vssd1 vccd1 vccd1 sky130_fd_sc_hd__fill_1
X_10425_ _05423_ _05420_ _05380_ vssd1 vssd1 vccd1 vccd1 _05424_ sky130_fd_sc_hd__mux2_1
X_14193_ clknet_leaf_53_clk _01165_ net714 vssd1 vssd1 vccd1 vccd1 cell3.CB_0.config_dataA\[3\]
+ sky130_fd_sc_hd__dfstp_1
XFILLER_109_463 vssd1 vssd1 vccd1 vccd1 sky130_fd_sc_hd__fill_1
X_13213_ clknet_1_1__leaf_cell0.LE_0B.sel_clk _00185_ net751 vssd1 vssd1 vccd1 vccd1
+ cell0.LE_0B.dff1_out sky130_fd_sc_hd__dfstp_1
X_13144_ clknet_leaf_129_clk _00116_ net578 vssd1 vssd1 vccd1 vccd1 cell0.CB_1.config_dataB\[21\]
+ sky130_fd_sc_hd__dfstp_1
XANTENNA__09782__A2 net315 vssd1 vssd1 vccd1 vccd1 sky130_fd_sc_hd__diode_2
X_10356_ _05354_ _05353_ _05351_ _05347_ vssd1 vssd1 vccd1 vccd1 _05355_ sky130_fd_sc_hd__a2bb2o_1
XPHY_EDGE_ROW_115_Left_258 vssd1 vssd1 vccd1 vccd1 sky130_fd_sc_hd__decap_3
XFILLER_3_741 vccd1 vssd1 vccd1 vssd1 sky130_ef_sc_hd__decap_40_12
X_10287_ net431 _05148_ _05285_ net430 vssd1 vssd1 vccd1 vccd1 _05286_ sky130_fd_sc_hd__o211a_1
XFILLER_97_317 vssd1 vssd1 vccd1 vccd1 sky130_fd_sc_hd__fill_1
X_13075_ clknet_leaf_8_clk _00047_ net574 vssd1 vssd1 vccd1 vccd1 cell0.CB_0.config_dataB\[2\]
+ sky130_fd_sc_hd__dfstp_1
XFILLER_3_785 vccd1 vssd1 vccd1 vssd1 sky130_ef_sc_hd__decap_40_12
XFILLER_2_251 vssd1 vssd1 vccd1 vccd1 sky130_fd_sc_hd__fill_1
XTAP_TAPCELL_ROW_111_1978 vssd1 vccd1 sky130_fd_sc_hd__tapvpwrvgnd_1
XTAP_TAPCELL_ROW_111_1967 vssd1 vccd1 sky130_fd_sc_hd__tapvpwrvgnd_1
XFILLER_78_531 vssd1 vssd1 vccd1 vccd1 sky130_fd_sc_hd__fill_1
X_12026_ cell1.CB_1.config_dataB\[4\] cell1.CB_1.config_dataB\[3\] net901 vssd1 vssd1
+ vccd1 vccd1 _00463_ sky130_fd_sc_hd__mux2_1
XANTENNA__11341__A2 _05890_ vssd1 vssd1 vccd1 vccd1 sky130_fd_sc_hd__diode_2
XFILLER_78_586 vssd1 vssd1 vccd1 vccd1 sky130_fd_sc_hd__fill_2
XTAP_TAPCELL_ROW_53_1096 vssd1 vccd1 sky130_fd_sc_hd__tapvpwrvgnd_1
XFILLER_38_417 vssd1 vssd1 vccd1 vccd1 sky130_fd_sc_hd__fill_1
XANTENNA__08742__A0 net31 vssd1 vssd1 vccd1 vccd1 sky130_fd_sc_hd__diode_2
X_13977_ clknet_leaf_42_clk _00949_ net633 vssd1 vssd1 vccd1 vccd1 cell2.LEI0.config_data\[34\]
+ sky130_fd_sc_hd__dfrtp_1
XPHY_EDGE_ROW_124_Left_267 vssd1 vssd1 vccd1 vccd1 sky130_fd_sc_hd__decap_3
X_12928_ cell3.LE_1A.config_data\[16\] net1396 net953 vssd1 vssd1 vccd1 vccd1 _01357_
+ sky130_fd_sc_hd__mux2_1
XFILLER_33_111 vssd1 vssd1 vccd1 vccd1 sky130_fd_sc_hd__fill_1
X_12859_ cell2.SB0.route_sel\[101\] cell2.SB0.route_sel\[100\] net821 vssd1 vssd1
+ vccd1 vccd1 _01288_ sky130_fd_sc_hd__mux2_1
XANTENNA__07481__A0 net38 vssd1 vssd1 vccd1 vccd1 sky130_fd_sc_hd__diode_2
X_08050_ net526 net527 vssd1 vssd1 vccd1 vccd1 _03092_ sky130_fd_sc_hd__and2b_1
X_07001_ _02065_ _02066_ _02060_ vssd1 vssd1 vccd1 vccd1 _02067_ sky130_fd_sc_hd__a21oi_1
XPHY_EDGE_ROW_133_Left_276 vssd1 vssd1 vccd1 vccd1 sky130_fd_sc_hd__decap_3
XTAP_TAPCELL_ROW_73_1406 vssd1 vccd1 sky130_fd_sc_hd__tapvpwrvgnd_1
XANTENNA__08025__A2 bus2_0\[10\] vssd1 vssd1 vccd1 vccd1 sky130_fd_sc_hd__diode_2
XANTENNA__07233__A0 net330 vssd1 vssd1 vccd1 vccd1 sky130_fd_sc_hd__diode_2
XFILLER_130_425 vssd1 vssd1 vccd1 vccd1 sky130_fd_sc_hd__fill_2
XFILLER_130_403 vssd1 vssd1 vccd1 vccd1 sky130_fd_sc_hd__fill_4
X_08952_ _03890_ _03972_ _03973_ _03894_ _01683_ vssd1 vssd1 vccd1 vccd1 _03984_ sky130_fd_sc_hd__a221o_1
X_08883_ _03826_ _03905_ _03906_ _03830_ _01678_ vssd1 vssd1 vccd1 vccd1 _03915_ sky130_fd_sc_hd__a221o_1
X_07903_ _01570_ _02943_ _02946_ vssd1 vssd1 vccd1 vccd1 _02947_ sky130_fd_sc_hd__a21oi_4
XANTENNA__11854__S net897 vssd1 vssd1 vccd1 vccd1 sky130_fd_sc_hd__diode_2
X_07834_ _02074_ _02869_ _02870_ _02172_ cell0.CB_0.config_dataA\[7\] vssd1 vssd1
+ vccd1 vccd1 _02878_ sky130_fd_sc_hd__a221o_1
XFILLER_29_417 vssd1 vssd1 vccd1 vccd1 sky130_fd_sc_hd__fill_1
XPHY_EDGE_ROW_142_Left_285 vssd1 vssd1 vccd1 vccd1 sky130_fd_sc_hd__decap_3
XFILLER_112_25 vssd1 vssd1 vccd1 vccd1 sky130_fd_sc_hd__fill_2
XFILLER_84_589 vssd1 vssd1 vccd1 vccd1 sky130_fd_sc_hd__fill_2
X_07765_ _02789_ _02808_ _02810_ vssd1 vssd1 vccd1 vccd1 _02811_ sky130_fd_sc_hd__a21o_1
X_06716_ cell3.CB_1.config_dataA\[4\] vssd1 vssd1 vccd1 vccd1 _01786_ sky130_fd_sc_hd__inv_2
X_09504_ cell2.SB0.route_sel\[64\] cell2.SB0.route_sel\[65\] vssd1 vssd1 vccd1 vccd1
+ _04524_ sky130_fd_sc_hd__nand2b_1
XFILLER_71_228 vssd1 vssd1 vccd1 vccd1 sky130_fd_sc_hd__fill_4
X_07696_ _02741_ _02742_ vssd1 vssd1 vccd1 vccd1 _02743_ sky130_fd_sc_hd__nand2_1
X_09435_ net46 _04457_ vssd1 vssd1 vccd1 vccd1 _04458_ sky130_fd_sc_hd__or2_1
XTAP_TAPCELL_ROW_84_1568 vssd1 vccd1 sky130_fd_sc_hd__tapvpwrvgnd_1
X_06647_ cell3.SB0.route_sel\[65\] vssd1 vssd1 vccd1 vccd1 _01717_ sky130_fd_sc_hd__inv_2
X_09366_ _01920_ _02095_ vssd1 vssd1 vccd1 vccd1 _04390_ sky130_fd_sc_hd__nor2_1
X_06578_ net120 vssd1 vssd1 vccd1 vccd1 _01648_ sky130_fd_sc_hd__inv_2
X_09297_ _01691_ cell3.SB0.route_sel\[18\] cell3.SB0.route_sel\[22\] cell3.SB0.route_sel\[23\]
+ _04322_ vssd1 vssd1 vccd1 vccd1 _04323_ sky130_fd_sc_hd__o221a_1
XANTENNA_40 net147 vssd1 vssd1 vccd1 vccd1 sky130_fd_sc_hd__diode_2
X_08317_ cell0.CB_1.config_dataB\[2\] cell0.CB_1.config_dataB\[3\] vssd1 vssd1 vccd1
+ vccd1 _03355_ sky130_fd_sc_hd__nor2_1
XANTENNA_51 net142 vssd1 vssd1 vccd1 vccd1 sky130_fd_sc_hd__diode_2
XANTENNA__08183__B _02277_ vssd1 vssd1 vccd1 vccd1 sky130_fd_sc_hd__diode_2
XFILLER_20_372 vssd1 vssd1 vccd1 vccd1 sky130_fd_sc_hd__fill_1
X_08248_ net535 _03286_ _03287_ vssd1 vssd1 vccd1 vccd1 _03288_ sky130_fd_sc_hd__a21oi_1
XTAP_TAPCELL_ROW_115_2034 vssd1 vccd1 sky130_fd_sc_hd__tapvpwrvgnd_1
XFILLER_21_55 vssd1 vssd1 vccd1 vccd1 sky130_fd_sc_hd__fill_1
XFILLER_137_55 vssd1 vssd1 vccd1 vccd1 sky130_fd_sc_hd__fill_1
X_10210_ net415 _05144_ vssd1 vssd1 vccd1 vccd1 _05211_ sky130_fd_sc_hd__nand2_1
X_08179_ _02350_ _03202_ _03217_ _03218_ cell0.CB_1.config_dataA\[7\] vssd1 vssd1
+ vccd1 vccd1 _03219_ sky130_fd_sc_hd__o2111a_1
X_11190_ cell3.CB_0.config_dataB\[14\] _06110_ _06125_ _06136_ _06141_ vssd1 vssd1
+ vccd1 vccd1 _06142_ sky130_fd_sc_hd__a311o_1
XFILLER_97_15 vccd1 vssd1 vccd1 vssd1 sky130_ef_sc_hd__decap_40_12
XFILLER_21_99 vssd1 vssd1 vccd1 vccd1 sky130_fd_sc_hd__fill_1
XANTENNA__07353__A1_N cell0.CB_1.le_outA vssd1 vssd1 vccd1 vccd1 sky130_fd_sc_hd__diode_2
XFILLER_133_274 vssd1 vssd1 vccd1 vccd1 sky130_fd_sc_hd__fill_1
XFILLER_106_477 vssd1 vssd1 vccd1 vccd1 sky130_fd_sc_hd__fill_2
XFILLER_97_59 vssd1 vssd1 vccd1 vccd1 sky130_fd_sc_hd__fill_1
X_10141_ cell2.SB0.route_sel\[27\] cell2.SB0.route_sel\[26\] vssd1 vssd1 vccd1 vccd1
+ _05142_ sky130_fd_sc_hd__nor2_1
Xoutput191 net191 vssd1 vssd1 vccd1 vccd1 CBnorth_out[3] sky130_fd_sc_hd__buf_2
Xoutput180 net180 vssd1 vssd1 vccd1 vccd1 CBnorth_out[22] sky130_fd_sc_hd__buf_2
X_10072_ _05074_ _05075_ _04992_ vssd1 vssd1 vccd1 vccd1 _05076_ sky130_fd_sc_hd__mux2_1
X_13900_ clknet_leaf_35_clk net1106 net639 vssd1 vssd1 vccd1 vccd1 cell2.LE_0B.config_data\[1\]
+ sky130_fd_sc_hd__dfrtp_1
XANTENNA__07246__C cell2.SB0.route_sel\[93\] vssd1 vssd1 vccd1 vccd1 sky130_fd_sc_hd__diode_2
XFILLER_0_777 vssd1 vssd1 vccd1 vccd1 sky130_fd_sc_hd__fill_4
XFILLER_75_545 vccd1 vssd1 vccd1 vssd1 sky130_ef_sc_hd__decap_40_12
X_13831_ clknet_leaf_115_clk _00803_ net657 vssd1 vssd1 vccd1 vccd1 cell1.SB0.route_sel\[108\]
+ sky130_fd_sc_hd__dfstp_1
XFILLER_28_450 vssd1 vssd1 vccd1 vccd1 sky130_fd_sc_hd__fill_1
XTAP_TAPCELL_ROW_126_2196 vssd1 vccd1 sky130_fd_sc_hd__tapvpwrvgnd_1
X_10974_ net286 net279 net298 net291 cell3.LEI0.config_data\[0\] cell3.LEI0.config_data\[1\]
+ vssd1 vssd1 vccd1 vccd1 _05928_ sky130_fd_sc_hd__mux4_1
XANTENNA_input115_X net115 vssd1 vssd1 vccd1 vccd1 sky130_fd_sc_hd__diode_2
X_13762_ clknet_leaf_111_clk _00734_ net655 vssd1 vssd1 vccd1 vccd1 cell1.SB0.route_sel\[39\]
+ sky130_fd_sc_hd__dfstp_1
X_12713_ net387 cell3.CB_0.config_dataB\[4\] net930 vssd1 vssd1 vccd1 vccd1 _01142_
+ sky130_fd_sc_hd__mux2_1
X_13693_ clknet_leaf_32_clk _00665_ net621 vssd1 vssd1 vccd1 vccd1 cell2.CB_0.config_dataB\[20\]
+ sky130_fd_sc_hd__dfstp_1
XANTENNA__11352__X net186 vssd1 vssd1 vccd1 vccd1 sky130_fd_sc_hd__diode_2
XFILLER_31_615 vssd1 vssd1 vccd1 vccd1 sky130_fd_sc_hd__fill_1
X_12644_ cell3.SB0.route_sel\[109\] cell3.SB0.route_sel\[108\] net923 vssd1 vssd1
+ vccd1 vccd1 _01073_ sky130_fd_sc_hd__mux2_1
XTAP_TAPCELL_ROW_26_695 vssd1 vccd1 sky130_fd_sc_hd__tapvpwrvgnd_1
X_12575_ cell3.SB0.route_sel\[40\] cell3.SB0.route_sel\[39\] net916 vssd1 vssd1 vccd1
+ vccd1 _01004_ sky130_fd_sc_hd__mux2_1
XFILLER_30_169 vssd1 vssd1 vccd1 vccd1 sky130_fd_sc_hd__fill_4
X_14314_ clknet_leaf_18_clk _01286_ net628 vssd1 vssd1 vccd1 vccd1 cell2.SB0.route_sel\[99\]
+ sky130_fd_sc_hd__dfstp_1
X_11526_ cell2.SB0.route_sel\[108\] cell2.SB0.route_sel\[109\] vssd1 vssd1 vccd1 vccd1
+ _06351_ sky130_fd_sc_hd__nand2b_1
XANTENNA_input80_X net80 vssd1 vssd1 vccd1 vccd1 sky130_fd_sc_hd__diode_2
XFILLER_7_57 vccd1 vssd1 vccd1 vssd1 sky130_ef_sc_hd__decap_40_12
X_14245_ clknet_leaf_20_clk _01217_ net612 vssd1 vssd1 vccd1 vccd1 cell2.SB0.route_sel\[30\]
+ sky130_fd_sc_hd__dfstp_1
X_11457_ cell1.SB0.route_sel\[49\] cell1.SB0.route_sel\[48\] vssd1 vssd1 vccd1 vccd1
+ _06305_ sky130_fd_sc_hd__nand2b_1
X_14176_ clknet_leaf_56_clk _01148_ net722 vssd1 vssd1 vccd1 vccd1 cell3.CB_0.config_dataB\[11\]
+ sky130_fd_sc_hd__dfstp_1
X_10408_ cell2.CB_0.config_dataB\[16\] _05405_ _05406_ vssd1 vssd1 vccd1 vccd1 _05407_
+ sky130_fd_sc_hd__a21o_1
XFILLER_98_604 vssd1 vssd1 vccd1 vccd1 sky130_fd_sc_hd__fill_2
XANTENNA__08558__A3 net26 vssd1 vssd1 vccd1 vccd1 sky130_fd_sc_hd__diode_2
X_11388_ _01465_ cell0.SB0.route_sel\[58\] vssd1 vssd1 vccd1 vccd1 _06259_ sky130_fd_sc_hd__nand2_1
X_10339_ net36 net37 net38 net39 net436 net434 vssd1 vssd1 vccd1 vccd1 _05338_ sky130_fd_sc_hd__mux4_1
XFILLER_98_637 vssd1 vssd1 vccd1 vccd1 sky130_fd_sc_hd__fill_1
XTAP_TAPCELL_ROW_55_1136 vssd1 vccd1 sky130_fd_sc_hd__tapvpwrvgnd_1
X_13127_ clknet_leaf_121_clk _00099_ net583 vssd1 vssd1 vccd1 vccd1 cell0.CB_1.config_dataB\[4\]
+ sky130_fd_sc_hd__dfstp_2
X_13058_ clknet_leaf_126_clk _00030_ net584 vssd1 vssd1 vccd1 vccd1 cell0.CB_1.config_dataA\[10\]
+ sky130_fd_sc_hd__dfstp_1
XANTENNA__10117__A3 net39 vssd1 vssd1 vccd1 vccd1 sky130_fd_sc_hd__diode_2
X_12009_ cell0.SB0.route_sel\[115\] cell0.SB0.route_sel\[114\] net765 vssd1 vssd1
+ vccd1 vccd1 _00446_ sky130_fd_sc_hd__mux2_1
XANTENNA__07518__A1 net336 vssd1 vssd1 vccd1 vccd1 sky130_fd_sc_hd__diode_2
X_07550_ net311 _02599_ _02590_ vssd1 vssd1 vccd1 vccd1 _02601_ sky130_fd_sc_hd__a21bo_1
XANTENNA__10825__A1 net22 vssd1 vssd1 vccd1 vccd1 sky130_fd_sc_hd__diode_2
X_06501_ cell0.CB_0.config_dataA\[7\] vssd1 vssd1 vccd1 vccd1 _01571_ sky130_fd_sc_hd__inv_2
XANTENNA__11262__X net193 vssd1 vssd1 vccd1 vccd1 sky130_fd_sc_hd__diode_2
X_07481_ net38 net307 _02532_ vssd1 vssd1 vccd1 vccd1 _02534_ sky130_fd_sc_hd__mux2_1
X_09220_ _04244_ _04246_ _01580_ _01581_ vssd1 vssd1 vccd1 vccd1 _04247_ sky130_fd_sc_hd__a211o_1
XTAP_TAPCELL_ROW_45_982 vssd1 vccd1 sky130_fd_sc_hd__tapvpwrvgnd_1
XFILLER_34_475 vssd1 vssd1 vccd1 vccd1 sky130_fd_sc_hd__fill_1
XTAP_TAPCELL_ROW_66_1298 vssd1 vccd1 sky130_fd_sc_hd__tapvpwrvgnd_1
X_06432_ cell1.SB0.route_sel\[8\] vssd1 vssd1 vccd1 vccd1 _01502_ sky130_fd_sc_hd__inv_2
X_09151_ bus3_2\[0\] _04177_ _04178_ vssd1 vssd1 vccd1 vccd1 _04179_ sky130_fd_sc_hd__a21o_1
XANTENNA_clkbuf_4_8_0_clk_A clknet_0_clk vssd1 vssd1 vccd1 vccd1 sky130_fd_sc_hd__diode_2
XANTENNA__10589__B1 cell3.SB0.route_sel\[69\] vssd1 vssd1 vccd1 vccd1 sky130_fd_sc_hd__diode_2
X_09082_ net479 _03881_ vssd1 vssd1 vccd1 vccd1 _04112_ sky130_fd_sc_hd__nand2_1
X_08102_ bus2_0\[8\] bus2_0\[9\] bus2_0\[10\] bus2_0\[11\] net525 net523 vssd1 vssd1
+ vccd1 vccd1 _03144_ sky130_fd_sc_hd__mux4_1
XANTENNA__11849__S net897 vssd1 vssd1 vccd1 vccd1 sky130_fd_sc_hd__diode_2
X_08033_ net533 _02894_ _03074_ net532 vssd1 vssd1 vccd1 vccd1 _03075_ sky130_fd_sc_hd__o211a_1
Xinput60 CBnorth_in[5] vssd1 vssd1 vccd1 vccd1 net60 sky130_fd_sc_hd__clkbuf_4
XANTENNA__09827__B _04724_ vssd1 vssd1 vccd1 vccd1 sky130_fd_sc_hd__diode_2
Xinput71 SBsouth_in[15] vssd1 vssd1 vccd1 vccd1 net71 sky130_fd_sc_hd__clkbuf_2
Xinput82 SBsouth_in[25] vssd1 vssd1 vccd1 vccd1 net82 sky130_fd_sc_hd__dlymetal6s2s_1
Xinput93 SBsouth_in[6] vssd1 vssd1 vccd1 vccd1 net93 sky130_fd_sc_hd__clkbuf_2
XANTENNA__07757__A1 _02799_ vssd1 vssd1 vccd1 vccd1 sky130_fd_sc_hd__diode_2
X_09984_ cell2.LEI0.config_data\[21\] net303 vssd1 vssd1 vccd1 vccd1 _04988_ sky130_fd_sc_hd__nand2_1
XFILLER_76_309 vccd1 vssd1 vccd1 vssd1 sky130_ef_sc_hd__decap_40_12
X_08935_ cell1.CB_0.config_dataA\[14\] _03940_ _03945_ _03966_ _01680_ vssd1 vssd1
+ vccd1 vccd1 _03967_ sky130_fd_sc_hd__a32o_1
XANTENNA__12048__B1_N _06377_ vssd1 vssd1 vccd1 vccd1 sky130_fd_sc_hd__diode_2
XANTENNA_fanout577_A net581 vssd1 vssd1 vccd1 vccd1 sky130_fd_sc_hd__diode_2
XANTENNA__08706__A0 _03517_ vssd1 vssd1 vccd1 vccd1 sky130_fd_sc_hd__diode_2
XANTENNA__07509__A1 _01932_ vssd1 vssd1 vccd1 vccd1 sky130_fd_sc_hd__diode_2
X_08866_ _03837_ _03855_ _03897_ cell1.CB_0.config_dataA\[9\] vssd1 vssd1 vccd1 vccd1
+ _03898_ sky130_fd_sc_hd__a211o_1
XFILLER_29_225 vssd1 vssd1 vccd1 vccd1 sky130_fd_sc_hd__fill_1
XANTENNA__10513__A0 _03489_ vssd1 vssd1 vccd1 vccd1 sky130_fd_sc_hd__diode_2
XFILLER_123_57 vssd1 vssd1 vccd1 vccd1 sky130_fd_sc_hd__fill_8
X_07817_ _01890_ _02153_ bus3_1\[5\] vssd1 vssd1 vccd1 vccd1 _02862_ sky130_fd_sc_hd__o21ai_1
XTAP_TAPCELL_ROW_4_368 vssd1 vccd1 sky130_fd_sc_hd__tapvpwrvgnd_1
XANTENNA__08721__A3 net3 vssd1 vssd1 vccd1 vccd1 sky130_fd_sc_hd__diode_2
X_08797_ _01540_ _01541_ cell1.SB0.route_sel\[103\] _01543_ _03828_ vssd1 vssd1 vccd1
+ vccd1 _03829_ sky130_fd_sc_hd__a221o_1
X_07748_ cell0.SB0.route_sel\[35\] cell0.SB0.route_sel\[34\] vssd1 vssd1 vccd1 vccd1
+ _02794_ sky130_fd_sc_hd__nand2_1
XFILLER_16_22 vssd1 vssd1 vccd1 vccd1 sky130_fd_sc_hd__fill_4
XFILLER_25_442 vssd1 vssd1 vccd1 vccd1 sky130_fd_sc_hd__fill_4
XANTENNA__08906__B _03881_ vssd1 vssd1 vccd1 vccd1 sky130_fd_sc_hd__diode_2
XFILLER_13_626 vssd1 vssd1 vccd1 vccd1 sky130_fd_sc_hd__fill_1
X_07679_ _01841_ _02640_ vssd1 vssd1 vccd1 vccd1 _02727_ sky130_fd_sc_hd__nor2_1
XANTENNA__08485__A2 net23 vssd1 vssd1 vccd1 vccd1 sky130_fd_sc_hd__diode_2
X_09418_ _04428_ _04440_ net551 vssd1 vssd1 vccd1 vccd1 _04441_ sky130_fd_sc_hd__o21ai_1
X_10690_ net17 net18 net19 net20 cell3.CB_1.config_dataA\[15\] net390 vssd1 vssd1
+ vccd1 vccd1 _05648_ sky130_fd_sc_hd__mux4_1
XFILLER_12_136 vssd1 vssd1 vccd1 vccd1 sky130_fd_sc_hd__fill_2
XFILLER_13_648 vccd1 vssd1 vccd1 vssd1 sky130_ef_sc_hd__decap_40_12
X_09349_ _04373_ _04371_ vssd1 vssd1 vccd1 vccd1 bus3_1\[3\] sky130_fd_sc_hd__and2b_2
XFILLER_40_456 vssd1 vssd1 vccd1 vccd1 sky130_fd_sc_hd__fill_1
XTAP_TAPCELL_ROW_23_654 vssd1 vccd1 sky130_fd_sc_hd__tapvpwrvgnd_1
XFILLER_32_10 vccd1 vssd1 vccd1 vssd1 sky130_ef_sc_hd__decap_40_12
XFILLER_139_845 vssd1 vssd1 vccd1 vccd1 sky130_fd_sc_hd__fill_1
X_12360_ cell1.SB0.route_sel\[98\] cell1.SB0.route_sel\[97\] net887 vssd1 vssd1 vccd1
+ vccd1 _00793_ sky130_fd_sc_hd__mux2_1
XANTENNA__09985__A2 net316 vssd1 vssd1 vccd1 vccd1 sky130_fd_sc_hd__diode_2
X_11311_ net295 _04538_ _04539_ _06220_ vssd1 vssd1 vccd1 vccd1 net150 sky130_fd_sc_hd__a22o_1
XANTENNA__08481__X _03517_ vssd1 vssd1 vccd1 vccd1 sky130_fd_sc_hd__diode_2
XTAP_TAPCELL_ROW_97_1759 vssd1 vccd1 sky130_fd_sc_hd__tapvpwrvgnd_1
X_12291_ cell1.SB0.route_sel\[29\] cell1.SB0.route_sel\[28\] net857 vssd1 vssd1 vccd1
+ vccd1 _00724_ sky130_fd_sc_hd__mux2_1
X_11242_ cell3.LE_0B.config_data\[16\] _06191_ _06192_ net352 vssd1 vssd1 vccd1 vccd1
+ cell3.CB_0.le_outB sky130_fd_sc_hd__o211a_1
X_14030_ clknet_leaf_46_clk _01002_ net701 vssd1 vssd1 vccd1 vccd1 cell3.SB0.route_sel\[38\]
+ sky130_fd_sc_hd__dfstp_1
X_11173_ cell3.CB_0.config_dataB\[13\] cell3.CB_0.config_dataB\[12\] vssd1 vssd1 vccd1
+ vccd1 _06125_ sky130_fd_sc_hd__nor2_1
XFILLER_122_734 vssd1 vssd1 vccd1 vccd1 sky130_fd_sc_hd__fill_1
XANTENNA_input40_A CBnorth_in[16] vssd1 vssd1 vccd1 vccd1 sky130_fd_sc_hd__diode_2
X_10124_ net417 _05123_ _05124_ vssd1 vssd1 vccd1 vccd1 _05125_ sky130_fd_sc_hd__a21oi_1
XANTENNA__10752__A0 net15 vssd1 vssd1 vccd1 vccd1 sky130_fd_sc_hd__diode_2
XTAP_TAPCELL_ROW_128_2225 vssd1 vccd1 sky130_fd_sc_hd__tapvpwrvgnd_1
XANTENNA__08960__A3 bus3_1\[11\] vssd1 vssd1 vccd1 vccd1 sky130_fd_sc_hd__diode_2
XFILLER_102_491 vssd1 vssd1 vccd1 vccd1 sky130_fd_sc_hd__fill_1
X_10055_ _05058_ vssd1 vssd1 vccd1 vccd1 _05059_ sky130_fd_sc_hd__inv_2
XTAP_TAPCELL_ROW_50_1055 vssd1 vccd1 sky130_fd_sc_hd__tapvpwrvgnd_1
XTAP_TAPCELL_ROW_141_2425 vssd1 vccd1 sky130_fd_sc_hd__tapvpwrvgnd_1
XFILLER_91_824 vssd1 vssd1 vccd1 vccd1 sky130_fd_sc_hd__fill_1
XFILLER_35_228 vssd1 vssd1 vccd1 vccd1 sky130_fd_sc_hd__fill_1
X_13814_ clknet_leaf_113_clk _00786_ net662 vssd1 vssd1 vccd1 vccd1 cell1.SB0.route_sel\[91\]
+ sky130_fd_sc_hd__dfstp_1
XFILLER_28_280 vssd1 vssd1 vccd1 vccd1 sky130_fd_sc_hd__fill_1
X_10957_ cell3.SB0.route_sel\[19\] cell3.SB0.route_sel\[18\] cell3.SB0.route_sel\[22\]
+ _01692_ _05910_ vssd1 vssd1 vccd1 vccd1 _05911_ sky130_fd_sc_hd__o221a_1
X_13745_ clknet_leaf_106_clk _00717_ net658 vssd1 vssd1 vccd1 vccd1 cell1.SB0.route_sel\[22\]
+ sky130_fd_sc_hd__dfstp_1
X_13676_ clknet_leaf_30_clk _00648_ net620 vssd1 vssd1 vccd1 vccd1 cell2.CB_0.config_dataB\[3\]
+ sky130_fd_sc_hd__dfstp_1
XTAP_TAPCELL_ROW_106_1899 vssd1 vccd1 sky130_fd_sc_hd__tapvpwrvgnd_1
XTAP_TAPCELL_ROW_42_941 vssd1 vccd1 sky130_fd_sc_hd__tapvpwrvgnd_1
X_10888_ cell3.LE_1B.dff0_out cell3.LE_1B.dff1_out cell3.LE_1B.reset_val vssd1 vssd1
+ vccd1 vccd1 cell3.LE_1B.dff_out sky130_fd_sc_hd__mux2_1
X_12627_ cell3.SB0.route_sel\[92\] cell3.SB0.route_sel\[91\] net918 vssd1 vssd1 vccd1
+ vccd1 _01056_ sky130_fd_sc_hd__mux2_1
XTAP_TAPCELL_ROW_139_2398 vssd1 vccd1 sky130_fd_sc_hd__tapvpwrvgnd_1
XTAP_TAPCELL_ROW_139_2387 vssd1 vccd1 sky130_fd_sc_hd__tapvpwrvgnd_1
XANTENNA__09425__A1 net318 vssd1 vssd1 vccd1 vccd1 sky130_fd_sc_hd__diode_2
X_12558_ cell3.SB0.route_sel\[23\] cell3.SB0.route_sel\[22\] net917 vssd1 vssd1 vccd1
+ vccd1 _00987_ sky130_fd_sc_hd__mux2_1
XFILLER_8_641 vssd1 vssd1 vccd1 vccd1 sky130_fd_sc_hd__fill_2
XFILLER_11_180 vssd1 vssd1 vccd1 vccd1 sky130_fd_sc_hd__fill_1
XANTENNA__10991__A0 _05893_ vssd1 vssd1 vccd1 vccd1 sky130_fd_sc_hd__diode_2
X_12489_ net1516 cell2.LEI0.config_data\[2\] net840 vssd1 vssd1 vccd1 vccd1 _00918_
+ sky130_fd_sc_hd__mux2_1
X_11509_ cell2.SB0.route_sel\[56\] cell2.SB0.route_sel\[57\] cell2.SB0.route_sel\[60\]
+ _01619_ _06339_ vssd1 vssd1 vccd1 vccd1 _06340_ sky130_fd_sc_hd__o221a_1
Xhold107 cell0.LEI0.config_data\[17\] vssd1 vssd1 vccd1 vccd1 net1066 sky130_fd_sc_hd__dlygate4sd3_1
Xhold118 _00903_ vssd1 vssd1 vccd1 vccd1 net1077 sky130_fd_sc_hd__dlygate4sd3_1
X_14228_ clknet_leaf_12_clk _01200_ net588 vssd1 vssd1 vccd1 vccd1 cell2.SB0.route_sel\[13\]
+ sky130_fd_sc_hd__dfstp_1
Xhold129 cell0.LE_1A.config_data\[16\] vssd1 vssd1 vccd1 vccd1 net1088 sky130_fd_sc_hd__dlygate4sd3_1
XANTENNA__07448__A net6 vssd1 vssd1 vccd1 vccd1 sky130_fd_sc_hd__diode_2
XANTENNA__14342__Q cell2.SB0.config_data_out vssd1 vssd1 vccd1 vccd1 sky130_fd_sc_hd__diode_2
XFILLER_140_531 vssd1 vssd1 vccd1 vccd1 sky130_fd_sc_hd__fill_1
Xfanout609 net623 vssd1 vssd1 vccd1 vccd1 net609 sky130_fd_sc_hd__clkbuf_2
XANTENNA__10743__A0 _05540_ vssd1 vssd1 vccd1 vccd1 sky130_fd_sc_hd__diode_2
X_14159_ clknet_leaf_72_clk _01131_ net733 vssd1 vssd1 vccd1 vccd1 cell3.CB_1.config_dataA\[19\]
+ sky130_fd_sc_hd__dfstp_1
XANTENNA__08978__S _03968_ vssd1 vssd1 vccd1 vccd1 sky130_fd_sc_hd__diode_2
XFILLER_3_390 vssd1 vssd1 vccd1 vccd1 sky130_fd_sc_hd__fill_2
X_06981_ net450 net449 vssd1 vssd1 vccd1 vccd1 _02047_ sky130_fd_sc_hd__nand2b_2
XFILLER_100_428 vssd1 vssd1 vccd1 vccd1 sky130_fd_sc_hd__fill_1
X_08720_ _03752_ _03753_ vssd1 vssd1 vccd1 vccd1 _03754_ sky130_fd_sc_hd__nor2_1
XFILLER_94_662 vssd1 vssd1 vccd1 vccd1 sky130_fd_sc_hd__fill_4
XTAP_TAPCELL_ROW_1_316 vssd1 vccd1 sky130_fd_sc_hd__tapvpwrvgnd_1
XANTENNA__08164__A1 _02807_ vssd1 vssd1 vccd1 vccd1 sky130_fd_sc_hd__diode_2
XANTENNA__08164__B2 _02846_ vssd1 vssd1 vccd1 vccd1 sky130_fd_sc_hd__diode_2
XANTENNA__11417__B _02346_ vssd1 vssd1 vccd1 vccd1 sky130_fd_sc_hd__diode_2
X_08651_ net458 _03468_ vssd1 vssd1 vccd1 vccd1 _03685_ sky130_fd_sc_hd__nand2_1
XTAP_TAPCELL_ROW_68_1327 vssd1 vccd1 sky130_fd_sc_hd__tapvpwrvgnd_1
X_07602_ _01831_ _02062_ _02650_ _02646_ _02057_ vssd1 vssd1 vccd1 vccd1 _02652_ sky130_fd_sc_hd__o32a_1
XTAP_TAPCELL_ROW_1_327 vssd1 vccd1 sky130_fd_sc_hd__tapvpwrvgnd_1
X_08582_ _03614_ _03616_ _03617_ vssd1 vssd1 vccd1 vccd1 _03618_ sky130_fd_sc_hd__and3_1
XTAP_TAPCELL_ROW_81_1516 vssd1 vccd1 sky130_fd_sc_hd__tapvpwrvgnd_1
X_07533_ cell0.SB0.route_sel\[125\] _01488_ cell0.SB0.route_sel\[123\] cell0.SB0.route_sel\[122\]
+ _02583_ vssd1 vssd1 vccd1 vccd1 _02584_ sky130_fd_sc_hd__o221a_1
XTAP_TAPCELL_ROW_81_1527 vssd1 vccd1 sky130_fd_sc_hd__tapvpwrvgnd_1
X_07464_ _02515_ _02517_ vssd1 vssd1 vccd1 vccd1 bus1_0\[14\] sky130_fd_sc_hd__nor2_2
X_09203_ cell3.CB_1.config_dataA\[24\] cell3.CB_1.config_dataA\[21\] cell3.CB_1.config_dataA\[20\]
+ vssd1 vssd1 vccd1 vccd1 _04230_ sky130_fd_sc_hd__or3b_1
X_06415_ cell0.SB0.route_sel\[119\] vssd1 vssd1 vccd1 vccd1 _01485_ sky130_fd_sc_hd__inv_2
X_07395_ net302 _02448_ _02447_ vssd1 vssd1 vccd1 vccd1 _02450_ sky130_fd_sc_hd__o21ba_1
X_09134_ cell1.LE_0B.config_data\[13\] cell1.LE_0B.config_data\[12\] _04086_ vssd1
+ vssd1 vccd1 vccd1 _04164_ sky130_fd_sc_hd__mux2_1
XTAP_TAPCELL_ROW_20_602 vssd1 vccd1 sky130_fd_sc_hd__tapvpwrvgnd_1
XTAP_TAPCELL_ROW_20_613 vssd1 vccd1 sky130_fd_sc_hd__tapvpwrvgnd_1
XANTENNA__10577__A3 net25 vssd1 vssd1 vccd1 vccd1 sky130_fd_sc_hd__diode_2
X_09065_ _04093_ _04094_ _01671_ vssd1 vssd1 vccd1 vccd1 _04095_ sky130_fd_sc_hd__mux2_1
XTAP_TAPCELL_ROW_79_1489 vssd1 vccd1 sky130_fd_sc_hd__tapvpwrvgnd_1
X_08016_ net533 _02301_ vssd1 vssd1 vccd1 vccd1 _03058_ sky130_fd_sc_hd__nand2_1
XFILLER_104_701 vssd1 vssd1 vccd1 vccd1 sky130_fd_sc_hd__fill_1
XANTENNA__08927__A0 bus3_1\[12\] vssd1 vssd1 vccd1 vccd1 sky130_fd_sc_hd__diode_2
XTAP_TAPCELL_ROW_9_449 vssd1 vccd1 sky130_fd_sc_hd__tapvpwrvgnd_1
XTAP_TAPCELL_ROW_9_438 vssd1 vccd1 sky130_fd_sc_hd__tapvpwrvgnd_1
XFILLER_1_305 vccd1 vssd1 vccd1 vssd1 sky130_ef_sc_hd__decap_40_12
XFILLER_1_349 vccd1 vssd1 vccd1 vssd1 sky130_ef_sc_hd__decap_40_12
X_09967_ _04197_ _04957_ _04958_ _04260_ cell2.CB_1.config_dataB\[7\] vssd1 vssd1
+ vccd1 vccd1 _04971_ sky130_fd_sc_hd__a221o_1
XTAP_TAPCELL_ROW_92_1689 vssd1 vccd1 sky130_fd_sc_hd__tapvpwrvgnd_1
XANTENNA_fanout959_A net130 vssd1 vssd1 vccd1 vccd1 sky130_fd_sc_hd__diode_2
XFILLER_103_277 vssd1 vssd1 vccd1 vccd1 sky130_fd_sc_hd__fill_1
XFILLER_94_27 vssd1 vssd1 vccd1 vccd1 sky130_fd_sc_hd__fill_1
X_08918_ net467 _03862_ vssd1 vssd1 vccd1 vccd1 _03950_ sky130_fd_sc_hd__nand2_1
XANTENNA__06953__A2 net357 vssd1 vssd1 vccd1 vccd1 sky130_fd_sc_hd__diode_2
X_09898_ cell2.LEI0.config_data\[42\] net304 vssd1 vssd1 vccd1 vccd1 _04904_ sky130_fd_sc_hd__nand2_1
XFILLER_84_150 vssd1 vssd1 vccd1 vccd1 sky130_fd_sc_hd__fill_2
X_08849_ _01979_ _03880_ vssd1 vssd1 vccd1 vccd1 _03881_ sky130_fd_sc_hd__and2_2
XFILLER_18_729 vssd1 vssd1 vccd1 vccd1 sky130_fd_sc_hd__fill_1
XTAP_TAPCELL_ROW_28_724 vssd1 vccd1 sky130_fd_sc_hd__tapvpwrvgnd_1
XTAP_TAPCELL_ROW_123_2155 vssd1 vccd1 sky130_fd_sc_hd__tapvpwrvgnd_1
X_11860_ net475 net477 net897 vssd1 vssd1 vccd1 vccd1 _00297_ sky130_fd_sc_hd__mux2_1
XFILLER_45_559 vssd1 vssd1 vccd1 vccd1 sky130_fd_sc_hd__fill_1
XTAP_TAPCELL_ROW_28_735 vssd1 vccd1 sky130_fd_sc_hd__tapvpwrvgnd_1
X_10811_ net15 net16 cell3.CB_1.config_dataB\[10\] vssd1 vssd1 vccd1 vccd1 _05767_
+ sky130_fd_sc_hd__mux2_1
X_11791_ cell0.LEI0.config_data\[41\] net1120 net776 vssd1 vssd1 vccd1 vccd1 _00228_
+ sky130_fd_sc_hd__mux2_1
X_10742_ _01777_ _05695_ _05697_ vssd1 vssd1 vccd1 vccd1 _05698_ sky130_fd_sc_hd__a21oi_1
X_13530_ clknet_leaf_92_clk _00502_ net696 vssd1 vssd1 vccd1 vccd1 cell1.LE_1A.edge_mode
+ sky130_fd_sc_hd__dfstp_1
X_10673_ net297 net290 cell3.LEI0.config_data\[30\] vssd1 vssd1 vccd1 vccd1 _05631_
+ sky130_fd_sc_hd__mux2_1
XANTENNA__09407__A1 net317 vssd1 vssd1 vccd1 vccd1 sky130_fd_sc_hd__diode_2
XFILLER_9_449 vssd1 vssd1 vccd1 vccd1 sky130_fd_sc_hd__fill_2
X_13461_ clknet_leaf_2_clk _00433_ net562 vssd1 vssd1 vccd1 vccd1 cell0.SB0.route_sel\[102\]
+ sky130_fd_sc_hd__dfstp_1
X_12412_ cell2.CB_1.config_dataB\[22\] cell2.CB_1.config_dataB\[21\] net830 vssd1
+ vssd1 vccd1 vccd1 _00845_ sky130_fd_sc_hd__mux2_1
XANTENNA_input88_A SBsouth_in[30] vssd1 vssd1 vccd1 vccd1 sky130_fd_sc_hd__diode_2
X_13392_ clknet_leaf_1_clk _00364_ net560 vssd1 vssd1 vccd1 vccd1 cell0.SB0.route_sel\[33\]
+ sky130_fd_sc_hd__dfstp_1
XANTENNA__08091__A0 bus2_0\[6\] vssd1 vssd1 vccd1 vccd1 sky130_fd_sc_hd__diode_2
XFILLER_5_611 vssd1 vssd1 vccd1 vccd1 sky130_fd_sc_hd__fill_4
X_12343_ cell1.SB0.route_sel\[81\] cell1.SB0.route_sel\[80\] net861 vssd1 vssd1 vccd1
+ vccd1 _00776_ sky130_fd_sc_hd__mux2_1
X_12274_ cell1.SB0.route_sel\[12\] cell1.SB0.route_sel\[11\] net866 vssd1 vssd1 vccd1
+ vccd1 _00707_ sky130_fd_sc_hd__mux2_1
XFILLER_4_121 vccd1 vssd1 vccd1 vssd1 sky130_ef_sc_hd__decap_40_12
X_11225_ cell3.LE_0B.config_data\[12\] cell3.LE_0B.config_data\[13\] _06076_ vssd1
+ vssd1 vccd1 vccd1 _06177_ sky130_fd_sc_hd__mux2_1
XFILLER_107_550 vssd1 vssd1 vccd1 vccd1 sky130_fd_sc_hd__fill_1
X_14013_ clknet_leaf_84_clk _00985_ net707 vssd1 vssd1 vccd1 vccd1 cell3.SB0.route_sel\[21\]
+ sky130_fd_sc_hd__dfstp_2
XFILLER_4_165 vccd1 vssd1 vccd1 vssd1 sky130_ef_sc_hd__decap_40_12
XFILLER_4_143 vssd1 vssd1 vccd1 vccd1 sky130_fd_sc_hd__fill_1
XANTENNA_input43_X net43 vssd1 vssd1 vccd1 vccd1 sky130_fd_sc_hd__diode_2
X_11156_ net385 net384 vssd1 vssd1 vccd1 vccd1 _06108_ sky130_fd_sc_hd__nor2_1
XANTENNA_output244_A net244 vssd1 vssd1 vccd1 vccd1 sky130_fd_sc_hd__diode_2
XANTENNA__07555__X bus2_0\[15\] vssd1 vssd1 vccd1 vccd1 sky130_fd_sc_hd__diode_2
X_11087_ _05994_ _06036_ _06026_ vssd1 vssd1 vccd1 vccd1 _06041_ sky130_fd_sc_hd__o21bai_1
X_10107_ net418 _05107_ _05104_ cell2.CB_0.config_dataA\[6\] vssd1 vssd1 vccd1 vccd1
+ _05108_ sky130_fd_sc_hd__o211a_1
XANTENNA__10740__A3 net25 vssd1 vssd1 vccd1 vccd1 sky130_fd_sc_hd__diode_2
X_10038_ _04671_ _05035_ _05041_ _01751_ vssd1 vssd1 vccd1 vccd1 _05042_ sky130_fd_sc_hd__a211o_1
XFILLER_0_393 vssd1 vssd1 vccd1 vccd1 sky130_fd_sc_hd__fill_1
XTAP_TAPCELL_ROW_108_1928 vssd1 vccd1 sky130_fd_sc_hd__tapvpwrvgnd_1
XFILLER_36_515 vssd1 vssd1 vccd1 vccd1 sky130_fd_sc_hd__fill_4
XFILLER_91_698 vssd1 vssd1 vccd1 vccd1 sky130_fd_sc_hd__fill_1
XFILLER_84_93 vssd1 vssd1 vccd1 vccd1 sky130_fd_sc_hd__fill_2
X_13728_ clknet_leaf_102_clk _00700_ net660 vssd1 vssd1 vccd1 vccd1 cell1.SB0.route_sel\[5\]
+ sky130_fd_sc_hd__dfstp_1
X_11989_ cell0.SB0.route_sel\[95\] cell0.SB0.route_sel\[94\] net785 vssd1 vssd1 vccd1
+ vccd1 _00426_ sky130_fd_sc_hd__mux2_1
XANTENNA_clkbuf_leaf_50_clk_A clknet_4_12_0_clk vssd1 vssd1 vccd1 vccd1 sky130_fd_sc_hd__diode_2
XTAP_TAPCELL_ROW_63_1257 vssd1 vccd1 sky130_fd_sc_hd__tapvpwrvgnd_1
XTAP_TAPCELL_ROW_63_1246 vssd1 vccd1 sky130_fd_sc_hd__tapvpwrvgnd_1
X_13659_ clknet_leaf_48_clk _00631_ net704 vssd1 vssd1 vccd1 vccd1 cell2.CB_1.config_dataA\[11\]
+ sky130_fd_sc_hd__dfstp_1
XFILLER_83_3 vccd1 vssd1 vccd1 vssd1 sky130_ef_sc_hd__decap_40_12
XANTENNA__11540__X net230 vssd1 vssd1 vccd1 vccd1 sky130_fd_sc_hd__diode_2
XPHY_EDGE_ROW_140_Right_140 vssd1 vssd1 vccd1 vccd1 sky130_fd_sc_hd__decap_3
XANTENNA__11205__A1 net40 vssd1 vssd1 vccd1 vccd1 sky130_fd_sc_hd__diode_2
XANTENNA__11205__B2 net41 vssd1 vssd1 vccd1 vccd1 sky130_fd_sc_hd__diode_2
XFILLER_118_815 vssd1 vssd1 vccd1 vccd1 sky130_fd_sc_hd__fill_1
X_07180_ _01904_ _02084_ bus3_2\[10\] vssd1 vssd1 vccd1 vccd1 _02241_ sky130_fd_sc_hd__o21ai_1
XANTENNA_clkbuf_leaf_65_clk_A clknet_4_15_0_clk vssd1 vssd1 vccd1 vccd1 sky130_fd_sc_hd__diode_2
XANTENNA__08385__A1 _02422_ vssd1 vssd1 vccd1 vccd1 sky130_fd_sc_hd__diode_2
Xfanout428 cell2.CB_0.config_dataB\[10\] vssd1 vssd1 vccd1 vccd1 net428 sky130_fd_sc_hd__buf_2
X_09821_ cell2.LEI0.config_data\[6\] net303 vssd1 vssd1 vccd1 vccd1 _04827_ sky130_fd_sc_hd__nand2_1
Xfanout417 cell2.CB_0.config_dataA\[6\] vssd1 vssd1 vccd1 vccd1 net417 sky130_fd_sc_hd__clkbuf_2
XANTENNA_clkload12_A clknet_4_13_0_clk vssd1 vssd1 vccd1 vccd1 sky130_fd_sc_hd__diode_2
Xfanout406 net407 vssd1 vssd1 vccd1 vccd1 net406 sky130_fd_sc_hd__buf_2
XFILLER_101_704 vssd1 vssd1 vccd1 vccd1 sky130_fd_sc_hd__fill_1
XFILLER_98_253 vssd1 vssd1 vccd1 vccd1 sky130_fd_sc_hd__fill_8
Xfanout439 cell2.CB_1.config_dataA\[15\] vssd1 vssd1 vccd1 vccd1 net439 sky130_fd_sc_hd__buf_2
X_09752_ net444 net443 vssd1 vssd1 vccd1 vccd1 _04758_ sky130_fd_sc_hd__nor2_1
XANTENNA_clkbuf_leaf_123_clk_A clknet_4_2_0_clk vssd1 vssd1 vccd1 vccd1 sky130_fd_sc_hd__diode_2
X_06964_ cell0.CB_0.config_dataB\[24\] cell0.CB_0.config_dataB\[20\] cell0.CB_0.config_dataB\[21\]
+ vssd1 vssd1 vccd1 vccd1 _02030_ sky130_fd_sc_hd__nor3_1
X_08703_ net454 net456 vssd1 vssd1 vccd1 vccd1 _03737_ sky130_fd_sc_hd__nor2_1
X_09683_ _02519_ _02538_ _04695_ _02520_ vssd1 vssd1 vccd1 vccd1 _04697_ sky130_fd_sc_hd__a31o_1
XANTENNA__09885__A1 bus3_2\[2\] vssd1 vssd1 vccd1 vccd1 sky130_fd_sc_hd__diode_2
X_06895_ _01838_ _01962_ vssd1 vssd1 vccd1 vccd1 _01963_ sky130_fd_sc_hd__nand2b_1
XFILLER_27_526 vssd1 vssd1 vccd1 vccd1 sky130_fd_sc_hd__fill_8
XANTENNA__07896__A0 bus2_0\[12\] vssd1 vssd1 vccd1 vccd1 sky130_fd_sc_hd__diode_2
X_08634_ net458 _03529_ vssd1 vssd1 vccd1 vccd1 _03668_ sky130_fd_sc_hd__nand2_1
XFILLER_81_164 vssd1 vssd1 vccd1 vccd1 sky130_fd_sc_hd__fill_4
X_08565_ net491 _03489_ vssd1 vssd1 vccd1 vccd1 _03601_ sky130_fd_sc_hd__nand2_1
XFILLER_120_25 vssd1 vssd1 vccd1 vccd1 sky130_fd_sc_hd__fill_2
XANTENNA__10247__A2 net55 vssd1 vssd1 vccd1 vccd1 sky130_fd_sc_hd__diode_2
XANTENNA__09101__A3 bus3_1\[3\] vssd1 vssd1 vccd1 vccd1 sky130_fd_sc_hd__diode_2
XANTENNA__07648__B1 _02696_ vssd1 vssd1 vccd1 vccd1 sky130_fd_sc_hd__diode_2
X_07516_ _01964_ _02358_ vssd1 vssd1 vccd1 vccd1 _02568_ sky130_fd_sc_hd__nor2_1
XANTENNA_clkbuf_leaf_18_clk_A clknet_4_4_0_clk vssd1 vssd1 vccd1 vccd1 sky130_fd_sc_hd__diode_2
X_08496_ cell1.SB0.route_sel\[53\] cell1.SB0.route_sel\[52\] _01520_ cell1.SB0.route_sel\[55\]
+ _03531_ vssd1 vssd1 vccd1 vccd1 _03532_ sky130_fd_sc_hd__o221a_1
XANTENNA__11450__X net208 vssd1 vssd1 vccd1 vccd1 sky130_fd_sc_hd__diode_2
XFILLER_10_404 vssd1 vssd1 vccd1 vccd1 sky130_fd_sc_hd__fill_4
X_07447_ _01837_ _02356_ vssd1 vssd1 vccd1 vccd1 _02501_ sky130_fd_sc_hd__nor2_1
X_07378_ net5 net322 _02432_ vssd1 vssd1 vccd1 vccd1 _02434_ sky130_fd_sc_hd__mux2_1
XFILLER_136_634 vssd1 vssd1 vccd1 vccd1 sky130_fd_sc_hd__fill_1
XFILLER_135_111 vssd1 vssd1 vccd1 vccd1 sky130_fd_sc_hd__fill_1
XANTENNA__11747__A2 net548 vssd1 vssd1 vccd1 vccd1 sky130_fd_sc_hd__diode_2
X_09117_ _03825_ _04130_ cell1.CB_0.config_dataB\[17\] vssd1 vssd1 vccd1 vccd1 _04147_
+ sky130_fd_sc_hd__o21ai_1
XTAP_TAPCELL_ROW_94_1718 vssd1 vccd1 sky130_fd_sc_hd__tapvpwrvgnd_1
X_09048_ _04068_ _04069_ _04073_ _04077_ vssd1 vssd1 vccd1 vccd1 _04078_ sky130_fd_sc_hd__o211a_1
Xhold471 cell2.LE_0B.config_data\[0\] vssd1 vssd1 vccd1 vccd1 net1430 sky130_fd_sc_hd__dlygate4sd3_1
XANTENNA__10707__A0 _05501_ vssd1 vssd1 vccd1 vccd1 sky130_fd_sc_hd__diode_2
XFILLER_89_220 vssd1 vssd1 vccd1 vccd1 sky130_fd_sc_hd__fill_1
Xhold460 cell0.LEI0.config_data\[34\] vssd1 vssd1 vccd1 vccd1 net1419 sky130_fd_sc_hd__dlygate4sd3_1
XFILLER_2_625 vccd1 vssd1 vccd1 vssd1 sky130_ef_sc_hd__decap_40_12
XFILLER_1_113 vccd1 vssd1 vccd1 vssd1 sky130_ef_sc_hd__decap_40_12
X_11010_ net375 net374 vssd1 vssd1 vccd1 vccd1 _05964_ sky130_fd_sc_hd__or2_1
XANTENNA__10183__A1 net319 vssd1 vssd1 vccd1 vccd1 sky130_fd_sc_hd__diode_2
Xhold493 cell1.LE_1A.dff1_out vssd1 vssd1 vccd1 vccd1 net1452 sky130_fd_sc_hd__dlygate4sd3_1
Xhold482 cell0.LEI0.config_data\[26\] vssd1 vssd1 vccd1 vccd1 net1441 sky130_fd_sc_hd__dlygate4sd3_1
XFILLER_2_669 vccd1 vssd1 vccd1 vssd1 sky130_ef_sc_hd__decap_40_12
Xfanout951 net952 vssd1 vssd1 vccd1 vccd1 net951 sky130_fd_sc_hd__clkbuf_4
Xfanout940 net944 vssd1 vssd1 vccd1 vccd1 net940 sky130_fd_sc_hd__clkbuf_4
XFILLER_38_20 vssd1 vssd1 vccd1 vccd1 sky130_fd_sc_hd__fill_8
XFILLER_38_53 vssd1 vssd1 vccd1 vccd1 sky130_fd_sc_hd__fill_8
XANTENNA__11132__A0 net49 vssd1 vssd1 vccd1 vccd1 sky130_fd_sc_hd__diode_2
X_12961_ net1134 cell3.LE_0A.config_data\[3\] net927 vssd1 vssd1 vccd1 vccd1 _01389_
+ sky130_fd_sc_hd__mux2_1
XANTENNA__08679__A2 net6 vssd1 vssd1 vccd1 vccd1 sky130_fd_sc_hd__diode_2
X_12892_ cell3.CB_1.config_dataB\[6\] net369 net947 vssd1 vssd1 vccd1 vccd1 _01321_
+ sky130_fd_sc_hd__mux2_1
XANTENNA__07887__A0 bus2_0\[0\] vssd1 vssd1 vccd1 vccd1 sky130_fd_sc_hd__diode_2
XFILLER_18_537 vssd1 vssd1 vccd1 vccd1 sky130_fd_sc_hd__fill_1
XFILLER_18_559 vssd1 vssd1 vccd1 vccd1 sky130_fd_sc_hd__fill_4
X_11912_ cell0.SB0.route_sel\[18\] cell0.SB0.route_sel\[17\] net762 vssd1 vssd1 vccd1
+ vccd1 _00349_ sky130_fd_sc_hd__mux2_1
X_11843_ cell1.CB_1.config_dataA\[24\] cell1.CB_1.config_dataA\[23\] net886 vssd1
+ vssd1 vccd1 vccd1 _00280_ sky130_fd_sc_hd__mux2_1
XANTENNA__07351__A2 net355 vssd1 vssd1 vccd1 vccd1 sky130_fd_sc_hd__diode_2
XANTENNA__09628__A1 net318 vssd1 vssd1 vccd1 vccd1 sky130_fd_sc_hd__diode_2
XTAP_TAPCELL_ROW_103_1858 vssd1 vccd1 sky130_fd_sc_hd__tapvpwrvgnd_1
XTAP_TAPCELL_ROW_103_1847 vssd1 vccd1 sky130_fd_sc_hd__tapvpwrvgnd_1
X_11774_ cell0.LEI0.config_data\[24\] net1226 net791 vssd1 vssd1 vccd1 vccd1 _00211_
+ sky130_fd_sc_hd__mux2_1
XFILLER_41_551 vssd1 vssd1 vccd1 vccd1 sky130_fd_sc_hd__fill_1
X_10725_ cell3.LE_1A.config_data\[8\] cell3.LE_1A.config_data\[9\] _05600_ vssd1 vssd1
+ vccd1 vccd1 _05683_ sky130_fd_sc_hd__mux2_1
X_13513_ clknet_leaf_99_clk _00485_ net681 vssd1 vssd1 vccd1 vccd1 cell1.LE_1A.config_data\[0\]
+ sky130_fd_sc_hd__dfrtp_1
XTAP_TAPCELL_ROW_136_2346 vssd1 vccd1 sky130_fd_sc_hd__tapvpwrvgnd_1
X_10656_ _05608_ _05613_ _05612_ cell3.CB_1.config_dataA\[13\] _05605_ vssd1 vssd1
+ vccd1 vccd1 _05614_ sky130_fd_sc_hd__o2111a_1
Xclkbuf_1_1__f_cell0.LE_1A.sel_clk clknet_0_cell0.LE_1A.sel_clk vssd1 vssd1 vccd1
+ vccd1 clknet_1_1__leaf_cell0.LE_1A.sel_clk sky130_fd_sc_hd__clkbuf_16
XFILLER_9_235 vssd1 vssd1 vccd1 vccd1 sky130_fd_sc_hd__fill_2
X_13444_ clknet_leaf_129_clk _00416_ net578 vssd1 vssd1 vccd1 vccd1 cell0.SB0.route_sel\[85\]
+ sky130_fd_sc_hd__dfstp_2
XANTENNA_output194_A net194 vssd1 vssd1 vccd1 vccd1 sky130_fd_sc_hd__diode_2
Xclkload16 clknet_leaf_2_clk vssd1 vssd1 vccd1 vccd1 clkload16/X sky130_fd_sc_hd__clkbuf_4
XANTENNA__07269__Y _02327_ vssd1 vssd1 vccd1 vccd1 sky130_fd_sc_hd__diode_2
Xclkload49 clknet_leaf_26_clk vssd1 vssd1 vccd1 vccd1 clkload49/Y sky130_fd_sc_hd__clkinv_1
X_10587_ _04617_ _04623_ _04630_ _05542_ _01788_ vssd1 vssd1 vccd1 vccd1 _05545_ sky130_fd_sc_hd__a2111o_1
Xclkload38 clknet_leaf_14_clk vssd1 vssd1 vccd1 vccd1 clkload38/Y sky130_fd_sc_hd__inv_8
Xclkload27 clknet_leaf_9_clk vssd1 vssd1 vccd1 vccd1 clkload27/Y sky130_fd_sc_hd__inv_6
XANTENNA__09261__C1 _02711_ vssd1 vssd1 vccd1 vccd1 sky130_fd_sc_hd__diode_2
X_13375_ clknet_leaf_132_clk _00347_ net558 vssd1 vssd1 vccd1 vccd1 cell0.SB0.route_sel\[16\]
+ sky130_fd_sc_hd__dfstp_2
XTAP_TAPCELL_ROW_11_476 vssd1 vccd1 sky130_fd_sc_hd__tapvpwrvgnd_1
XANTENNA__08603__A2 _03465_ vssd1 vssd1 vccd1 vccd1 sky130_fd_sc_hd__diode_2
X_12326_ cell1.SB0.route_sel\[64\] cell1.SB0.route_sel\[63\] net867 vssd1 vssd1 vccd1
+ vccd1 _00759_ sky130_fd_sc_hd__mux2_1
X_12257_ cell2.CB_0.config_dataA\[20\] cell2.CB_0.config_dataA\[19\] net823 vssd1
+ vssd1 vccd1 vccd1 _00690_ sky130_fd_sc_hd__mux2_1
XFILLER_107_391 vssd1 vssd1 vccd1 vccd1 sky130_fd_sc_hd__fill_1
XFILLER_79_71 vssd1 vssd1 vccd1 vccd1 sky130_fd_sc_hd__fill_1
XFILLER_141_169 vssd1 vssd1 vccd1 vccd1 sky130_fd_sc_hd__fill_1
X_11208_ _05847_ _05851_ net383 vssd1 vssd1 vccd1 vccd1 _06160_ sky130_fd_sc_hd__mux2_1
X_12188_ cell2.CB_1.config_dataA\[1\] cell2.CB_1.config_dataA\[0\] net846 vssd1 vssd1
+ vccd1 vccd1 _00621_ sky130_fd_sc_hd__mux2_1
XANTENNA__08367__B2 bus1_0\[4\] vssd1 vssd1 vccd1 vccd1 sky130_fd_sc_hd__diode_2
XANTENNA__08367__A1 bus1_0\[5\] vssd1 vssd1 vccd1 vccd1 sky130_fd_sc_hd__diode_2
XFILLER_96_724 vssd1 vssd1 vccd1 vccd1 sky130_fd_sc_hd__fill_1
X_11139_ _05893_ _05890_ net387 vssd1 vssd1 vccd1 vccd1 _06091_ sky130_fd_sc_hd__mux2_1
XFILLER_55_109 vssd1 vssd1 vccd1 vccd1 sky130_fd_sc_hd__fill_1
XFILLER_49_673 vssd1 vssd1 vccd1 vccd1 sky130_fd_sc_hd__fill_1
X_06680_ cell2.CB_1.config_dataB\[4\] vssd1 vssd1 vccd1 vccd1 _01750_ sky130_fd_sc_hd__inv_2
XFILLER_64_643 vssd1 vssd1 vccd1 vccd1 sky130_fd_sc_hd__fill_1
XANTENNA__09152__S _04174_ vssd1 vssd1 vccd1 vccd1 sky130_fd_sc_hd__diode_2
X_08350_ bus1_0\[8\] bus1_0\[9\] bus1_0\[10\] bus1_0\[11\] net504 cell0.CB_1.config_dataB\[11\]
+ vssd1 vssd1 vccd1 vccd1 _03388_ sky130_fd_sc_hd__mux4_1
XTAP_TAPCELL_ROW_19_587 vssd1 vccd1 sky130_fd_sc_hd__tapvpwrvgnd_1
XTAP_TAPCELL_ROW_19_598 vssd1 vccd1 sky130_fd_sc_hd__tapvpwrvgnd_1
X_07301_ _02050_ _02358_ vssd1 vssd1 vccd1 vccd1 _02359_ sky130_fd_sc_hd__nor2_1
X_08281_ bus1_0\[8\] bus1_0\[9\] bus1_0\[10\] bus1_0\[11\] net507 cell0.CB_1.config_dataB\[6\]
+ vssd1 vssd1 vccd1 vccd1 _03319_ sky130_fd_sc_hd__mux4_1
X_07232_ bus3_1\[11\] net327 _02290_ vssd1 vssd1 vccd1 vccd1 _02292_ sky130_fd_sc_hd__mux2_1
X_07163_ _01888_ _02063_ vssd1 vssd1 vccd1 vccd1 _02225_ sky130_fd_sc_hd__nor2_1
XTAP_TAPCELL_ROW_30_752 vssd1 vccd1 sky130_fd_sc_hd__tapvpwrvgnd_1
XTAP_TAPCELL_ROW_30_763 vssd1 vccd1 sky130_fd_sc_hd__tapvpwrvgnd_1
XFILLER_118_678 vssd1 vssd1 vccd1 vccd1 sky130_fd_sc_hd__fill_1
XTAP_TAPCELL_ROW_76_1448 vssd1 vccd1 sky130_fd_sc_hd__tapvpwrvgnd_1
X_07094_ cell1.SB0.route_sel\[72\] cell1.SB0.route_sel\[73\] _02157_ vssd1 vssd1 vccd1
+ vccd1 _02158_ sky130_fd_sc_hd__a21oi_1
X_09804_ net447 _04298_ vssd1 vssd1 vccd1 vccd1 _04810_ sky130_fd_sc_hd__or2_1
XFILLER_99_584 vssd1 vssd1 vccd1 vccd1 sky130_fd_sc_hd__fill_1
XANTENNA__10704__A3 net11 vssd1 vssd1 vccd1 vccd1 sky130_fd_sc_hd__diode_2
X_07996_ _03036_ _03037_ _01558_ vssd1 vssd1 vccd1 vccd1 _03038_ sky130_fd_sc_hd__mux2_1
XANTENNA__09307__B1 net268 vssd1 vssd1 vccd1 vccd1 sky130_fd_sc_hd__diode_2
XANTENNA__09858__A1 net308 vssd1 vssd1 vccd1 vccd1 sky130_fd_sc_hd__diode_2
X_09735_ _01579_ cell2.SB0.route_sel\[9\] _01580_ cell2.SB0.route_sel\[10\] _04745_
+ vssd1 vssd1 vccd1 vccd1 _04746_ sky130_fd_sc_hd__o221a_1
X_06947_ cell0.CB_1.config_dataA\[22\] cell0.CB_1.config_dataA\[23\] vssd1 vssd1 vccd1
+ vccd1 _02013_ sky130_fd_sc_hd__nand2b_1
X_09666_ net296 _04680_ _04678_ vssd1 vssd1 vccd1 vccd1 _04681_ sky130_fd_sc_hd__mux2_1
XANTENNA_fanout657_A net675 vssd1 vssd1 vccd1 vccd1 sky130_fd_sc_hd__diode_2
XFILLER_27_312 vssd1 vssd1 vccd1 vccd1 sky130_fd_sc_hd__fill_1
XFILLER_131_57 vccd1 vssd1 vccd1 vssd1 sky130_ef_sc_hd__decap_40_12
XTAP_TAPCELL_ROW_120_2103 vssd1 vccd1 sky130_fd_sc_hd__tapvpwrvgnd_1
X_06878_ cell0.CB_0.config_dataB\[24\] cell0.CB_0.config_dataB\[20\] cell0.CB_0.config_dataB\[21\]
+ vssd1 vssd1 vccd1 vccd1 _01946_ sky130_fd_sc_hd__and3b_1
XTAP_TAPCELL_ROW_38_874 vssd1 vccd1 sky130_fd_sc_hd__tapvpwrvgnd_1
XANTENNA__08530__A1 _02444_ vssd1 vssd1 vccd1 vccd1 sky130_fd_sc_hd__diode_2
XPHY_EDGE_ROW_19_Left_162 vssd1 vssd1 vccd1 vccd1 sky130_fd_sc_hd__decap_3
X_08617_ _03648_ _03649_ _03652_ vssd1 vssd1 vccd1 vccd1 _03653_ sky130_fd_sc_hd__a21o_1
XFILLER_27_367 vssd1 vssd1 vccd1 vccd1 sky130_fd_sc_hd__fill_1
XANTENNA_fanout824_A net827 vssd1 vssd1 vccd1 vccd1 sky130_fd_sc_hd__diode_2
XTAP_TAPCELL_ROW_120_2114 vssd1 vccd1 sky130_fd_sc_hd__tapvpwrvgnd_1
XFILLER_91_39 vccd1 vssd1 vccd1 vssd1 sky130_ef_sc_hd__decap_40_12
X_09597_ net330 _02289_ cell3.SB0.route_sel\[92\] cell3.SB0.route_sel\[93\] vssd1
+ vssd1 vccd1 vccd1 _04614_ sky130_fd_sc_hd__a2bb2o_1
XTAP_TAPCELL_ROW_38_885 vssd1 vccd1 sky130_fd_sc_hd__tapvpwrvgnd_1
X_08548_ cell1.LE_1A.config_data\[15\] cell1.LE_1A.config_data\[14\] _03546_ vssd1
+ vssd1 vccd1 vccd1 _03584_ sky130_fd_sc_hd__mux2_1
XANTENNA__09569__Y _04587_ vssd1 vssd1 vccd1 vccd1 sky130_fd_sc_hd__diode_2
X_08479_ cell1.SB0.route_sel\[0\] cell1.SB0.route_sel\[1\] vssd1 vssd1 vccd1 vccd1
+ _03515_ sky130_fd_sc_hd__nand2b_1
X_11490_ cell2.SB0.route_sel\[8\] cell2.SB0.route_sel\[9\] vssd1 vssd1 vccd1 vccd1
+ _06327_ sky130_fd_sc_hd__nor2_1
X_10510_ _05470_ net335 _02433_ vssd1 vssd1 vccd1 vccd1 net138 sky130_fd_sc_hd__mux2_1
XANTENNA__06715__A net398 vssd1 vssd1 vccd1 vccd1 sky130_fd_sc_hd__diode_2
X_10441_ _04419_ _05434_ vssd1 vssd1 vccd1 vccd1 bus3_2\[4\] sky130_fd_sc_hd__and2_2
XTAP_TAPCELL_ROW_118_2076 vssd1 vccd1 sky130_fd_sc_hd__tapvpwrvgnd_1
XPHY_EDGE_ROW_28_Left_171 vssd1 vssd1 vccd1 vccd1 sky130_fd_sc_hd__decap_3
X_10372_ _05364_ _05366_ _05369_ _05370_ vssd1 vssd1 vccd1 vccd1 _05371_ sky130_fd_sc_hd__a22o_1
X_13160_ clknet_leaf_116_clk net1023 net665 vssd1 vssd1 vccd1 vccd1 cell0.LE_1A.config_data\[11\]
+ sky130_fd_sc_hd__dfrtp_1
XTAP_TAPCELL_ROW_131_2276 vssd1 vccd1 sky130_fd_sc_hd__tapvpwrvgnd_1
X_12111_ cell1.LE_0A.config_data\[16\] net1003 net879 vssd1 vssd1 vccd1 vccd1 _00545_
+ sky130_fd_sc_hd__mux2_1
X_13091_ clknet_leaf_3_clk _00063_ net571 vssd1 vssd1 vccd1 vccd1 cell0.CB_0.config_dataB\[18\]
+ sky130_fd_sc_hd__dfstp_1
XFILLER_2_433 vccd1 vssd1 vccd1 vssd1 sky130_ef_sc_hd__decap_40_12
X_12042_ cell1.CB_1.config_dataB\[20\] cell1.CB_1.config_dataB\[19\] net887 vssd1
+ vssd1 vccd1 vccd1 _00479_ sky130_fd_sc_hd__mux2_1
XANTENNA__10156__A1 net58 vssd1 vssd1 vccd1 vccd1 sky130_fd_sc_hd__diode_2
XANTENNA__11353__B1 _05861_ vssd1 vssd1 vccd1 vccd1 sky130_fd_sc_hd__diode_2
XFILLER_77_223 vssd1 vssd1 vccd1 vccd1 sky130_fd_sc_hd__fill_1
XANTENNA__09010__A2 bus3_1\[14\] vssd1 vssd1 vccd1 vccd1 sky130_fd_sc_hd__diode_2
Xhold290 cell0.LE_0B.config_data\[3\] vssd1 vssd1 vccd1 vccd1 net1249 sky130_fd_sc_hd__dlygate4sd3_1
XFILLER_2_477 vccd1 vssd1 vccd1 vssd1 sky130_ef_sc_hd__decap_40_12
XFILLER_93_705 vssd1 vssd1 vccd1 vccd1 sky130_fd_sc_hd__fill_1
XFILLER_77_234 vssd1 vssd1 vccd1 vccd1 sky130_fd_sc_hd__fill_8
X_13993_ clknet_leaf_75_clk _00965_ net725 vssd1 vssd1 vccd1 vccd1 cell3.SB0.route_sel\[1\]
+ sky130_fd_sc_hd__dfstp_1
Xfanout792 net794 vssd1 vssd1 vccd1 vccd1 net792 sky130_fd_sc_hd__clkbuf_4
Xfanout770 net780 vssd1 vssd1 vccd1 vccd1 net770 sky130_fd_sc_hd__buf_2
XFILLER_1_15 vccd1 vssd1 vccd1 vssd1 sky130_ef_sc_hd__decap_40_12
Xfanout781 net783 vssd1 vssd1 vccd1 vccd1 net781 sky130_fd_sc_hd__clkbuf_4
XPHY_EDGE_ROW_37_Left_180 vssd1 vssd1 vccd1 vccd1 sky130_fd_sc_hd__decap_3
X_12944_ net976 net1061 net949 vssd1 vssd1 vccd1 vccd1 _01372_ sky130_fd_sc_hd__mux2_1
XFILLER_18_334 vssd1 vssd1 vccd1 vccd1 sky130_fd_sc_hd__fill_1
XFILLER_19_835 vssd1 vssd1 vccd1 vccd1 sky130_fd_sc_hd__fill_1
X_12875_ cell2.SB0.route_sel\[117\] cell2.SB0.route_sel\[116\] net818 vssd1 vssd1
+ vccd1 vccd1 _01304_ sky130_fd_sc_hd__mux2_1
XTAP_TAPCELL_ROW_47_1016 vssd1 vccd1 sky130_fd_sc_hd__tapvpwrvgnd_1
XANTENNA_output207_A net207 vssd1 vssd1 vccd1 vccd1 sky130_fd_sc_hd__diode_2
XANTENNA__13904__RESET_B net622 vssd1 vssd1 vccd1 vccd1 sky130_fd_sc_hd__diode_2
XTAP_TAPCELL_ROW_16_546 vssd1 vccd1 sky130_fd_sc_hd__tapvpwrvgnd_1
X_11826_ cell1.CB_1.config_dataA\[7\] net493 net888 vssd1 vssd1 vccd1 vccd1 _00263_
+ sky130_fd_sc_hd__mux2_1
XANTENNA__09479__Y _04500_ vssd1 vssd1 vccd1 vccd1 sky130_fd_sc_hd__diode_2
XTAP_TAPCELL_ROW_60_1205 vssd1 vccd1 sky130_fd_sc_hd__tapvpwrvgnd_1
X_11757_ net1297 cell0.LEI0.config_data\[6\] net792 vssd1 vssd1 vccd1 vccd1 _00194_
+ sky130_fd_sc_hd__mux2_1
Xclkbuf_leaf_134_clk clknet_4_0_0_clk vssd1 vssd1 vccd1 vccd1 clknet_leaf_134_clk
+ sky130_fd_sc_hd__clkbuf_8
Xclkbuf_1_1__f_cell2.LE_1B.sel_clk clknet_0_cell2.LE_1B.sel_clk vssd1 vssd1 vccd1
+ vccd1 clknet_1_1__leaf_cell2.LE_1B.sel_clk sky130_fd_sc_hd__clkbuf_16
XANTENNA__10631__A2 net10 vssd1 vssd1 vccd1 vccd1 sky130_fd_sc_hd__diode_2
X_10708_ net390 _05665_ vssd1 vssd1 vccd1 vccd1 _05666_ sky130_fd_sc_hd__and2_1
X_14476_ clknet_leaf_60_clk net1425 net738 vssd1 vssd1 vccd1 vccd1 cell3.LEI0.config_data\[41\]
+ sky130_fd_sc_hd__dfrtp_1
XANTENNA__08037__A0 bus2_0\[6\] vssd1 vssd1 vccd1 vccd1 sky130_fd_sc_hd__diode_2
X_11688_ net1083 cell0.LE_1A.config_data\[6\] net872 vssd1 vssd1 vccd1 vccd1 _00128_
+ sky130_fd_sc_hd__mux2_1
Xclkload127 clknet_leaf_62_clk vssd1 vssd1 vccd1 vccd1 clkload127/Y sky130_fd_sc_hd__inv_16
X_10639_ net286 net279 net298 net291 cell3.LEI0.config_data\[6\] cell3.LEI0.config_data\[7\]
+ vssd1 vssd1 vccd1 vccd1 _05597_ sky130_fd_sc_hd__mux4_1
Xclkload116 clknet_leaf_69_clk vssd1 vssd1 vccd1 vccd1 clkload116/Y sky130_fd_sc_hd__inv_6
Xclkload105 clknet_leaf_50_clk vssd1 vssd1 vccd1 vccd1 clkload105/Y sky130_fd_sc_hd__inv_4
X_13427_ clknet_leaf_1_clk _00399_ net560 vssd1 vssd1 vccd1 vccd1 cell0.SB0.route_sel\[68\]
+ sky130_fd_sc_hd__dfstp_1
Xclkload138 clknet_1_1__leaf_cell2.LE_0B.sel_clk vssd1 vssd1 vccd1 vccd1 clkload138/X
+ sky130_fd_sc_hd__clkbuf_4
XANTENNA__10395__A1 net64 vssd1 vssd1 vccd1 vccd1 sky130_fd_sc_hd__diode_2
XFILLER_115_615 vssd1 vssd1 vccd1 vccd1 sky130_fd_sc_hd__fill_1
X_13358_ clknet_leaf_116_clk _00330_ net667 vssd1 vssd1 vccd1 vccd1 cell1.CB_0.config_dataA\[24\]
+ sky130_fd_sc_hd__dfstp_1
XFILLER_6_761 vssd1 vssd1 vccd1 vccd1 sky130_fd_sc_hd__fill_1
XFILLER_114_125 vssd1 vssd1 vccd1 vccd1 sky130_fd_sc_hd__fill_1
XFILLER_5_260 vccd1 vssd1 vccd1 vssd1 sky130_ef_sc_hd__decap_40_12
X_12309_ cell1.SB0.route_sel\[47\] cell1.SB0.route_sel\[46\] net861 vssd1 vssd1 vccd1
+ vccd1 _00742_ sky130_fd_sc_hd__mux2_1
XTAP_TAPCELL_ROW_58_1178 vssd1 vccd1 sky130_fd_sc_hd__tapvpwrvgnd_1
XFILLER_5_293 vssd1 vssd1 vccd1 vccd1 sky130_fd_sc_hd__fill_8
X_13289_ clknet_leaf_97_clk _00261_ net683 vssd1 vssd1 vccd1 vccd1 cell1.CB_1.config_dataA\[5\]
+ sky130_fd_sc_hd__dfstp_1
XPHY_EDGE_ROW_18_Right_18 vssd1 vssd1 vccd1 vccd1 sky130_fd_sc_hd__decap_3
XFILLER_111_843 vssd1 vssd1 vccd1 vccd1 sky130_fd_sc_hd__fill_1
XFILLER_110_331 vssd1 vssd1 vccd1 vccd1 sky130_fd_sc_hd__fill_1
XFILLER_84_705 vssd1 vssd1 vccd1 vccd1 sky130_fd_sc_hd__fill_1
XTAP_TAPCELL_ROW_71_1378 vssd1 vccd1 sky130_fd_sc_hd__tapvpwrvgnd_1
XTAP_TAPCELL_ROW_71_1367 vssd1 vccd1 sky130_fd_sc_hd__tapvpwrvgnd_1
X_07850_ _02716_ _02893_ vssd1 vssd1 vccd1 vccd1 _02894_ sky130_fd_sc_hd__and2_2
XFILLER_96_598 vssd1 vssd1 vccd1 vccd1 sky130_fd_sc_hd__fill_1
XFILLER_84_727 vssd1 vssd1 vccd1 vccd1 sky130_fd_sc_hd__fill_4
X_06801_ net345 _01867_ net359 vssd1 vssd1 vccd1 vccd1 _01871_ sky130_fd_sc_hd__nor3_1
XANTENNA__07563__A2 net353 vssd1 vssd1 vccd1 vccd1 sky130_fd_sc_hd__diode_2
X_07781_ _01852_ _02110_ bus1_0\[5\] vssd1 vssd1 vccd1 vccd1 _02826_ sky130_fd_sc_hd__o21ai_1
XANTENNA__08760__B2 _03537_ vssd1 vssd1 vccd1 vccd1 sky130_fd_sc_hd__diode_2
XANTENNA__08760__A1 _03540_ vssd1 vssd1 vccd1 vccd1 sky130_fd_sc_hd__diode_2
X_06732_ net383 vssd1 vssd1 vccd1 vccd1 _01802_ sky130_fd_sc_hd__inv_2
Xinput3 CBeast_in[11] vssd1 vssd1 vccd1 vccd1 net3 sky130_fd_sc_hd__clkbuf_4
X_09520_ net295 _04538_ _04539_ _04536_ vssd1 vssd1 vccd1 vccd1 _04540_ sky130_fd_sc_hd__a22o_1
XFILLER_83_259 vssd1 vssd1 vccd1 vccd1 sky130_fd_sc_hd__fill_1
X_09451_ _01904_ _01906_ net300 _04471_ vssd1 vssd1 vccd1 vccd1 _04473_ sky130_fd_sc_hd__o211a_1
X_06663_ cell3.SB0.route_sel\[91\] vssd1 vssd1 vccd1 vccd1 _01733_ sky130_fd_sc_hd__inv_2
XFILLER_64_473 vssd1 vssd1 vccd1 vccd1 sky130_fd_sc_hd__fill_2
XFILLER_101_27 vssd1 vssd1 vccd1 vccd1 sky130_fd_sc_hd__fill_1
X_09382_ cell3.CB_1.config_dataA\[23\] cell3.CB_1.config_dataA\[22\] vssd1 vssd1 vccd1
+ vccd1 _04406_ sky130_fd_sc_hd__nand2b_1
XANTENNA__09068__A2 _03817_ vssd1 vssd1 vccd1 vccd1 sky130_fd_sc_hd__diode_2
X_08402_ cell0.CB_1.config_dataB\[16\] _03438_ _03439_ vssd1 vssd1 vccd1 vccd1 _03440_
+ sky130_fd_sc_hd__a21oi_1
XPHY_EDGE_ROW_27_Right_27 vssd1 vssd1 vccd1 vccd1 sky130_fd_sc_hd__decap_3
XTAP_TAPCELL_ROW_35_833 vssd1 vccd1 sky130_fd_sc_hd__tapvpwrvgnd_1
X_06594_ cell1.CB_1.config_dataA\[2\] vssd1 vssd1 vccd1 vccd1 _01664_ sky130_fd_sc_hd__inv_2
XFILLER_51_156 vssd1 vssd1 vccd1 vccd1 sky130_fd_sc_hd__fill_1
X_08333_ bus1_0\[12\] bus1_0\[13\] bus1_0\[14\] bus1_0\[15\] net510 cell0.CB_1.config_dataB\[1\]
+ vssd1 vssd1 vccd1 vccd1 _03371_ sky130_fd_sc_hd__mux4_1
Xclkbuf_leaf_125_clk clknet_4_2_0_clk vssd1 vssd1 vccd1 vccd1 clknet_leaf_125_clk
+ sky130_fd_sc_hd__clkbuf_8
X_08264_ cell0.LE_1A.config_data\[15\] cell0.LE_1A.config_data\[14\] _03198_ vssd1
+ vssd1 vccd1 vccd1 _03304_ sky130_fd_sc_hd__mux2_1
XANTENNA__07618__A3 net108 vssd1 vssd1 vccd1 vccd1 sky130_fd_sc_hd__diode_2
XFILLER_20_510 vssd1 vssd1 vccd1 vccd1 sky130_fd_sc_hd__fill_1
X_08195_ bus1_0\[12\] bus1_0\[13\] bus1_0\[14\] bus1_0\[15\] net539 cell0.CB_1.config_dataA\[11\]
+ vssd1 vssd1 vccd1 vccd1 _03235_ sky130_fd_sc_hd__mux4_1
X_07215_ cell0.SB0.route_sel\[95\] cell0.SB0.route_sel\[94\] vssd1 vssd1 vccd1 vccd1
+ _02275_ sky130_fd_sc_hd__nand2b_1
X_07146_ cell0.SB0.route_sel\[80\] cell0.SB0.route_sel\[81\] _02200_ _02207_ net784
+ vssd1 vssd1 vccd1 vccd1 _02208_ sky130_fd_sc_hd__a311oi_4
XANTENNA__08043__A3 cell0.CB_1.le_outB vssd1 vssd1 vccd1 vccd1 sky130_fd_sc_hd__diode_2
X_07077_ cell1.SB0.route_sel\[74\] cell1.SB0.route_sel\[75\] vssd1 vssd1 vccd1 vccd1
+ _02141_ sky130_fd_sc_hd__nand2_1
XPHY_EDGE_ROW_36_Right_36 vssd1 vssd1 vccd1 vccd1 sky130_fd_sc_hd__decap_3
XANTENNA__11335__A0 _05901_ vssd1 vssd1 vccd1 vccd1 sky130_fd_sc_hd__diode_2
XANTENNA_fanout774_A net780 vssd1 vssd1 vccd1 vccd1 sky130_fd_sc_hd__diode_2
XTAP_TAPCELL_ROW_89_1639 vssd1 vccd1 sky130_fd_sc_hd__tapvpwrvgnd_1
XFILLER_19_55 vssd1 vssd1 vccd1 vccd1 sky130_fd_sc_hd__fill_1
XANTENNA__08751__A1 _03517_ vssd1 vssd1 vccd1 vccd1 sky130_fd_sc_hd__diode_2
XANTENNA__08751__B2 _03514_ vssd1 vssd1 vccd1 vccd1 sky130_fd_sc_hd__diode_2
XFILLER_142_67 vssd1 vssd1 vccd1 vccd1 sky130_fd_sc_hd__fill_1
X_09718_ _04730_ net294 _04729_ vssd1 vssd1 vccd1 vccd1 _04731_ sky130_fd_sc_hd__mux2_1
X_07979_ _03022_ _03019_ _02978_ vssd1 vssd1 vccd1 vccd1 _03023_ sky130_fd_sc_hd__mux2_1
XFILLER_142_89 vssd1 vssd1 vccd1 vccd1 sky130_fd_sc_hd__fill_1
X_10990_ _05932_ _05936_ _05940_ _05943_ vssd1 vssd1 vccd1 vccd1 _05944_ sky130_fd_sc_hd__o211a_1
XFILLER_90_708 vssd1 vssd1 vccd1 vccd1 sky130_fd_sc_hd__fill_1
XANTENNA__13135__SET_B net581 vssd1 vssd1 vccd1 vccd1 sky130_fd_sc_hd__diode_2
XANTENNA_fanout827_X net827 vssd1 vssd1 vccd1 vccd1 sky130_fd_sc_hd__diode_2
X_09649_ _04662_ _04664_ vssd1 vssd1 vccd1 vccd1 bus3_1\[12\] sky130_fd_sc_hd__and2_2
XFILLER_70_421 vssd1 vssd1 vccd1 vccd1 sky130_fd_sc_hd__fill_1
XPHY_EDGE_ROW_45_Right_45 vssd1 vssd1 vccd1 vccd1 sky130_fd_sc_hd__decap_3
X_12660_ cell3.SB0.route_sel\[125\] cell3.SB0.route_sel\[124\] net913 vssd1 vssd1
+ vccd1 vccd1 _01089_ sky130_fd_sc_hd__mux2_1
XANTENNA__10861__A2 net10 vssd1 vssd1 vccd1 vccd1 sky130_fd_sc_hd__diode_2
XANTENNA__09059__A2 _03841_ vssd1 vssd1 vccd1 vccd1 sky130_fd_sc_hd__diode_2
XANTENNA_input105_A SBwest_in[17] vssd1 vssd1 vccd1 vccd1 sky130_fd_sc_hd__diode_2
XTAP_TAPCELL_ROW_100_1806 vssd1 vccd1 sky130_fd_sc_hd__tapvpwrvgnd_1
X_11611_ cell0.CB_0.config_dataB\[7\] cell0.CB_0.config_dataB\[6\] net773 vssd1 vssd1
+ vccd1 vccd1 _00052_ sky130_fd_sc_hd__mux2_1
XTAP_TAPCELL_ROW_13_505 vssd1 vccd1 sky130_fd_sc_hd__tapvpwrvgnd_1
XFILLER_31_819 vssd1 vssd1 vccd1 vccd1 sky130_fd_sc_hd__fill_1
X_14330_ clknet_leaf_26_clk _01302_ net613 vssd1 vssd1 vccd1 vccd1 cell2.SB0.route_sel\[115\]
+ sky130_fd_sc_hd__dfstp_1
X_12591_ cell3.SB0.route_sel\[56\] cell3.SB0.route_sel\[55\] net912 vssd1 vssd1 vccd1
+ vccd1 _01020_ sky130_fd_sc_hd__mux2_1
Xclkbuf_leaf_116_clk clknet_4_9_0_clk vssd1 vssd1 vccd1 vccd1 clknet_leaf_116_clk
+ sky130_fd_sc_hd__clkbuf_8
XFILLER_129_729 vssd1 vssd1 vccd1 vccd1 sky130_fd_sc_hd__fill_1
XFILLER_51_53 vssd1 vssd1 vccd1 vccd1 sky130_fd_sc_hd__fill_1
X_11542_ _01584_ cell0.SB0.route_sel\[10\] cell0.SB0.route_sel\[15\] cell0.SB0.route_sel\[14\]
+ _06361_ vssd1 vssd1 vccd1 vccd1 _06362_ sky130_fd_sc_hd__o221a_1
XANTENNA__08282__A3 bus1_0\[15\] vssd1 vssd1 vccd1 vccd1 sky130_fd_sc_hd__diode_2
XTAP_TAPCELL_ROW_133_2305 vssd1 vccd1 sky130_fd_sc_hd__tapvpwrvgnd_1
X_14261_ clknet_leaf_25_clk _01233_ net608 vssd1 vssd1 vccd1 vccd1 cell2.SB0.route_sel\[46\]
+ sky130_fd_sc_hd__dfstp_1
X_11473_ cell1.SB0.route_sel\[90\] _01536_ cell1.SB0.route_sel\[95\] cell1.SB0.route_sel\[94\]
+ _06315_ vssd1 vssd1 vccd1 vccd1 _06316_ sky130_fd_sc_hd__o221a_1
X_10424_ _05421_ _05422_ _05309_ vssd1 vssd1 vccd1 vccd1 _05423_ sky130_fd_sc_hd__mux2_1
X_14192_ clknet_leaf_53_clk _01164_ net714 vssd1 vssd1 vccd1 vccd1 cell3.CB_0.config_dataA\[2\]
+ sky130_fd_sc_hd__dfstp_2
X_13212_ clknet_leaf_13_clk _00184_ net589 vssd1 vssd1 vccd1 vccd1 cell0.LE_0A.reset_mode
+ sky130_fd_sc_hd__dfrtp_1
XANTENNA_input70_A SBsouth_in[14] vssd1 vssd1 vccd1 vccd1 sky130_fd_sc_hd__diode_2
XPHY_EDGE_ROW_54_Right_54 vssd1 vssd1 vccd1 vccd1 sky130_fd_sc_hd__decap_3
X_13143_ clknet_leaf_129_clk _00115_ net578 vssd1 vssd1 vccd1 vccd1 cell0.CB_1.config_dataB\[20\]
+ sky130_fd_sc_hd__dfstp_1
X_10355_ _05152_ _05348_ _05350_ _05156_ cell2.CB_0.config_dataB\[12\] vssd1 vssd1
+ vccd1 vccd1 _05354_ sky130_fd_sc_hd__a221o_1
XFILLER_98_808 vssd1 vssd1 vccd1 vccd1 sky130_fd_sc_hd__fill_1
XFILLER_3_753 vccd1 vssd1 vccd1 vssd1 sky130_ef_sc_hd__decap_40_12
X_10286_ net431 _05144_ vssd1 vssd1 vccd1 vccd1 _05285_ sky130_fd_sc_hd__nand2_1
XFILLER_97_329 vssd1 vssd1 vccd1 vccd1 sky130_fd_sc_hd__fill_1
XANTENNA_output157_A net157 vssd1 vssd1 vccd1 vccd1 sky130_fd_sc_hd__diode_2
X_13074_ clknet_leaf_7_clk _00046_ net574 vssd1 vssd1 vccd1 vccd1 cell0.CB_0.config_dataB\[1\]
+ sky130_fd_sc_hd__dfstp_1
XFILLER_3_797 vccd1 vssd1 vccd1 vssd1 sky130_ef_sc_hd__decap_40_12
XTAP_TAPCELL_ROW_111_1979 vssd1 vccd1 sky130_fd_sc_hd__tapvpwrvgnd_1
XTAP_TAPCELL_ROW_111_1968 vssd1 vccd1 sky130_fd_sc_hd__tapvpwrvgnd_1
X_12025_ cell1.CB_1.config_dataB\[3\] cell1.CB_1.config_dataB\[2\] net901 vssd1 vssd1
+ vccd1 vccd1 _00462_ sky130_fd_sc_hd__mux2_1
XFILLER_78_576 vssd1 vssd1 vccd1 vccd1 sky130_fd_sc_hd__fill_1
XTAP_TAPCELL_ROW_53_1097 vssd1 vccd1 sky130_fd_sc_hd__tapvpwrvgnd_1
XANTENNA__08742__A1 net32 vssd1 vssd1 vccd1 vccd1 sky130_fd_sc_hd__diode_2
XANTENNA__13486__SET_B net592 vssd1 vssd1 vccd1 vccd1 sky130_fd_sc_hd__diode_2
XANTENNA__11629__A1 cell0.CB_0.config_data_inA vssd1 vssd1 vccd1 vccd1 sky130_fd_sc_hd__diode_2
X_13976_ clknet_leaf_41_clk _00948_ net641 vssd1 vssd1 vccd1 vccd1 cell2.LEI0.config_data\[33\]
+ sky130_fd_sc_hd__dfrtp_1
XPHY_EDGE_ROW_63_Right_63 vssd1 vssd1 vccd1 vccd1 sky130_fd_sc_hd__decap_3
X_12927_ cell3.LE_1A.config_data\[15\] net1219 net953 vssd1 vssd1 vccd1 vccd1 _01356_
+ sky130_fd_sc_hd__mux2_1
X_12858_ cell2.SB0.route_sel\[100\] cell2.SB0.route_sel\[99\] net821 vssd1 vssd1 vccd1
+ vccd1 _01287_ sky130_fd_sc_hd__mux2_1
XANTENNA__11813__X _00250_ vssd1 vssd1 vccd1 vccd1 sky130_fd_sc_hd__diode_2
XFILLER_18_197 vssd1 vssd1 vccd1 vccd1 sky130_fd_sc_hd__fill_1
X_11809_ cell1.LE_1B.config_data\[10\] cell1.LE_1B.config_data\[9\] net902 vssd1 vssd1
+ vccd1 vccd1 _00246_ sky130_fd_sc_hd__mux2_1
XANTENNA__10429__X cell2.CB_0.le_outB vssd1 vssd1 vccd1 vccd1 sky130_fd_sc_hd__diode_2
X_12789_ cell2.SB0.route_sel\[31\] cell2.SB0.route_sel\[30\] net820 vssd1 vssd1 vccd1
+ vccd1 _01218_ sky130_fd_sc_hd__mux2_1
Xclkbuf_leaf_107_clk clknet_4_8_0_clk vssd1 vssd1 vccd1 vccd1 clknet_leaf_107_clk
+ sky130_fd_sc_hd__clkbuf_8
XANTENNA__06808__A1 net361 vssd1 vssd1 vccd1 vccd1 sky130_fd_sc_hd__diode_2
XANTENNA__08046__S _03087_ vssd1 vssd1 vccd1 vccd1 sky130_fd_sc_hd__diode_2
X_14459_ clknet_leaf_60_clk _01431_ net740 vssd1 vssd1 vccd1 vccd1 cell3.LEI0.config_data\[24\]
+ sky130_fd_sc_hd__dfrtp_1
XPHY_EDGE_ROW_72_Right_72 vssd1 vssd1 vccd1 vccd1 sky130_fd_sc_hd__decap_3
X_07000_ net325 _02062_ _02063_ _02059_ vssd1 vssd1 vccd1 vccd1 _02066_ sky130_fd_sc_hd__o31a_1
XANTENNA__08025__A3 bus2_0\[11\] vssd1 vssd1 vccd1 vccd1 sky130_fd_sc_hd__diode_2
XFILLER_142_253 vssd1 vssd1 vccd1 vccd1 sky130_fd_sc_hd__fill_1
XANTENNA__10605__A net398 vssd1 vssd1 vccd1 vccd1 sky130_fd_sc_hd__diode_2
XFILLER_88_307 vssd1 vssd1 vccd1 vccd1 sky130_fd_sc_hd__fill_1
XTAP_TAPCELL_ROW_73_1407 vssd1 vccd1 sky130_fd_sc_hd__tapvpwrvgnd_1
X_08951_ _03982_ vssd1 vssd1 vccd1 vccd1 _03983_ sky130_fd_sc_hd__inv_2
XFILLER_97_841 vssd1 vssd1 vccd1 vccd1 sky130_fd_sc_hd__fill_1
XFILLER_69_532 vssd1 vssd1 vccd1 vccd1 sky130_fd_sc_hd__fill_1
X_08882_ net474 _03817_ _03913_ net472 vssd1 vssd1 vccd1 vccd1 _03914_ sky130_fd_sc_hd__o211a_1
X_07902_ _01568_ _01569_ cell0.CB_0.config_dataA\[4\] _02920_ _02945_ vssd1 vssd1
+ vccd1 vccd1 _02946_ sky130_fd_sc_hd__a41o_1
XANTENNA_clkbuf_4_4_0_clk_A clknet_0_clk vssd1 vssd1 vccd1 vccd1 sky130_fd_sc_hd__diode_2
X_07833_ bus2_0\[8\] bus2_0\[9\] bus2_0\[10\] bus2_0\[11\] net518 net517 vssd1 vssd1
+ vccd1 vccd1 _02877_ sky130_fd_sc_hd__mux4_1
XFILLER_84_524 vssd1 vssd1 vccd1 vccd1 sky130_fd_sc_hd__fill_2
XPHY_EDGE_ROW_81_Right_81 vssd1 vssd1 vccd1 vccd1 sky130_fd_sc_hd__decap_3
Xclkbuf_0_cell1.LE_1A.sel_clk cell1.LE_1A.sel_clk vssd1 vssd1 vccd1 vccd1 clknet_0_cell1.LE_1A.sel_clk
+ sky130_fd_sc_hd__clkbuf_16
X_07764_ cell1.SB0.route_sel\[38\] cell1.SB0.route_sel\[39\] _02791_ _02809_ vssd1
+ vssd1 vccd1 vccd1 _02810_ sky130_fd_sc_hd__a211o_1
X_06715_ net398 vssd1 vssd1 vccd1 vccd1 _01785_ sky130_fd_sc_hd__inv_2
X_09503_ _04523_ _04521_ vssd1 vssd1 vccd1 vccd1 bus3_1\[7\] sky130_fd_sc_hd__and2b_4
X_07695_ net339 _01933_ _02609_ vssd1 vssd1 vccd1 vccd1 _02742_ sky130_fd_sc_hd__or3_1
XFILLER_37_484 vccd1 vssd1 vccd1 vssd1 sky130_ef_sc_hd__decap_40_12
X_09434_ _04265_ _04412_ vssd1 vssd1 vccd1 vccd1 _04457_ sky130_fd_sc_hd__nor2_1
XTAP_TAPCELL_ROW_84_1569 vssd1 vccd1 sky130_fd_sc_hd__tapvpwrvgnd_1
X_06646_ cell3.SB0.route_sel\[61\] vssd1 vssd1 vccd1 vccd1 _01716_ sky130_fd_sc_hd__inv_2
XANTENNA__11870__S net883 vssd1 vssd1 vccd1 vccd1 sky130_fd_sc_hd__diode_2
XANTENNA__08249__A0 bus1_0\[0\] vssd1 vssd1 vccd1 vccd1 sky130_fd_sc_hd__diode_2
XANTENNA__11171__A _05901_ vssd1 vssd1 vccd1 vccd1 sky130_fd_sc_hd__diode_2
XANTENNA__09997__A0 bus3_2\[12\] vssd1 vssd1 vccd1 vccd1 sky130_fd_sc_hd__diode_2
X_09365_ cell2.SB0.route_sel\[32\] cell2.SB0.route_sel\[33\] _04388_ vssd1 vssd1 vccd1
+ vccd1 _04389_ sky130_fd_sc_hd__and3_1
X_06577_ cell2.SB0.route_sel\[118\] vssd1 vssd1 vccd1 vccd1 _01647_ sky130_fd_sc_hd__inv_2
XFILLER_40_649 vssd1 vssd1 vccd1 vccd1 sky130_fd_sc_hd__fill_1
XFILLER_40_638 vssd1 vssd1 vccd1 vccd1 sky130_fd_sc_hd__fill_1
XFILLER_21_841 vssd1 vssd1 vccd1 vccd1 sky130_fd_sc_hd__fill_1
XANTENNA_41 net193 vssd1 vssd1 vccd1 vccd1 sky130_fd_sc_hd__diode_2
X_09296_ cell3.SB0.route_sel\[16\] _01690_ vssd1 vssd1 vccd1 vccd1 _04322_ sky130_fd_sc_hd__nand2_1
XANTENNA_30 net1332 vssd1 vssd1 vccd1 vccd1 sky130_fd_sc_hd__diode_2
X_08316_ _03353_ vssd1 vssd1 vccd1 vccd1 _03354_ sky130_fd_sc_hd__inv_2
XPHY_EDGE_ROW_90_Right_90 vssd1 vssd1 vccd1 vccd1 sky130_fd_sc_hd__decap_3
X_08247_ bus1_0\[5\] _03266_ _03267_ bus1_0\[4\] cell0.CB_1.config_dataA\[18\] vssd1
+ vssd1 vccd1 vccd1 _03287_ sky130_fd_sc_hd__a221o_1
XTAP_TAPCELL_ROW_115_2035 vssd1 vccd1 sky130_fd_sc_hd__tapvpwrvgnd_1
XTAP_TAPCELL_ROW_99_1790 vssd1 vccd1 sky130_fd_sc_hd__tapvpwrvgnd_1
XANTENNA__10359__B2 net59 vssd1 vssd1 vccd1 vccd1 sky130_fd_sc_hd__diode_2
XANTENNA__10359__A1 net60 vssd1 vssd1 vccd1 vccd1 sky130_fd_sc_hd__diode_2
X_08178_ _02422_ _02424_ _03203_ vssd1 vssd1 vccd1 vccd1 _03218_ sky130_fd_sc_hd__o21ai_1
XANTENNA_fanout891_A net908 vssd1 vssd1 vccd1 vccd1 sky130_fd_sc_hd__diode_2
XFILLER_21_78 vssd1 vssd1 vccd1 vccd1 sky130_fd_sc_hd__fill_8
XFILLER_106_445 vssd1 vssd1 vccd1 vccd1 sky130_fd_sc_hd__fill_1
XFILLER_97_27 vccd1 vssd1 vccd1 vssd1 sky130_ef_sc_hd__decap_40_12
X_07129_ net339 net361 net357 vssd1 vssd1 vccd1 vccd1 _02191_ sky130_fd_sc_hd__or3_1
Xoutput170 net170 vssd1 vssd1 vccd1 vccd1 CBnorth_out[13] sky130_fd_sc_hd__buf_2
X_10140_ cell2.CB_0.config_dataA\[7\] _05133_ _05140_ vssd1 vssd1 vccd1 vccd1 _05141_
+ sky130_fd_sc_hd__and3_1
Xoutput181 net181 vssd1 vssd1 vccd1 vccd1 CBnorth_out[23] sky130_fd_sc_hd__buf_2
Xoutput192 net192 vssd1 vssd1 vccd1 vccd1 CBnorth_out[4] sky130_fd_sc_hd__buf_2
X_10071_ cell2.LE_1B.config_data\[8\] cell2.LE_1B.config_data\[9\] _04956_ vssd1 vssd1
+ vccd1 vccd1 _05075_ sky130_fd_sc_hd__mux2_1
XANTENNA__09582__Y _04600_ vssd1 vssd1 vccd1 vccd1 sky130_fd_sc_hd__diode_2
XANTENNA__10802__X _05758_ vssd1 vssd1 vccd1 vccd1 sky130_fd_sc_hd__diode_2
XANTENNA__09921__A0 bus3_2\[0\] vssd1 vssd1 vccd1 vccd1 sky130_fd_sc_hd__diode_2
XANTENNA_hold567_A _00250_ vssd1 vssd1 vccd1 vccd1 sky130_fd_sc_hd__diode_2
XANTENNA_fanout944_X net944 vssd1 vssd1 vccd1 vccd1 sky130_fd_sc_hd__diode_2
XFILLER_75_579 vssd1 vssd1 vccd1 vccd1 sky130_fd_sc_hd__fill_2
XFILLER_75_557 vssd1 vssd1 vccd1 vccd1 sky130_fd_sc_hd__fill_1
X_13830_ clknet_leaf_115_clk _00802_ net666 vssd1 vssd1 vccd1 vccd1 cell1.SB0.route_sel\[107\]
+ sky130_fd_sc_hd__dfstp_1
XTAP_TAPCELL_ROW_126_2197 vssd1 vccd1 sky130_fd_sc_hd__tapvpwrvgnd_1
X_10973_ cell3.CB_0.config_dataA\[2\] _05895_ _05903_ _05909_ _05926_ vssd1 vssd1
+ vccd1 vccd1 _05927_ sky130_fd_sc_hd__a311o_1
XANTENNA__08488__A0 net29 vssd1 vssd1 vccd1 vccd1 sky130_fd_sc_hd__diode_2
X_13761_ clknet_leaf_111_clk _00733_ net654 vssd1 vssd1 vccd1 vccd1 cell1.SB0.route_sel\[38\]
+ sky130_fd_sc_hd__dfstp_1
X_12712_ cell3.CB_0.config_dataB\[4\] cell3.CB_0.config_dataB\[3\] net930 vssd1 vssd1
+ vccd1 vccd1 _01141_ sky130_fd_sc_hd__mux2_1
X_13692_ clknet_leaf_32_clk _00664_ net621 vssd1 vssd1 vccd1 vccd1 cell2.CB_0.config_dataB\[19\]
+ sky130_fd_sc_hd__dfstp_1
XFILLER_71_774 vssd1 vssd1 vccd1 vccd1 sky130_fd_sc_hd__fill_1
XANTENNA_input108_X net108 vssd1 vssd1 vccd1 vccd1 sky130_fd_sc_hd__diode_2
X_12643_ cell3.SB0.route_sel\[108\] cell3.SB0.route_sel\[107\] net923 vssd1 vssd1
+ vccd1 vccd1 _01072_ sky130_fd_sc_hd__mux2_1
XTAP_TAPCELL_ROW_26_696 vssd1 vccd1 sky130_fd_sc_hd__tapvpwrvgnd_1
XFILLER_30_137 vssd1 vssd1 vccd1 vccd1 sky130_fd_sc_hd__fill_2
X_12574_ cell3.SB0.route_sel\[39\] cell3.SB0.route_sel\[38\] net909 vssd1 vssd1 vccd1
+ vccd1 _01003_ sky130_fd_sc_hd__mux2_1
XFILLER_129_559 vssd1 vssd1 vccd1 vccd1 sky130_fd_sc_hd__fill_1
X_11525_ _06350_ net319 vssd1 vssd1 vccd1 vccd1 net250 sky130_fd_sc_hd__and2b_1
X_14313_ clknet_leaf_18_clk _01285_ net628 vssd1 vssd1 vccd1 vccd1 cell2.SB0.route_sel\[98\]
+ sky130_fd_sc_hd__dfstp_1
XFILLER_11_384 vssd1 vssd1 vccd1 vccd1 sky130_fd_sc_hd__fill_1
XFILLER_109_250 vssd1 vssd1 vccd1 vccd1 sky130_fd_sc_hd__fill_1
X_14244_ clknet_leaf_8_clk _01216_ net572 vssd1 vssd1 vccd1 vccd1 cell2.SB0.route_sel\[29\]
+ sky130_fd_sc_hd__dfstp_1
XFILLER_7_69 vccd1 vssd1 vccd1 vssd1 sky130_ef_sc_hd__decap_40_12
X_11456_ _02866_ _06304_ vssd1 vssd1 vccd1 vccd1 net211 sky130_fd_sc_hd__nor2_1
X_14175_ clknet_leaf_57_clk _01147_ net722 vssd1 vssd1 vccd1 vccd1 cell3.CB_0.config_dataB\[10\]
+ sky130_fd_sc_hd__dfstp_1
X_10407_ net60 _05385_ _05386_ net59 cell2.CB_0.config_dataB\[18\] vssd1 vssd1 vccd1
+ vccd1 _05406_ sky130_fd_sc_hd__a221o_1
X_11387_ _06258_ _01953_ vssd1 vssd1 vccd1 vccd1 net227 sky130_fd_sc_hd__and2b_1
X_10338_ _05336_ vssd1 vssd1 vccd1 vccd1 _05337_ sky130_fd_sc_hd__inv_2
XTAP_TAPCELL_ROW_55_1137 vssd1 vccd1 sky130_fd_sc_hd__tapvpwrvgnd_1
XTAP_TAPCELL_ROW_55_1126 vssd1 vccd1 sky130_fd_sc_hd__tapvpwrvgnd_1
X_13126_ clknet_leaf_121_clk _00098_ net583 vssd1 vssd1 vccd1 vccd1 cell0.CB_1.config_dataB\[3\]
+ sky130_fd_sc_hd__dfstp_1
XFILLER_3_561 vccd1 vssd1 vccd1 vssd1 sky130_ef_sc_hd__decap_40_12
XFILLER_140_757 vccd1 vssd1 vccd1 vssd1 sky130_ef_sc_hd__decap_40_12
XANTENNA__10144__B _05144_ vssd1 vssd1 vccd1 vccd1 sky130_fd_sc_hd__diode_2
XFILLER_79_841 vssd1 vssd1 vccd1 vccd1 sky130_fd_sc_hd__fill_1
X_13057_ clknet_leaf_126_clk _00029_ net582 vssd1 vssd1 vccd1 vccd1 cell0.CB_1.config_dataA\[9\]
+ sky130_fd_sc_hd__dfstp_1
X_10269_ cell2.LE_0A.config_data\[15\] cell2.LE_0A.config_data\[14\] _05196_ vssd1
+ vssd1 vccd1 vccd1 _05270_ sky130_fd_sc_hd__mux2_1
XFILLER_39_716 vssd1 vssd1 vccd1 vccd1 sky130_fd_sc_hd__fill_1
XANTENNA__07293__X _02351_ vssd1 vssd1 vccd1 vccd1 sky130_fd_sc_hd__diode_2
X_12008_ cell0.SB0.route_sel\[114\] cell0.SB0.route_sel\[113\] net765 vssd1 vssd1
+ vccd1 vccd1 _00445_ sky130_fd_sc_hd__mux2_1
XANTENNA__13990__RESET_B net632 vssd1 vssd1 vccd1 vccd1 sky130_fd_sc_hd__diode_2
XANTENNA__08549__B _03529_ vssd1 vssd1 vccd1 vccd1 sky130_fd_sc_hd__diode_2
XFILLER_19_451 vccd1 vssd1 vccd1 vssd1 sky130_ef_sc_hd__decap_40_12
X_13959_ clknet_leaf_34_clk net1440 net638 vssd1 vssd1 vccd1 vccd1 cell2.LEI0.config_data\[16\]
+ sky130_fd_sc_hd__dfrtp_1
X_07480_ _01922_ _02397_ vssd1 vssd1 vccd1 vccd1 _02533_ sky130_fd_sc_hd__nor2_1
X_06500_ cell0.CB_0.config_dataA\[4\] vssd1 vssd1 vccd1 vccd1 _01570_ sky130_fd_sc_hd__inv_2
XANTENNA__08836__Y _03868_ vssd1 vssd1 vccd1 vccd1 sky130_fd_sc_hd__diode_2
XFILLER_34_443 vssd1 vssd1 vccd1 vccd1 sky130_fd_sc_hd__fill_1
XANTENNA__10825__A2 net24 vssd1 vssd1 vccd1 vccd1 sky130_fd_sc_hd__diode_2
XTAP_TAPCELL_ROW_66_1299 vssd1 vccd1 sky130_fd_sc_hd__tapvpwrvgnd_1
X_06431_ cell0.LE_1A.config_data\[16\] vssd1 vssd1 vccd1 vccd1 _01501_ sky130_fd_sc_hd__inv_2
XTAP_TAPCELL_ROW_45_983 vssd1 vccd1 sky130_fd_sc_hd__tapvpwrvgnd_1
XANTENNA__08284__B _02494_ vssd1 vssd1 vccd1 vccd1 sky130_fd_sc_hd__diode_2
XFILLER_22_627 vssd1 vssd1 vccd1 vccd1 sky130_fd_sc_hd__fill_1
X_09150_ net301 _04177_ vssd1 vssd1 vccd1 vccd1 _04178_ sky130_fd_sc_hd__nor2_1
X_09081_ cell1.CB_0.config_dataB\[12\] _04106_ _04107_ _04110_ vssd1 vssd1 vccd1 vccd1
+ _04111_ sky130_fd_sc_hd__o22a_1
X_08101_ net524 _02235_ _03142_ net523 vssd1 vssd1 vccd1 vccd1 _03143_ sky130_fd_sc_hd__o211a_1
X_08032_ net533 _02897_ vssd1 vssd1 vccd1 vccd1 _03074_ sky130_fd_sc_hd__nand2_1
Xinput50 CBnorth_in[25] vssd1 vssd1 vccd1 vccd1 net50 sky130_fd_sc_hd__buf_2
Xinput61 CBnorth_in[6] vssd1 vssd1 vccd1 vccd1 net61 sky130_fd_sc_hd__buf_2
Xinput72 SBsouth_in[16] vssd1 vssd1 vccd1 vccd1 net72 sky130_fd_sc_hd__clkbuf_1
Xinput94 SBsouth_in[7] vssd1 vssd1 vccd1 vccd1 net94 sky130_fd_sc_hd__clkbuf_2
Xinput83 SBsouth_in[26] vssd1 vssd1 vccd1 vccd1 net83 sky130_fd_sc_hd__clkbuf_2
X_09983_ net312 cell2.CB_0.le_outB cell2.LEI0.config_data\[21\] vssd1 vssd1 vccd1
+ vccd1 _04987_ sky130_fd_sc_hd__mux2_1
XFILLER_107_15 vccd1 vssd1 vccd1 vssd1 sky130_ef_sc_hd__decap_40_12
XANTENNA__09683__X _04697_ vssd1 vssd1 vccd1 vccd1 sky130_fd_sc_hd__diode_2
XANTENNA__10761__A1 _05510_ vssd1 vssd1 vccd1 vccd1 sky130_fd_sc_hd__diode_2
X_08934_ net332 net327 net336 net323 cell1.LEI0.config_data\[24\] cell1.LEI0.config_data\[25\]
+ vssd1 vssd1 vccd1 vccd1 _03966_ sky130_fd_sc_hd__mux4_1
XANTENNA__08706__A1 _03514_ vssd1 vssd1 vccd1 vccd1 sky130_fd_sc_hd__diode_2
X_08865_ cell1.CB_0.config_dataA\[7\] _03878_ _03896_ _03876_ vssd1 vssd1 vccd1 vccd1
+ _03897_ sky130_fd_sc_hd__o211a_1
XANTENNA__10513__A1 net322 vssd1 vssd1 vccd1 vccd1 sky130_fd_sc_hd__diode_2
Xclkbuf_0_cell3.LE_1B.sel_clk cell3.LE_1B.sel_clk vssd1 vssd1 vccd1 vccd1 clknet_0_cell3.LE_1B.sel_clk
+ sky130_fd_sc_hd__clkbuf_16
XFILLER_84_343 vssd1 vssd1 vccd1 vccd1 sky130_fd_sc_hd__fill_1
X_07816_ _01890_ _02153_ vssd1 vssd1 vccd1 vccd1 _02861_ sky130_fd_sc_hd__nor2_1
XTAP_TAPCELL_ROW_4_369 vssd1 vccd1 sky130_fd_sc_hd__tapvpwrvgnd_1
X_08796_ cell1.SB0.route_sel\[101\] cell1.SB0.route_sel\[100\] vssd1 vssd1 vccd1 vccd1
+ _03828_ sky130_fd_sc_hd__and2b_1
X_07747_ _02789_ _02792_ _02791_ vssd1 vssd1 vccd1 vccd1 _02793_ sky130_fd_sc_hd__a21oi_2
XANTENNA_fanout737_A net742 vssd1 vssd1 vccd1 vccd1 sky130_fd_sc_hd__diode_2
XANTENNA_fanout358_X net358 vssd1 vssd1 vccd1 vccd1 sky130_fd_sc_hd__diode_2
XPHY_EDGE_ROW_0_Right_0 vssd1 vssd1 vccd1 vccd1 sky130_fd_sc_hd__decap_3
X_07678_ net449 net450 _01837_ vssd1 vssd1 vccd1 vccd1 _02726_ sky130_fd_sc_hd__or3_1
XANTENNA__08485__A3 net26 vssd1 vssd1 vccd1 vccd1 sky130_fd_sc_hd__diode_2
X_09417_ _04439_ net311 _04438_ vssd1 vssd1 vccd1 vccd1 _04440_ sky130_fd_sc_hd__mux2_1
X_06629_ cell3.SB0.route_sel\[35\] vssd1 vssd1 vccd1 vccd1 _01699_ sky130_fd_sc_hd__inv_2
XANTENNA_fanout904_A net907 vssd1 vssd1 vccd1 vccd1 sky130_fd_sc_hd__diode_2
XANTENNA__08890__A0 bus3_1\[0\] vssd1 vssd1 vccd1 vccd1 sky130_fd_sc_hd__diode_2
X_09348_ _01695_ cell3.SB0.route_sel\[26\] cell3.SB0.route_sel\[31\] cell3.SB0.route_sel\[30\]
+ _04372_ vssd1 vssd1 vccd1 vccd1 _04373_ sky130_fd_sc_hd__o221a_1
XTAP_TAPCELL_ROW_23_655 vssd1 vccd1 sky130_fd_sc_hd__tapvpwrvgnd_1
XFILLER_32_22 vssd1 vssd1 vccd1 vccd1 sky130_fd_sc_hd__fill_4
XANTENNA__08642__A0 net29 vssd1 vssd1 vccd1 vccd1 sky130_fd_sc_hd__diode_2
X_09279_ _04208_ _04304_ vssd1 vssd1 vccd1 vccd1 _04305_ sky130_fd_sc_hd__nor2_1
X_11310_ net273 _05548_ _04535_ vssd1 vssd1 vccd1 vccd1 _06220_ sky130_fd_sc_hd__a21o_1
XFILLER_21_693 vssd1 vssd1 vccd1 vccd1 sky130_fd_sc_hd__fill_1
XANTENNA__08922__B _03820_ vssd1 vssd1 vccd1 vccd1 sky130_fd_sc_hd__diode_2
XFILLER_113_3 vccd1 vssd1 vccd1 vssd1 sky130_ef_sc_hd__decap_40_12
XANTENNA__08414__S _03347_ vssd1 vssd1 vccd1 vccd1 sky130_fd_sc_hd__diode_2
X_12290_ cell1.SB0.route_sel\[28\] cell1.SB0.route_sel\[27\] net857 vssd1 vssd1 vccd1
+ vccd1 _00723_ sky130_fd_sc_hd__mux2_1
X_11241_ _01803_ cell3.LE_0B.dff_out vssd1 vssd1 vccd1 vccd1 _06192_ sky130_fd_sc_hd__or2_1
XFILLER_134_562 vssd1 vssd1 vccd1 vccd1 sky130_fd_sc_hd__fill_1
X_11172_ _05898_ _06110_ _06122_ net384 _01800_ vssd1 vssd1 vccd1 vccd1 _06124_ sky130_fd_sc_hd__a221o_1
X_10123_ net60 _05094_ _05098_ net59 cell2.CB_0.config_dataA\[8\] vssd1 vssd1 vccd1
+ vccd1 _05124_ sky130_fd_sc_hd__a221o_1
XANTENNA__10752__A1 net16 vssd1 vssd1 vccd1 vccd1 sky130_fd_sc_hd__diode_2
XTAP_TAPCELL_ROW_128_2226 vssd1 vccd1 sky130_fd_sc_hd__tapvpwrvgnd_1
XANTENNA__08158__C1 _03194_ vssd1 vssd1 vccd1 vccd1 sky130_fd_sc_hd__diode_2
XANTENNA_input33_A CBnorth_in[0] vssd1 vssd1 vccd1 vccd1 sky130_fd_sc_hd__diode_2
X_10054_ bus3_2\[0\] bus3_2\[2\] bus3_2\[1\] bus3_2\[3\] net399 net401 vssd1 vssd1
+ vccd1 vccd1 _05058_ sky130_fd_sc_hd__mux4_1
XFILLER_0_597 vssd1 vssd1 vccd1 vccd1 sky130_fd_sc_hd__fill_1
XTAP_TAPCELL_ROW_50_1056 vssd1 vccd1 sky130_fd_sc_hd__tapvpwrvgnd_1
XTAP_TAPCELL_ROW_141_2426 vssd1 vccd1 sky130_fd_sc_hd__tapvpwrvgnd_1
XFILLER_63_505 vssd1 vssd1 vccd1 vccd1 sky130_fd_sc_hd__fill_4
X_13813_ clknet_leaf_113_clk _00785_ net663 vssd1 vssd1 vccd1 vccd1 cell1.SB0.route_sel\[90\]
+ sky130_fd_sc_hd__dfstp_1
XPHY_EDGE_ROW_121_Right_121 vssd1 vssd1 vccd1 vccd1 sky130_fd_sc_hd__decap_3
XANTENNA__09658__C1 _04666_ vssd1 vssd1 vccd1 vccd1 sky130_fd_sc_hd__diode_2
X_10956_ _01693_ cell3.SB0.route_sel\[20\] vssd1 vssd1 vccd1 vccd1 _05910_ sky130_fd_sc_hd__nand2_1
X_13744_ clknet_leaf_107_clk _00716_ net658 vssd1 vssd1 vccd1 vccd1 cell1.SB0.route_sel\[21\]
+ sky130_fd_sc_hd__dfstp_1
X_13675_ clknet_leaf_31_clk _00647_ net620 vssd1 vssd1 vccd1 vccd1 cell2.CB_0.config_dataB\[2\]
+ sky130_fd_sc_hd__dfstp_2
X_10887_ _05835_ _05842_ _05831_ vssd1 vssd1 vccd1 vccd1 _05843_ sky130_fd_sc_hd__mux2_1
XTAP_TAPCELL_ROW_42_931 vssd1 vccd1 sky130_fd_sc_hd__tapvpwrvgnd_1
X_12626_ cell3.SB0.route_sel\[91\] cell3.SB0.route_sel\[90\] net918 vssd1 vssd1 vccd1
+ vccd1 _01055_ sky130_fd_sc_hd__mux2_1
XTAP_TAPCELL_ROW_42_942 vssd1 vccd1 sky130_fd_sc_hd__tapvpwrvgnd_1
XTAP_TAPCELL_ROW_139_2388 vssd1 vccd1 sky130_fd_sc_hd__tapvpwrvgnd_1
XFILLER_129_312 vssd1 vssd1 vccd1 vccd1 sky130_fd_sc_hd__fill_1
XANTENNA__09425__A2 _04425_ vssd1 vssd1 vccd1 vccd1 sky130_fd_sc_hd__diode_2
XFILLER_85_7 vssd1 vssd1 vccd1 vccd1 sky130_fd_sc_hd__fill_1
XFILLER_12_682 vssd1 vssd1 vccd1 vccd1 sky130_fd_sc_hd__fill_4
XTAP_TAPCELL_ROW_139_2399 vssd1 vccd1 sky130_fd_sc_hd__tapvpwrvgnd_1
X_12557_ cell3.SB0.route_sel\[22\] cell3.SB0.route_sel\[21\] net917 vssd1 vssd1 vccd1
+ vccd1 _00986_ sky130_fd_sc_hd__mux2_1
XANTENNA__10991__A1 _05890_ vssd1 vssd1 vccd1 vccd1 sky130_fd_sc_hd__diode_2
X_12488_ cell2.LEI0.config_data\[2\] net1427 net840 vssd1 vssd1 vccd1 vccd1 _00917_
+ sky130_fd_sc_hd__mux2_1
XANTENNA__06633__A cell3.SB0.route_sel\[37\] vssd1 vssd1 vccd1 vccd1 sky130_fd_sc_hd__diode_2
X_11508_ _01616_ cell2.SB0.route_sel\[58\] vssd1 vssd1 vccd1 vccd1 _06339_ sky130_fd_sc_hd__nand2_1
Xhold108 _00205_ vssd1 vssd1 vccd1 vccd1 net1067 sky130_fd_sc_hd__dlygate4sd3_1
XFILLER_8_697 vssd1 vssd1 vccd1 vccd1 sky130_fd_sc_hd__fill_2
Xhold119 cell2.LEI0.config_data\[20\] vssd1 vssd1 vccd1 vccd1 net1078 sky130_fd_sc_hd__dlygate4sd3_1
X_14227_ clknet_leaf_16_clk _01199_ net624 vssd1 vssd1 vccd1 vccd1 cell2.SB0.route_sel\[12\]
+ sky130_fd_sc_hd__dfstp_1
X_11439_ cell1.SB0.route_sel\[1\] cell1.SB0.route_sel\[0\] vssd1 vssd1 vccd1 vccd1
+ _06293_ sky130_fd_sc_hd__nand2b_1
X_14158_ clknet_leaf_72_clk _01130_ net733 vssd1 vssd1 vccd1 vccd1 cell3.CB_1.config_dataA\[18\]
+ sky130_fd_sc_hd__dfstp_1
XFILLER_98_457 vssd1 vssd1 vccd1 vccd1 sky130_fd_sc_hd__fill_1
X_13109_ clknet_leaf_5_clk _00081_ net566 vssd1 vssd1 vccd1 vccd1 cell0.CB_0.config_dataA\[11\]
+ sky130_fd_sc_hd__dfstp_1
X_14089_ clknet_leaf_77_clk _01061_ net712 vssd1 vssd1 vccd1 vccd1 cell3.SB0.route_sel\[97\]
+ sky130_fd_sc_hd__dfstp_1
XFILLER_67_800 vssd1 vssd1 vccd1 vccd1 sky130_fd_sc_hd__fill_1
X_06980_ cell1.CB_1.config_dataB\[24\] cell1.CB_1.config_dataB\[21\] cell1.CB_1.config_dataB\[20\]
+ vssd1 vssd1 vccd1 vccd1 _02046_ sky130_fd_sc_hd__or3_2
XFILLER_100_418 vssd1 vssd1 vccd1 vccd1 sky130_fd_sc_hd__fill_2
X_08650_ _03669_ _03672_ _03683_ vssd1 vssd1 vccd1 vccd1 _03684_ sky130_fd_sc_hd__o21ai_1
XFILLER_82_836 vssd1 vssd1 vccd1 vccd1 sky130_fd_sc_hd__fill_1
XFILLER_81_313 vssd1 vssd1 vccd1 vccd1 sky130_fd_sc_hd__fill_1
XTAP_TAPCELL_ROW_68_1328 vssd1 vccd1 sky130_fd_sc_hd__tapvpwrvgnd_1
X_07601_ _02062_ _02650_ bus3_1\[0\] vssd1 vssd1 vccd1 vccd1 _02651_ sky130_fd_sc_hd__o21ai_1
XTAP_TAPCELL_ROW_1_317 vssd1 vccd1 sky130_fd_sc_hd__tapvpwrvgnd_1
XTAP_TAPCELL_ROW_1_328 vssd1 vccd1 sky130_fd_sc_hd__tapvpwrvgnd_1
XFILLER_93_195 vssd1 vssd1 vccd1 vccd1 sky130_fd_sc_hd__fill_2
XFILLER_82_847 vssd1 vssd1 vccd1 vccd1 sky130_fd_sc_hd__fill_1
XFILLER_81_335 vssd1 vssd1 vccd1 vccd1 sky130_fd_sc_hd__fill_1
XFILLER_19_292 vssd1 vssd1 vccd1 vccd1 sky130_fd_sc_hd__fill_8
X_08581_ cell1.CB_1.config_dataA\[14\] _03588_ _03590_ vssd1 vssd1 vccd1 vccd1 _03617_
+ sky130_fd_sc_hd__nand3_1
XTAP_TAPCELL_ROW_81_1517 vssd1 vccd1 sky130_fd_sc_hd__tapvpwrvgnd_1
X_07532_ cell0.SB0.route_sel\[126\] cell0.SB0.config_data_out vssd1 vssd1 vccd1 vccd1
+ _02583_ sky130_fd_sc_hd__nand2b_1
XTAP_TAPCELL_ROW_81_1528 vssd1 vccd1 sky130_fd_sc_hd__tapvpwrvgnd_1
XANTENNA__11433__B cell0.SB0.config_data_out vssd1 vssd1 vccd1 vccd1 sky130_fd_sc_hd__diode_2
X_07463_ cell1.SB0.route_sel\[113\] cell1.SB0.route_sel\[112\] _01547_ cell1.SB0.route_sel\[115\]
+ _02516_ vssd1 vssd1 vccd1 vccd1 _02517_ sky130_fd_sc_hd__o221a_1
XFILLER_139_109 vssd1 vssd1 vccd1 vccd1 sky130_fd_sc_hd__fill_2
X_09202_ net363 net362 _04228_ vssd1 vssd1 vccd1 vccd1 _04229_ sky130_fd_sc_hd__or3_1
X_06414_ cell0.SB0.route_sel\[118\] vssd1 vssd1 vccd1 vccd1 _01484_ sky130_fd_sc_hd__inv_2
X_07394_ bus3_2\[13\] _02448_ vssd1 vssd1 vccd1 vccd1 _02449_ sky130_fd_sc_hd__nand2_1
X_09133_ _04121_ _04123_ _04161_ vssd1 vssd1 vccd1 vccd1 _04163_ sky130_fd_sc_hd__o21a_1
XTAP_TAPCELL_ROW_20_603 vssd1 vccd1 sky130_fd_sc_hd__tapvpwrvgnd_1
XTAP_TAPCELL_ROW_20_614 vssd1 vccd1 sky130_fd_sc_hd__tapvpwrvgnd_1
XFILLER_136_805 vssd1 vssd1 vccd1 vccd1 sky130_fd_sc_hd__fill_4
XANTENNA_fanout318_A cell2.CB_1.le_outA vssd1 vssd1 vccd1 vccd1 sky130_fd_sc_hd__diode_2
XANTENNA__09838__B _04608_ vssd1 vssd1 vccd1 vccd1 sky130_fd_sc_hd__diode_2
XANTENNA__10982__A1 _05856_ vssd1 vssd1 vccd1 vccd1 sky130_fd_sc_hd__diode_2
XANTENNA__14188__SET_B net723 vssd1 vssd1 vccd1 vccd1 sky130_fd_sc_hd__diode_2
X_09064_ bus3_1\[8\] bus3_1\[9\] bus3_1\[10\] bus3_1\[11\] net479 net478 vssd1 vssd1
+ vccd1 vccd1 _04094_ sky130_fd_sc_hd__mux4_1
XFILLER_135_337 vssd1 vssd1 vccd1 vccd1 sky130_fd_sc_hd__fill_1
XANTENNA__10982__B2 _05861_ vssd1 vssd1 vccd1 vccd1 sky130_fd_sc_hd__diode_2
XFILLER_118_25 vssd1 vssd1 vccd1 vccd1 sky130_fd_sc_hd__fill_2
X_08015_ _03047_ _03054_ _03056_ _03053_ vssd1 vssd1 vccd1 vccd1 _03057_ sky130_fd_sc_hd__o211a_2
XFILLER_116_573 vssd1 vssd1 vccd1 vccd1 sky130_fd_sc_hd__fill_1
XANTENNA__08927__A1 bus3_1\[13\] vssd1 vssd1 vccd1 vccd1 sky130_fd_sc_hd__diode_2
XTAP_TAPCELL_ROW_9_439 vssd1 vccd1 sky130_fd_sc_hd__tapvpwrvgnd_1
XFILLER_2_829 vssd1 vssd1 vccd1 vccd1 sky130_fd_sc_hd__fill_2
XFILLER_103_223 vssd1 vssd1 vccd1 vccd1 sky130_fd_sc_hd__fill_1
XANTENNA_fanout687_A net691 vssd1 vssd1 vccd1 vccd1 sky130_fd_sc_hd__diode_2
XFILLER_1_317 vccd1 vssd1 vccd1 vssd1 sky130_ef_sc_hd__decap_40_12
XANTENNA__06830__X bus1_0\[6\] vssd1 vssd1 vccd1 vccd1 sky130_fd_sc_hd__diode_2
X_09966_ cell2.CB_1.config_dataB\[7\] _04959_ vssd1 vssd1 vccd1 vccd1 _04970_ sky130_fd_sc_hd__nand2b_1
X_09897_ _04897_ _04902_ cell2.CB_1.config_dataA\[19\] _04887_ vssd1 vssd1 vccd1 vccd1
+ _04903_ sky130_fd_sc_hd__a211oi_1
X_08917_ _01681_ _03944_ _03945_ _03948_ vssd1 vssd1 vccd1 vccd1 _03949_ sky130_fd_sc_hd__o2bb2a_1
XANTENNA_fanout854_A net855 vssd1 vssd1 vccd1 vccd1 sky130_fd_sc_hd__diode_2
XANTENNA__09352__B2 _04375_ vssd1 vssd1 vccd1 vccd1 sky130_fd_sc_hd__diode_2
Xclkbuf_leaf_96_clk clknet_4_10_0_clk vssd1 vssd1 vccd1 vccd1 clknet_leaf_96_clk sky130_fd_sc_hd__clkbuf_8
X_08848_ _01523_ cell1.SB0.route_sel\[60\] _01524_ cell1.SB0.route_sel\[63\] _03879_
+ vssd1 vssd1 vccd1 vccd1 _03880_ sky130_fd_sc_hd__a221o_1
XTAP_TAPCELL_ROW_123_2156 vssd1 vccd1 sky130_fd_sc_hd__tapvpwrvgnd_1
XFILLER_84_195 vssd1 vssd1 vccd1 vccd1 sky130_fd_sc_hd__fill_1
X_08779_ cell1.LE_1B.dff0_out cell1.LE_1B.dff1_out cell1.LE_1B.reset_val vssd1 vssd1
+ vccd1 vccd1 cell1.LE_1B.dff_out sky130_fd_sc_hd__mux2_1
XANTENNA__09104__A1 _03868_ vssd1 vssd1 vccd1 vccd1 sky130_fd_sc_hd__diode_2
XFILLER_27_55 vssd1 vssd1 vccd1 vccd1 sky130_fd_sc_hd__fill_1
XTAP_TAPCELL_ROW_28_725 vssd1 vccd1 sky130_fd_sc_hd__tapvpwrvgnd_1
X_10810_ cell3.CB_1.config_dataB\[13\] cell3.CB_1.config_dataB\[12\] vssd1 vssd1 vccd1
+ vccd1 _05766_ sky130_fd_sc_hd__nor2_1
X_11790_ net1120 net1196 net776 vssd1 vssd1 vccd1 vccd1 _00227_ sky130_fd_sc_hd__mux2_1
XANTENNA__09104__B2 _03871_ vssd1 vssd1 vccd1 vccd1 sky130_fd_sc_hd__diode_2
X_10741_ cell3.CB_1.config_dataB\[2\] _05696_ cell3.CB_1.config_dataB\[3\] vssd1 vssd1
+ vccd1 vccd1 _05697_ sky130_fd_sc_hd__a21bo_1
XANTENNA__08863__B1 _03894_ vssd1 vssd1 vccd1 vccd1 sky130_fd_sc_hd__diode_2
XANTENNA__07666__A1 bus2_0\[2\] vssd1 vssd1 vccd1 vccd1 sky130_fd_sc_hd__diode_2
XANTENNA__13327__SET_B net691 vssd1 vssd1 vccd1 vccd1 sky130_fd_sc_hd__diode_2
XANTENNA_fanout907_X net907 vssd1 vssd1 vccd1 vccd1 sky130_fd_sc_hd__diode_2
X_13460_ clknet_leaf_130_clk _00432_ net562 vssd1 vssd1 vccd1 vccd1 cell0.SB0.route_sel\[101\]
+ sky130_fd_sc_hd__dfstp_1
X_10672_ _05610_ _05614_ _05629_ cell3.CB_1.config_dataA\[14\] vssd1 vssd1 vccd1 vccd1
+ _05630_ sky130_fd_sc_hd__a211o_1
XANTENNA__09407__A2 _04425_ vssd1 vssd1 vccd1 vccd1 sky130_fd_sc_hd__diode_2
X_12411_ cell2.CB_1.config_dataB\[21\] cell2.CB_1.config_dataB\[20\] net830 vssd1
+ vssd1 vccd1 vccd1 _00844_ sky130_fd_sc_hd__mux2_1
XFILLER_43_87 vssd1 vssd1 vccd1 vccd1 sky130_fd_sc_hd__fill_1
XFILLER_127_816 vssd1 vssd1 vccd1 vccd1 sky130_fd_sc_hd__fill_4
XANTENNA__09748__B _04442_ vssd1 vssd1 vccd1 vccd1 sky130_fd_sc_hd__diode_2
Xclkbuf_leaf_20_clk clknet_4_4_0_clk vssd1 vssd1 vccd1 vccd1 clknet_leaf_20_clk sky130_fd_sc_hd__clkbuf_8
X_13391_ clknet_leaf_133_clk _00363_ net556 vssd1 vssd1 vccd1 vccd1 cell0.SB0.route_sel\[32\]
+ sky130_fd_sc_hd__dfstp_1
XANTENNA__08091__A1 bus2_0\[7\] vssd1 vssd1 vccd1 vccd1 sky130_fd_sc_hd__diode_2
X_12342_ cell1.SB0.route_sel\[80\] cell1.SB0.route_sel\[79\] net861 vssd1 vssd1 vccd1
+ vccd1 _00775_ sky130_fd_sc_hd__mux2_1
X_12273_ cell1.SB0.route_sel\[11\] cell1.SB0.route_sel\[10\] net866 vssd1 vssd1 vccd1
+ vccd1 _00706_ sky130_fd_sc_hd__mux2_1
XFILLER_4_133 vssd1 vssd1 vccd1 vccd1 sky130_fd_sc_hd__fill_4
X_11224_ cell3.LE_0B.config_data\[14\] cell3.LE_0B.config_data\[15\] _06076_ vssd1
+ vssd1 vccd1 vccd1 _06176_ sky130_fd_sc_hd__mux2_1
XANTENNA_clkbuf_4_12_0_clk_A clknet_0_clk vssd1 vssd1 vccd1 vccd1 sky130_fd_sc_hd__diode_2
X_14012_ clknet_leaf_79_clk _00984_ net707 vssd1 vssd1 vccd1 vccd1 cell3.SB0.route_sel\[20\]
+ sky130_fd_sc_hd__dfstp_2
XFILLER_4_15 vccd1 vssd1 vccd1 vssd1 sky130_ef_sc_hd__decap_40_12
XANTENNA__11358__X net190 vssd1 vssd1 vccd1 vccd1 sky130_fd_sc_hd__diode_2
XFILLER_4_177 vccd1 vssd1 vccd1 vssd1 sky130_ef_sc_hd__decap_40_12
X_11155_ cell3.CB_0.config_dataB\[9\] _06090_ _06104_ _06106_ vssd1 vssd1 vccd1 vccd1
+ _06107_ sky130_fd_sc_hd__o31a_2
XANTENNA_input36_X net36 vssd1 vssd1 vccd1 vccd1 sky130_fd_sc_hd__diode_2
X_11086_ _06039_ _05994_ vssd1 vssd1 vccd1 vccd1 _06040_ sky130_fd_sc_hd__and2b_1
XFILLER_122_587 vssd1 vssd1 vccd1 vccd1 sky130_fd_sc_hd__fill_1
X_10106_ _02538_ _05106_ vssd1 vssd1 vccd1 vccd1 _05107_ sky130_fd_sc_hd__and2_2
XFILLER_0_350 vssd1 vssd1 vccd1 vccd1 sky130_fd_sc_hd__fill_8
XANTENNA_output237_A net237 vssd1 vssd1 vccd1 vccd1 sky130_fd_sc_hd__diode_2
X_10037_ net400 _04696_ _05040_ net399 vssd1 vssd1 vccd1 vccd1 _05041_ sky130_fd_sc_hd__o211a_1
Xclkbuf_leaf_87_clk clknet_4_11_0_clk vssd1 vssd1 vccd1 vccd1 clknet_leaf_87_clk sky130_fd_sc_hd__clkbuf_8
XTAP_TAPCELL_ROW_108_1929 vssd1 vccd1 sky130_fd_sc_hd__tapvpwrvgnd_1
XFILLER_76_696 vssd1 vssd1 vccd1 vccd1 sky130_fd_sc_hd__fill_1
XANTENNA__13678__SET_B net622 vssd1 vssd1 vccd1 vccd1 sky130_fd_sc_hd__diode_2
XFILLER_91_666 vssd1 vssd1 vccd1 vccd1 sky130_fd_sc_hd__fill_2
XFILLER_16_251 vssd1 vssd1 vccd1 vccd1 sky130_fd_sc_hd__fill_1
X_11988_ cell0.SB0.route_sel\[94\] cell0.SB0.route_sel\[93\] net785 vssd1 vssd1 vccd1
+ vccd1 _00425_ sky130_fd_sc_hd__mux2_1
X_10939_ _04477_ _04484_ _04491_ _05892_ vssd1 vssd1 vccd1 vccd1 _05893_ sky130_fd_sc_hd__a211o_2
X_13727_ clknet_leaf_106_clk _00699_ net676 vssd1 vssd1 vccd1 vccd1 cell1.SB0.route_sel\[4\]
+ sky130_fd_sc_hd__dfstp_1
XTAP_TAPCELL_ROW_63_1258 vssd1 vccd1 sky130_fd_sc_hd__tapvpwrvgnd_1
XTAP_TAPCELL_ROW_63_1247 vssd1 vccd1 sky130_fd_sc_hd__tapvpwrvgnd_1
XFILLER_31_243 vssd1 vssd1 vccd1 vccd1 sky130_fd_sc_hd__fill_1
X_13658_ clknet_leaf_49_clk _00630_ net704 vssd1 vssd1 vccd1 vccd1 cell2.CB_1.config_dataA\[10\]
+ sky130_fd_sc_hd__dfstp_1
X_12609_ cell3.SB0.route_sel\[74\] cell3.SB0.route_sel\[73\] net876 vssd1 vssd1 vccd1
+ vccd1 _01038_ sky130_fd_sc_hd__mux2_1
Xclkbuf_leaf_11_clk clknet_4_3_0_clk vssd1 vssd1 vccd1 vccd1 clknet_leaf_11_clk sky130_fd_sc_hd__clkbuf_8
X_13589_ clknet_leaf_94_clk net1447 net692 vssd1 vssd1 vccd1 vccd1 cell1.LEI0.config_data\[10\]
+ sky130_fd_sc_hd__dfrtp_1
XANTENNA__10964__A1 cell3.CB_0.config_dataA\[0\] vssd1 vssd1 vccd1 vccd1 sky130_fd_sc_hd__diode_2
XFILLER_141_841 vssd1 vssd1 vccd1 vccd1 sky130_fd_sc_hd__fill_4
XFILLER_140_351 vssd1 vssd1 vccd1 vccd1 sky130_fd_sc_hd__fill_1
Xfanout429 cell2.CB_0.config_dataB\[10\] vssd1 vssd1 vccd1 vccd1 net429 sky130_fd_sc_hd__clkbuf_2
X_09820_ cell2.LEI0.config_data\[7\] _04825_ vssd1 vssd1 vccd1 vccd1 _04826_ sky130_fd_sc_hd__nor2_1
Xfanout407 cell2.CB_1.config_dataB\[5\] vssd1 vssd1 vccd1 vccd1 net407 sky130_fd_sc_hd__clkbuf_2
Xfanout418 cell2.CB_0.config_dataA\[5\] vssd1 vssd1 vccd1 vccd1 net418 sky130_fd_sc_hd__buf_2
XANTENNA__07465__Y _02518_ vssd1 vssd1 vccd1 vccd1 sky130_fd_sc_hd__diode_2
XANTENNA__08385__A2 _02424_ vssd1 vssd1 vccd1 vccd1 sky130_fd_sc_hd__diode_2
X_09751_ net443 net445 vssd1 vssd1 vccd1 vccd1 _04757_ sky130_fd_sc_hd__and2b_1
X_06963_ net343 _02028_ vssd1 vssd1 vccd1 vccd1 _02029_ sky130_fd_sc_hd__nor2_1
XANTENNA__10332__B _05084_ vssd1 vssd1 vccd1 vccd1 sky130_fd_sc_hd__diode_2
Xclkbuf_leaf_78_clk clknet_4_12_0_clk vssd1 vssd1 vccd1 vccd1 clknet_leaf_78_clk sky130_fd_sc_hd__clkbuf_8
X_08702_ cell1.LE_1B.config_data\[5\] cell1.LE_1B.config_data\[4\] _03735_ vssd1 vssd1
+ vccd1 vccd1 _03736_ sky130_fd_sc_hd__mux2_1
XFILLER_94_460 vssd1 vssd1 vccd1 vccd1 sky130_fd_sc_hd__fill_1
X_09682_ _02538_ _04695_ vssd1 vssd1 vccd1 vccd1 _04696_ sky130_fd_sc_hd__nand2_4
XANTENNA__09885__A2 bus3_2\[1\] vssd1 vssd1 vccd1 vccd1 sky130_fd_sc_hd__diode_2
X_06894_ cell1.CB_1.config_dataB\[24\] cell1.CB_1.config_dataB\[21\] cell1.CB_1.config_dataB\[20\]
+ vssd1 vssd1 vccd1 vccd1 _01962_ sky130_fd_sc_hd__and3b_1
XFILLER_82_633 vssd1 vssd1 vccd1 vccd1 sky130_fd_sc_hd__fill_4
XFILLER_66_195 vssd1 vssd1 vccd1 vccd1 sky130_fd_sc_hd__fill_1
XFILLER_55_847 vssd1 vssd1 vccd1 vccd1 sky130_fd_sc_hd__fill_1
X_08633_ _01668_ _03666_ _03667_ vssd1 vssd1 vccd1 vccd1 cell1.CB_1.le_outA sky130_fd_sc_hd__a21oi_1
XANTENNA__07896__A1 bus2_0\[13\] vssd1 vssd1 vccd1 vccd1 sky130_fd_sc_hd__diode_2
XFILLER_81_132 vssd1 vssd1 vccd1 vccd1 sky130_fd_sc_hd__fill_1
XFILLER_54_357 vssd1 vssd1 vccd1 vccd1 sky130_fd_sc_hd__fill_1
X_08564_ _03586_ _03589_ _03598_ _03599_ vssd1 vssd1 vccd1 vccd1 _03600_ sky130_fd_sc_hd__o22a_1
XANTENNA__10247__A3 net58 vssd1 vssd1 vccd1 vccd1 sky130_fd_sc_hd__diode_2
XANTENNA__08845__A0 bus3_1\[0\] vssd1 vssd1 vccd1 vccd1 sky130_fd_sc_hd__diode_2
X_07515_ net449 net450 _01962_ vssd1 vssd1 vccd1 vccd1 _02567_ sky130_fd_sc_hd__and3_1
XFILLER_80_19 vssd1 vssd1 vccd1 vccd1 sky130_fd_sc_hd__fill_1
X_08495_ cell1.SB0.route_sel\[48\] cell1.SB0.route_sel\[49\] vssd1 vssd1 vccd1 vccd1
+ _03531_ sky130_fd_sc_hd__nand2b_1
X_07446_ net88 _02497_ _01547_ _01548_ vssd1 vssd1 vccd1 vccd1 _02500_ sky130_fd_sc_hd__a211o_1
XFILLER_23_788 vssd1 vssd1 vccd1 vccd1 sky130_fd_sc_hd__fill_1
XANTENNA_fanout602_A net650 vssd1 vssd1 vccd1 vccd1 sky130_fd_sc_hd__diode_2
XFILLER_13_57 vccd1 vssd1 vccd1 vssd1 sky130_ef_sc_hd__decap_40_12
X_07377_ _02146_ _02358_ vssd1 vssd1 vccd1 vccd1 _02433_ sky130_fd_sc_hd__nor2_1
XFILLER_129_57 vssd1 vssd1 vccd1 vccd1 sky130_fd_sc_hd__fill_4
X_09116_ net477 _03817_ _04145_ cell1.CB_0.config_dataB\[16\] vssd1 vssd1 vccd1 vccd1
+ _04146_ sky130_fd_sc_hd__o211a_1
XANTENNA__07369__A _02422_ vssd1 vssd1 vccd1 vccd1 sky130_fd_sc_hd__diode_2
XFILLER_13_79 vssd1 vssd1 vccd1 vccd1 sky130_fd_sc_hd__fill_1
XTAP_TAPCELL_ROW_94_1719 vssd1 vccd1 sky130_fd_sc_hd__tapvpwrvgnd_1
X_09047_ net484 _04074_ _04075_ _04076_ vssd1 vssd1 vccd1 vccd1 _04077_ sky130_fd_sc_hd__a31o_1
XFILLER_135_178 vssd1 vssd1 vccd1 vccd1 sky130_fd_sc_hd__fill_1
XANTENNA__07656__X _02704_ vssd1 vssd1 vccd1 vccd1 sky130_fd_sc_hd__diode_2
Xhold450 _01454_ vssd1 vssd1 vccd1 vccd1 net1409 sky130_fd_sc_hd__dlygate4sd3_1
Xhold472 cell3.LEI0.config_data\[7\] vssd1 vssd1 vccd1 vccd1 net1431 sky130_fd_sc_hd__dlygate4sd3_1
XANTENNA__10707__A1 _05504_ vssd1 vssd1 vccd1 vccd1 sky130_fd_sc_hd__diode_2
XANTENNA_fanout592_X net592 vssd1 vssd1 vccd1 vccd1 sky130_fd_sc_hd__diode_2
Xhold461 _00221_ vssd1 vssd1 vccd1 vccd1 net1420 sky130_fd_sc_hd__dlygate4sd3_1
XFILLER_2_637 vssd1 vssd1 vccd1 vccd1 sky130_fd_sc_hd__fill_4
XFILLER_1_125 vccd1 vssd1 vccd1 vssd1 sky130_ef_sc_hd__decap_40_12
Xhold494 cell3.LEI0.config_data\[14\] vssd1 vssd1 vccd1 vccd1 net1453 sky130_fd_sc_hd__dlygate4sd3_1
Xhold483 _00214_ vssd1 vssd1 vccd1 vccd1 net1442 sky130_fd_sc_hd__dlygate4sd3_1
Xfanout952 net959 vssd1 vssd1 vccd1 vccd1 net952 sky130_fd_sc_hd__buf_2
Xfanout930 net933 vssd1 vssd1 vccd1 vccd1 net930 sky130_fd_sc_hd__clkbuf_4
Xfanout941 net943 vssd1 vssd1 vccd1 vccd1 net941 sky130_fd_sc_hd__clkbuf_4
XANTENNA__10183__A2 _05113_ vssd1 vssd1 vccd1 vccd1 sky130_fd_sc_hd__diode_2
X_09949_ cell2.CB_1.config_dataB\[3\] cell2.CB_1.config_dataB\[2\] _04924_ vssd1 vssd1
+ vccd1 vccd1 _04953_ sky130_fd_sc_hd__or3b_1
XFILLER_77_416 vssd1 vssd1 vccd1 vccd1 sky130_fd_sc_hd__fill_1
XANTENNA__08781__C1 net352 vssd1 vssd1 vccd1 vccd1 sky130_fd_sc_hd__diode_2
XFILLER_1_169 vccd1 vssd1 vccd1 vssd1 sky130_ef_sc_hd__decap_40_12
Xclkbuf_leaf_69_clk clknet_4_14_0_clk vssd1 vssd1 vccd1 vccd1 clknet_leaf_69_clk sky130_fd_sc_hd__clkbuf_8
XANTENNA__11132__A1 net50 vssd1 vssd1 vccd1 vccd1 sky130_fd_sc_hd__diode_2
X_12960_ net1340 net1216 net927 vssd1 vssd1 vccd1 vccd1 _01388_ sky130_fd_sc_hd__mux2_1
XANTENNA__08679__A3 net7 vssd1 vssd1 vccd1 vccd1 sky130_fd_sc_hd__diode_2
XFILLER_18_516 vssd1 vssd1 vccd1 vccd1 sky130_fd_sc_hd__fill_1
XANTENNA__07391__X bus1_0\[13\] vssd1 vssd1 vccd1 vccd1 sky130_fd_sc_hd__diode_2
X_12891_ cell3.CB_1.config_dataB\[5\] cell3.CB_1.config_dataB\[4\] net947 vssd1 vssd1
+ vccd1 vccd1 _01320_ sky130_fd_sc_hd__mux2_1
XFILLER_85_493 vssd1 vssd1 vccd1 vccd1 sky130_fd_sc_hd__fill_2
XANTENNA__07887__A1 bus2_0\[1\] vssd1 vssd1 vccd1 vccd1 sky130_fd_sc_hd__diode_2
X_11911_ cell0.SB0.route_sel\[17\] cell0.SB0.route_sel\[16\] net762 vssd1 vssd1 vccd1
+ vccd1 _00348_ sky130_fd_sc_hd__mux2_1
XFILLER_72_143 vssd1 vssd1 vccd1 vccd1 sky130_fd_sc_hd__fill_1
X_11842_ cell1.CB_1.config_dataA\[23\] cell1.CB_1.config_dataA\[22\] net885 vssd1
+ vssd1 vccd1 vccd1 _00279_ sky130_fd_sc_hd__mux2_1
XANTENNA__09628__A2 _02377_ vssd1 vssd1 vccd1 vccd1 sky130_fd_sc_hd__diode_2
XFILLER_72_165 vssd1 vssd1 vccd1 vccd1 sky130_fd_sc_hd__fill_2
XANTENNA__07639__A1 net12 vssd1 vssd1 vccd1 vccd1 sky130_fd_sc_hd__diode_2
XFILLER_26_582 vssd1 vssd1 vccd1 vccd1 sky130_fd_sc_hd__fill_1
XTAP_TAPCELL_ROW_103_1859 vssd1 vccd1 sky130_fd_sc_hd__tapvpwrvgnd_1
XTAP_TAPCELL_ROW_103_1848 vssd1 vccd1 sky130_fd_sc_hd__tapvpwrvgnd_1
X_13512_ clknet_1_0__leaf_cell1.LE_1B.sel_clk _00484_ net753 vssd1 vssd1 vccd1 vccd1
+ cell1.LE_1B.dff0_out sky130_fd_sc_hd__dfrtp_1
X_11773_ net1226 net1337 net792 vssd1 vssd1 vccd1 vccd1 _00210_ sky130_fd_sc_hd__mux2_1
XFILLER_13_210 vssd1 vssd1 vccd1 vccd1 sky130_fd_sc_hd__fill_2
XANTENNA__07270__C net349 vssd1 vssd1 vccd1 vccd1 sky130_fd_sc_hd__diode_2
X_10724_ _05561_ _05681_ _05680_ _05638_ vssd1 vssd1 vccd1 vccd1 _05682_ sky130_fd_sc_hd__o211a_1
XFILLER_9_203 vssd1 vssd1 vccd1 vccd1 sky130_fd_sc_hd__fill_1
XANTENNA__11199__A1 _05898_ vssd1 vssd1 vccd1 vccd1 sky130_fd_sc_hd__diode_2
X_10655_ _05554_ _05602_ _05603_ _05549_ cell3.CB_1.config_dataA\[12\] vssd1 vssd1
+ vccd1 vccd1 _05613_ sky130_fd_sc_hd__a221o_1
XFILLER_9_247 vssd1 vssd1 vccd1 vccd1 sky130_fd_sc_hd__fill_4
X_13443_ clknet_leaf_129_clk _00415_ net578 vssd1 vssd1 vccd1 vccd1 cell0.SB0.route_sel\[84\]
+ sky130_fd_sc_hd__dfstp_2
XTAP_TAPCELL_ROW_136_2347 vssd1 vccd1 sky130_fd_sc_hd__tapvpwrvgnd_1
X_13374_ clknet_leaf_132_clk _00346_ net558 vssd1 vssd1 vccd1 vccd1 cell0.SB0.route_sel\[15\]
+ sky130_fd_sc_hd__dfstp_1
Xclkload17 clknet_leaf_130_clk vssd1 vssd1 vccd1 vccd1 clkload17/Y sky130_fd_sc_hd__inv_6
XANTENNA_output187_A net187 vssd1 vssd1 vccd1 vccd1 sky130_fd_sc_hd__diode_2
X_10586_ _05543_ vssd1 vssd1 vccd1 vccd1 _05544_ sky130_fd_sc_hd__inv_2
Xclkload39 clknet_leaf_119_clk vssd1 vssd1 vccd1 vccd1 clkload39/Y sky130_fd_sc_hd__bufinv_16
Xclkload28 clknet_leaf_10_clk vssd1 vssd1 vccd1 vccd1 clkload28/Y sky130_fd_sc_hd__clkinv_1
XFILLER_5_431 vccd1 vssd1 vccd1 vssd1 sky130_ef_sc_hd__decap_40_12
XTAP_TAPCELL_ROW_11_466 vssd1 vccd1 sky130_fd_sc_hd__tapvpwrvgnd_1
X_12325_ cell1.SB0.route_sel\[63\] cell1.SB0.route_sel\[62\] net856 vssd1 vssd1 vccd1
+ vccd1 _00758_ sky130_fd_sc_hd__mux2_1
XTAP_TAPCELL_ROW_11_477 vssd1 vccd1 sky130_fd_sc_hd__tapvpwrvgnd_1
XFILLER_114_307 vssd1 vssd1 vccd1 vccd1 sky130_fd_sc_hd__fill_1
X_12256_ cell2.CB_0.config_dataA\[19\] cell2.CB_0.config_dataA\[18\] net823 vssd1
+ vssd1 vccd1 vccd1 _00689_ sky130_fd_sc_hd__mux2_1
X_11207_ _06152_ _06158_ _06150_ vssd1 vssd1 vccd1 vccd1 _06159_ sky130_fd_sc_hd__a21oi_1
X_12187_ cell2.CB_1.config_dataA\[0\] cell2.CB_0.config_dataB\[24\] net840 vssd1 vssd1
+ vccd1 vccd1 _00620_ sky130_fd_sc_hd__mux2_1
X_11138_ cell3.CB_0.config_dataB\[8\] _06082_ _06086_ _06089_ vssd1 vssd1 vccd1 vccd1
+ _06090_ sky130_fd_sc_hd__and4_1
XFILLER_68_416 vssd1 vssd1 vccd1 vccd1 sky130_fd_sc_hd__fill_4
XANTENNA__07575__B1 bus2_0\[0\] vssd1 vssd1 vccd1 vccd1 sky130_fd_sc_hd__diode_2
X_11069_ cell3.CB_0.config_dataA\[18\] _06002_ _06004_ _06009_ cell3.CB_0.config_dataA\[19\]
+ vssd1 vssd1 vccd1 vccd1 _06023_ sky130_fd_sc_hd__a41o_1
XFILLER_76_460 vssd1 vssd1 vccd1 vccd1 sky130_fd_sc_hd__fill_1
Xclkbuf_leaf_0_clk clknet_4_0_0_clk vssd1 vssd1 vccd1 vccd1 clknet_leaf_0_clk sky130_fd_sc_hd__clkbuf_8
XFILLER_91_430 vssd1 vssd1 vccd1 vccd1 sky130_fd_sc_hd__fill_4
XANTENNA__07878__A1 _02890_ vssd1 vssd1 vccd1 vccd1 sky130_fd_sc_hd__diode_2
XFILLER_37_847 vssd1 vssd1 vccd1 vccd1 sky130_fd_sc_hd__fill_1
XFILLER_64_699 vssd1 vssd1 vccd1 vccd1 sky130_fd_sc_hd__fill_1
XTAP_TAPCELL_ROW_19_588 vssd1 vccd1 sky130_fd_sc_hd__tapvpwrvgnd_1
XTAP_TAPCELL_ROW_19_599 vssd1 vccd1 sky130_fd_sc_hd__tapvpwrvgnd_1
X_07300_ cell1.CB_1.config_dataA\[23\] cell1.CB_1.config_dataA\[22\] vssd1 vssd1 vccd1
+ vccd1 _02358_ sky130_fd_sc_hd__nand2_1
X_08280_ _02136_ _03315_ _03317_ _02040_ vssd1 vssd1 vccd1 vccd1 _03318_ sky130_fd_sc_hd__o2bb2a_1
XANTENNA__11270__Y net196 vssd1 vssd1 vccd1 vccd1 sky130_fd_sc_hd__diode_2
X_07231_ net327 _02290_ vssd1 vssd1 vccd1 vccd1 _02291_ sky130_fd_sc_hd__nand2_1
XFILLER_20_747 vssd1 vssd1 vccd1 vccd1 sky130_fd_sc_hd__fill_1
XANTENNA__10608__A net398 vssd1 vssd1 vccd1 vccd1 sky130_fd_sc_hd__diode_2
X_07162_ _02223_ vssd1 vssd1 vccd1 vccd1 _02224_ sky130_fd_sc_hd__inv_2
XTAP_TAPCELL_ROW_30_753 vssd1 vccd1 sky130_fd_sc_hd__tapvpwrvgnd_1
XTAP_TAPCELL_ROW_30_764 vssd1 vccd1 sky130_fd_sc_hd__tapvpwrvgnd_1
XFILLER_8_280 vssd1 vssd1 vccd1 vccd1 sky130_fd_sc_hd__fill_4
XTAP_TAPCELL_ROW_76_1449 vssd1 vccd1 sky130_fd_sc_hd__tapvpwrvgnd_1
X_07093_ net328 _02152_ _02155_ _02156_ vssd1 vssd1 vccd1 vccd1 _02157_ sky130_fd_sc_hd__o22a_1
XANTENNA__07195__Y bus2_0\[10\] vssd1 vssd1 vccd1 vccd1 sky130_fd_sc_hd__diode_2
XFILLER_115_15 vccd1 vssd1 vccd1 vssd1 sky130_ef_sc_hd__decap_40_12
XANTENNA__10165__A2 _05131_ vssd1 vssd1 vccd1 vccd1 sky130_fd_sc_hd__diode_2
X_09803_ bus3_2\[0\] bus3_2\[2\] bus3_2\[1\] bus3_2\[3\] net446 net447 vssd1 vssd1
+ vccd1 vccd1 _04809_ sky130_fd_sc_hd__mux4_1
X_07995_ bus2_0\[8\] bus2_0\[9\] bus2_0\[10\] bus2_0\[11\] net531 net529 vssd1 vssd1
+ vccd1 vccd1 _03037_ sky130_fd_sc_hd__mux4_1
XANTENNA__11873__S net883 vssd1 vssd1 vccd1 vccd1 sky130_fd_sc_hd__diode_2
XANTENNA__09851__B _04498_ vssd1 vssd1 vccd1 vccd1 sky130_fd_sc_hd__diode_2
X_09734_ cell2.SB0.route_sel\[15\] cell2.SB0.route_sel\[14\] vssd1 vssd1 vccd1 vccd1
+ _04745_ sky130_fd_sc_hd__or2_1
X_06946_ cell0.CB_1.config_dataA\[22\] cell0.CB_1.config_dataA\[23\] vssd1 vssd1 vccd1
+ vccd1 _02012_ sky130_fd_sc_hd__and2b_1
XANTENNA_fanout552_A _01495_ vssd1 vssd1 vccd1 vccd1 sky130_fd_sc_hd__diode_2
X_09665_ net22 net288 _04679_ vssd1 vssd1 vccd1 vccd1 _04680_ sky130_fd_sc_hd__mux2_1
XFILLER_67_471 vssd1 vssd1 vccd1 vccd1 sky130_fd_sc_hd__fill_2
X_06877_ net343 _01863_ _01943_ vssd1 vssd1 vccd1 vccd1 _01945_ sky130_fd_sc_hd__or3_1
XTAP_TAPCELL_ROW_120_2104 vssd1 vccd1 sky130_fd_sc_hd__tapvpwrvgnd_1
XFILLER_43_817 vssd1 vssd1 vccd1 vccd1 sky130_fd_sc_hd__fill_1
XANTENNA__08530__A2 _03493_ vssd1 vssd1 vccd1 vccd1 sky130_fd_sc_hd__diode_2
X_08616_ cell1.CB_1.config_dataA\[19\] _03624_ _03628_ _03651_ vssd1 vssd1 vccd1 vccd1
+ _03652_ sky130_fd_sc_hd__a31o_1
XFILLER_131_69 vssd1 vssd1 vccd1 vccd1 sky130_fd_sc_hd__fill_1
XTAP_TAPCELL_ROW_120_2115 vssd1 vccd1 sky130_fd_sc_hd__tapvpwrvgnd_1
X_09596_ _02290_ _02295_ _03843_ _02291_ vssd1 vssd1 vccd1 vccd1 _04613_ sky130_fd_sc_hd__o31a_1
XFILLER_42_305 vssd1 vssd1 vccd1 vccd1 sky130_fd_sc_hd__fill_1
XTAP_TAPCELL_ROW_38_875 vssd1 vccd1 sky130_fd_sc_hd__tapvpwrvgnd_1
XANTENNA_fanout817_A net828 vssd1 vssd1 vccd1 vccd1 sky130_fd_sc_hd__diode_2
XFILLER_70_658 vssd1 vssd1 vccd1 vccd1 sky130_fd_sc_hd__fill_1
XANTENNA_fanout340_X net340 vssd1 vssd1 vccd1 vccd1 sky130_fd_sc_hd__diode_2
X_08547_ cell1.CB_1.config_dataA\[9\] _03550_ _03554_ _03582_ vssd1 vssd1 vccd1 vccd1
+ _03583_ sky130_fd_sc_hd__a31oi_4
XANTENNA__09579__A net51 vssd1 vssd1 vccd1 vccd1 sky130_fd_sc_hd__diode_2
X_08478_ _02698_ _03513_ vssd1 vssd1 vccd1 vccd1 _03514_ sky130_fd_sc_hd__nand2_4
X_07429_ _02482_ _02478_ _02479_ vssd1 vssd1 vccd1 vccd1 _02483_ sky130_fd_sc_hd__mux2_1
X_10440_ _01699_ cell3.SB0.route_sel\[34\] _01702_ cell3.SB0.route_sel\[37\] _05433_
+ vssd1 vssd1 vccd1 vccd1 _05434_ sky130_fd_sc_hd__a221o_1
XFILLER_7_729 vccd1 vssd1 vccd1 vssd1 sky130_ef_sc_hd__decap_40_12
XTAP_TAPCELL_ROW_118_2077 vssd1 vccd1 sky130_fd_sc_hd__tapvpwrvgnd_1
X_10371_ _05093_ _05348_ _05368_ cell2.CB_0.config_dataB\[12\] vssd1 vssd1 vccd1 vccd1
+ _05370_ sky130_fd_sc_hd__a211oi_1
XANTENNA__08597__A2 _03533_ vssd1 vssd1 vccd1 vccd1 sky130_fd_sc_hd__diode_2
XTAP_TAPCELL_ROW_131_2266 vssd1 vccd1 sky130_fd_sc_hd__tapvpwrvgnd_1
X_12110_ net1003 cell1.LE_0A.config_data\[14\] net879 vssd1 vssd1 vccd1 vccd1 _00544_
+ sky130_fd_sc_hd__mux2_1
X_13090_ clknet_leaf_3_clk _00062_ net571 vssd1 vssd1 vccd1 vccd1 cell0.CB_0.config_dataB\[17\]
+ sky130_fd_sc_hd__dfstp_1
XFILLER_2_401 vccd1 vssd1 vccd1 vssd1 sky130_ef_sc_hd__decap_40_12
XTAP_TAPCELL_ROW_131_2277 vssd1 vccd1 sky130_fd_sc_hd__tapvpwrvgnd_1
Xhold280 _00589_ vssd1 vssd1 vccd1 vccd1 net1239 sky130_fd_sc_hd__dlygate4sd3_1
X_12041_ cell1.CB_1.config_dataB\[19\] cell1.CB_1.config_dataB\[18\] net892 vssd1
+ vssd1 vccd1 vccd1 _00478_ sky130_fd_sc_hd__mux2_1
XFILLER_6_3 vccd1 vssd1 vccd1 vssd1 sky130_ef_sc_hd__decap_40_12
XFILLER_2_445 vccd1 vssd1 vccd1 vssd1 sky130_ef_sc_hd__decap_40_12
Xhold291 cell3.LE_0B.config_data\[10\] vssd1 vssd1 vccd1 vccd1 net1250 sky130_fd_sc_hd__dlygate4sd3_1
XANTENNA__09010__A3 bus3_1\[15\] vssd1 vssd1 vccd1 vccd1 sky130_fd_sc_hd__diode_2
XFILLER_2_489 vccd1 vssd1 vccd1 vssd1 sky130_ef_sc_hd__decap_40_12
Xfanout760 net768 vssd1 vssd1 vccd1 vccd1 net760 sky130_fd_sc_hd__clkbuf_4
XFILLER_77_279 vssd1 vssd1 vccd1 vccd1 sky130_fd_sc_hd__fill_1
X_13992_ clknet_leaf_74_clk _00964_ net727 vssd1 vssd1 vccd1 vccd1 cell3.SB0.route_sel\[0\]
+ sky130_fd_sc_hd__dfstp_1
Xfanout771 net773 vssd1 vssd1 vccd1 vccd1 net771 sky130_fd_sc_hd__clkbuf_4
Xfanout793 net794 vssd1 vssd1 vccd1 vccd1 net793 sky130_fd_sc_hd__buf_2
XFILLER_1_27 vccd1 vssd1 vccd1 vssd1 sky130_ef_sc_hd__decap_40_12
Xfanout782 net783 vssd1 vssd1 vccd1 vccd1 net782 sky130_fd_sc_hd__buf_2
X_12943_ net1061 cell3.LE_0B.config_data\[7\] net932 vssd1 vssd1 vccd1 vccd1 _01371_
+ sky130_fd_sc_hd__mux2_1
XFILLER_105_81 vssd1 vssd1 vccd1 vccd1 sky130_fd_sc_hd__fill_4
XFILLER_18_324 vssd1 vssd1 vccd1 vccd1 sky130_fd_sc_hd__fill_8
XANTENNA_clkbuf_leaf_64_clk_A clknet_4_15_0_clk vssd1 vssd1 vccd1 vccd1 sky130_fd_sc_hd__diode_2
XANTENNA__10864__A0 _05501_ vssd1 vssd1 vccd1 vccd1 sky130_fd_sc_hd__diode_2
XFILLER_73_463 vssd1 vssd1 vccd1 vccd1 sky130_fd_sc_hd__fill_4
XTAP_TAPCELL_ROW_47_1006 vssd1 vccd1 sky130_fd_sc_hd__tapvpwrvgnd_1
X_12874_ cell2.SB0.route_sel\[116\] cell2.SB0.route_sel\[115\] net818 vssd1 vssd1
+ vccd1 vccd1 _01303_ sky130_fd_sc_hd__mux2_1
XFILLER_46_699 vssd1 vssd1 vccd1 vccd1 sky130_fd_sc_hd__fill_1
XTAP_TAPCELL_ROW_47_1017 vssd1 vccd1 sky130_fd_sc_hd__tapvpwrvgnd_1
XANTENNA__12605__A1 cell3.SB0.route_sel\[69\] vssd1 vssd1 vccd1 vccd1 sky130_fd_sc_hd__diode_2
XTAP_TAPCELL_ROW_16_547 vssd1 vccd1 sky130_fd_sc_hd__tapvpwrvgnd_1
X_11825_ net493 net494 net888 vssd1 vssd1 vccd1 vccd1 _00262_ sky130_fd_sc_hd__mux2_1
X_11756_ cell0.LEI0.config_data\[6\] net1540 net796 vssd1 vssd1 vccd1 vccd1 _00193_
+ sky130_fd_sc_hd__mux2_1
XTAP_TAPCELL_ROW_60_1206 vssd1 vccd1 sky130_fd_sc_hd__tapvpwrvgnd_1
XFILLER_60_168 vssd1 vssd1 vccd1 vccd1 sky130_fd_sc_hd__fill_1
XFILLER_41_360 vssd1 vssd1 vccd1 vccd1 sky130_fd_sc_hd__fill_1
X_14475_ clknet_leaf_61_clk _01447_ net738 vssd1 vssd1 vccd1 vccd1 cell3.LEI0.config_data\[40\]
+ sky130_fd_sc_hd__dfrtp_1
X_10707_ _05501_ _05504_ net391 vssd1 vssd1 vccd1 vccd1 _05665_ sky130_fd_sc_hd__mux2_1
XANTENNA_clkbuf_leaf_79_clk_A clknet_4_12_0_clk vssd1 vssd1 vccd1 vccd1 sky130_fd_sc_hd__diode_2
XFILLER_14_585 vssd1 vssd1 vccd1 vccd1 sky130_fd_sc_hd__fill_2
XANTENNA__13944__RESET_B net635 vssd1 vssd1 vccd1 vccd1 sky130_fd_sc_hd__diode_2
XANTENNA__10631__A3 net11 vssd1 vssd1 vccd1 vccd1 sky130_fd_sc_hd__diode_2
XANTENNA__08037__A1 bus2_0\[7\] vssd1 vssd1 vccd1 vccd1 sky130_fd_sc_hd__diode_2
X_11687_ net1293 net1152 net802 vssd1 vssd1 vccd1 vccd1 _00127_ sky130_fd_sc_hd__mux2_1
X_13426_ clknet_leaf_1_clk _00398_ net560 vssd1 vssd1 vccd1 vccd1 cell0.SB0.route_sel\[67\]
+ sky130_fd_sc_hd__dfstp_1
XANTENNA_clkbuf_leaf_122_clk_A clknet_4_3_0_clk vssd1 vssd1 vccd1 vccd1 sky130_fd_sc_hd__diode_2
Xclkload128 clknet_leaf_63_clk vssd1 vssd1 vccd1 vccd1 clkload128/Y sky130_fd_sc_hd__inv_16
Xclkload117 clknet_leaf_70_clk vssd1 vssd1 vccd1 vccd1 clkload117/Y sky130_fd_sc_hd__clkinv_2
X_10638_ _05571_ _05580_ _05584_ _05595_ vssd1 vssd1 vccd1 vccd1 _05596_ sky130_fd_sc_hd__a22o_1
Xclkload106 clknet_leaf_78_clk vssd1 vssd1 vccd1 vccd1 clkload106/Y sky130_fd_sc_hd__clkinv_4
XANTENNA__09001__B _03881_ vssd1 vssd1 vccd1 vccd1 sky130_fd_sc_hd__diode_2
Xclkload139 clknet_1_1__leaf_cell2.LE_1A.sel_clk vssd1 vssd1 vccd1 vccd1 clkload139/X
+ sky130_fd_sc_hd__clkbuf_4
X_10569_ _01739_ cell3.SB0.route_sel\[103\] _05526_ vssd1 vssd1 vccd1 vccd1 _05527_
+ sky130_fd_sc_hd__o21ai_2
X_13357_ clknet_leaf_116_clk _00329_ net666 vssd1 vssd1 vccd1 vccd1 cell1.CB_0.config_dataA\[23\]
+ sky130_fd_sc_hd__dfstp_1
XANTENNA__10395__A2 net34 vssd1 vssd1 vccd1 vccd1 sky130_fd_sc_hd__diode_2
X_13288_ clknet_leaf_94_clk _00260_ net692 vssd1 vssd1 vccd1 vccd1 cell1.CB_1.config_dataA\[4\]
+ sky130_fd_sc_hd__dfstp_1
XFILLER_5_272 vssd1 vssd1 vccd1 vccd1 sky130_fd_sc_hd__fill_8
X_12308_ cell1.SB0.route_sel\[46\] cell1.SB0.route_sel\[45\] net858 vssd1 vssd1 vccd1
+ vccd1 _00741_ sky130_fd_sc_hd__mux2_1
XANTENNA__07796__B1 _02840_ vssd1 vssd1 vccd1 vccd1 sky130_fd_sc_hd__diode_2
XFILLER_130_608 vssd1 vssd1 vccd1 vccd1 sky130_fd_sc_hd__fill_1
X_12239_ cell2.CB_0.config_dataA\[2\] net420 net818 vssd1 vssd1 vccd1 vccd1 _00672_
+ sky130_fd_sc_hd__mux2_1
XTAP_TAPCELL_ROW_58_1179 vssd1 vccd1 sky130_fd_sc_hd__tapvpwrvgnd_1
XANTENNA_clkbuf_leaf_17_clk_A clknet_4_6_0_clk vssd1 vssd1 vccd1 vccd1 sky130_fd_sc_hd__diode_2
XFILLER_39_3 vccd1 vssd1 vccd1 vssd1 sky130_ef_sc_hd__decap_40_12
XTAP_TAPCELL_ROW_71_1379 vssd1 vccd1 sky130_fd_sc_hd__tapvpwrvgnd_1
XTAP_TAPCELL_ROW_71_1368 vssd1 vccd1 sky130_fd_sc_hd__tapvpwrvgnd_1
XANTENNA__08839__Y _03871_ vssd1 vssd1 vccd1 vccd1 sky130_fd_sc_hd__diode_2
XANTENNA__10450__X bus3_2\[7\] vssd1 vssd1 vccd1 vccd1 sky130_fd_sc_hd__diode_2
X_06800_ _01867_ net359 bus2_0\[6\] vssd1 vssd1 vccd1 vccd1 _01870_ sky130_fd_sc_hd__o21a_1
XANTENNA__11546__X net241 vssd1 vssd1 vccd1 vccd1 sky130_fd_sc_hd__diode_2
X_07780_ _02109_ net349 _01848_ vssd1 vssd1 vccd1 vccd1 _02825_ sky130_fd_sc_hd__and3b_1
X_06731_ cell3.CB_0.config_dataB\[17\] vssd1 vssd1 vccd1 vccd1 _01801_ sky130_fd_sc_hd__inv_2
Xinput4 CBeast_in[12] vssd1 vssd1 vccd1 vccd1 net4 sky130_fd_sc_hd__clkbuf_4
X_09450_ net300 _04471_ vssd1 vssd1 vccd1 vccd1 _04472_ sky130_fd_sc_hd__nand2_4
XANTENNA__08512__A2 _03504_ vssd1 vssd1 vccd1 vccd1 sky130_fd_sc_hd__diode_2
X_06662_ cell3.SB0.route_sel\[89\] vssd1 vssd1 vccd1 vccd1 _01732_ sky130_fd_sc_hd__inv_2
X_08401_ bus1_0\[4\] _03420_ _03422_ bus1_0\[5\] cell0.CB_1.config_dataB\[18\] vssd1
+ vssd1 vccd1 vccd1 _03439_ sky130_fd_sc_hd__a221o_1
XFILLER_37_699 vssd1 vssd1 vccd1 vccd1 sky130_fd_sc_hd__fill_4
X_09381_ _04210_ _04403_ vssd1 vssd1 vccd1 vccd1 _04405_ sky130_fd_sc_hd__nor2_1
X_06593_ cell1.LEI0.config_data\[8\] vssd1 vssd1 vccd1 vccd1 _01663_ sky130_fd_sc_hd__inv_2
XTAP_TAPCELL_ROW_35_834 vssd1 vccd1 sky130_fd_sc_hd__tapvpwrvgnd_1
X_08332_ bus1_0\[8\] bus1_0\[9\] bus1_0\[10\] bus1_0\[11\] net509 net508 vssd1 vssd1
+ vccd1 vccd1 _03370_ sky130_fd_sc_hd__mux4_1
X_08263_ _03302_ _03265_ _03263_ vssd1 vssd1 vccd1 vccd1 _03303_ sky130_fd_sc_hd__mux2_1
XFILLER_20_533 vssd1 vssd1 vccd1 vccd1 sky130_fd_sc_hd__fill_2
XANTENNA_clkbuf_4_0_0_clk_A clknet_0_clk vssd1 vssd1 vccd1 vccd1 sky130_fd_sc_hd__diode_2
X_07214_ cell0.SB0.route_sel\[88\] cell0.SB0.route_sel\[89\] _02267_ _02273_ net785
+ vssd1 vssd1 vccd1 vccd1 _02274_ sky130_fd_sc_hd__a311o_4
XANTENNA__11032__A0 _05912_ vssd1 vssd1 vccd1 vccd1 sky130_fd_sc_hd__diode_2
X_08194_ net538 net539 vssd1 vssd1 vccd1 vccd1 _03234_ sky130_fd_sc_hd__nor2_1
XANTENNA__09776__B2 _04399_ vssd1 vssd1 vccd1 vccd1 sky130_fd_sc_hd__diode_2
XANTENNA__08579__A2 net336 vssd1 vssd1 vccd1 vccd1 sky130_fd_sc_hd__diode_2
X_07145_ cell0.SB0.route_sel\[80\] cell0.SB0.route_sel\[81\] _02203_ _02206_ vssd1
+ vssd1 vccd1 vccd1 _02207_ sky130_fd_sc_hd__o2bb2a_1
X_07076_ _02112_ _02137_ _02139_ vssd1 vssd1 vccd1 vccd1 _02140_ sky130_fd_sc_hd__a21o_1
XFILLER_126_25 vssd1 vssd1 vccd1 vccd1 sky130_fd_sc_hd__fill_2
XANTENNA__10791__C1 _05503_ vssd1 vssd1 vccd1 vccd1 sky130_fd_sc_hd__diode_2
XFILLER_126_69 vssd1 vssd1 vccd1 vccd1 sky130_fd_sc_hd__fill_1
XFILLER_86_29 vccd1 vssd1 vccd1 vssd1 sky130_ef_sc_hd__decap_40_12
XANTENNA__08200__A1 _02037_ vssd1 vssd1 vccd1 vccd1 sky130_fd_sc_hd__diode_2
X_07978_ _03021_ _03020_ _02917_ vssd1 vssd1 vccd1 vccd1 _03022_ sky130_fd_sc_hd__mux2_1
XANTENNA_fanout767_A net768 vssd1 vssd1 vccd1 vccd1 sky130_fd_sc_hd__diode_2
XFILLER_142_57 vssd1 vssd1 vccd1 vccd1 sky130_fd_sc_hd__fill_1
XANTENNA__11099__A0 net53 vssd1 vssd1 vccd1 vccd1 sky130_fd_sc_hd__diode_2
XANTENNA__09840__A1_N _04527_ vssd1 vssd1 vccd1 vccd1 sky130_fd_sc_hd__diode_2
X_09717_ net25 net287 _04728_ vssd1 vssd1 vccd1 vccd1 _04730_ sky130_fd_sc_hd__mux2_1
X_06929_ _01901_ _01995_ vssd1 vssd1 vccd1 vccd1 _01996_ sky130_fd_sc_hd__or2_1
XANTENNA_fanout934_A net959 vssd1 vssd1 vccd1 vccd1 sky130_fd_sc_hd__diode_2
X_09648_ cell3.SB0.route_sel\[96\] _01736_ cell3.SB0.route_sel\[99\] _01738_ _04663_
+ vssd1 vssd1 vccd1 vccd1 _04664_ sky130_fd_sc_hd__a221o_1
X_09579_ net51 _04596_ vssd1 vssd1 vccd1 vccd1 _04597_ sky130_fd_sc_hd__or2_1
XANTENNA__10861__A3 net11 vssd1 vssd1 vccd1 vccd1 sky130_fd_sc_hd__diode_2
XFILLER_35_55 vssd1 vssd1 vccd1 vccd1 sky130_fd_sc_hd__fill_1
XTAP_TAPCELL_ROW_100_1807 vssd1 vccd1 sky130_fd_sc_hd__tapvpwrvgnd_1
X_12590_ cell3.SB0.route_sel\[55\] cell3.SB0.route_sel\[54\] net909 vssd1 vssd1 vccd1
+ vccd1 _01019_ sky130_fd_sc_hd__mux2_1
XFILLER_70_477 vssd1 vssd1 vccd1 vccd1 sky130_fd_sc_hd__fill_1
XFILLER_70_466 vssd1 vssd1 vccd1 vccd1 sky130_fd_sc_hd__fill_1
X_11610_ cell0.CB_0.config_dataB\[6\] net531 net773 vssd1 vssd1 vccd1 vccd1 _00051_
+ sky130_fd_sc_hd__mux2_1
XTAP_TAPCELL_ROW_13_506 vssd1 vccd1 sky130_fd_sc_hd__tapvpwrvgnd_1
XFILLER_35_77 vssd1 vssd1 vccd1 vccd1 sky130_fd_sc_hd__fill_2
X_11541_ _01816_ cell0.SB0.route_sel\[8\] vssd1 vssd1 vccd1 vccd1 _06361_ sky130_fd_sc_hd__nand2_1
XFILLER_23_393 vssd1 vssd1 vccd1 vccd1 sky130_fd_sc_hd__fill_1
XTAP_TAPCELL_ROW_133_2306 vssd1 vccd1 sky130_fd_sc_hd__tapvpwrvgnd_1
X_14260_ clknet_leaf_26_clk _01232_ net607 vssd1 vssd1 vccd1 vccd1 cell2.SB0.route_sel\[45\]
+ sky130_fd_sc_hd__dfstp_1
X_11472_ cell1.SB0.route_sel\[89\] cell1.SB0.route_sel\[88\] vssd1 vssd1 vccd1 vccd1
+ _06315_ sky130_fd_sc_hd__nand2b_1
X_10423_ cell2.LE_0B.config_data\[11\] cell2.LE_0B.config_data\[10\] _05344_ vssd1
+ vssd1 vccd1 vccd1 _05422_ sky130_fd_sc_hd__mux2_1
X_14191_ clknet_leaf_53_clk _01163_ net714 vssd1 vssd1 vccd1 vccd1 cell3.CB_0.config_dataA\[1\]
+ sky130_fd_sc_hd__dfstp_1
X_13211_ clknet_leaf_11_clk _00183_ net589 vssd1 vssd1 vccd1 vccd1 cell0.LE_0A.reset_val
+ sky130_fd_sc_hd__dfrtp_1
XANTENNA_input63_A CBnorth_in[8] vssd1 vssd1 vccd1 vccd1 sky130_fd_sc_hd__diode_2
XFILLER_137_785 vccd1 vssd1 vccd1 vssd1 sky130_ef_sc_hd__decap_40_12
X_10354_ net428 _05148_ _05352_ net426 vssd1 vssd1 vccd1 vccd1 _05353_ sky130_fd_sc_hd__o211a_1
XFILLER_3_721 vssd1 vssd1 vccd1 vccd1 sky130_fd_sc_hd__fill_4
X_13142_ clknet_leaf_124_clk _00114_ net579 vssd1 vssd1 vccd1 vccd1 cell0.CB_1.config_dataB\[19\]
+ sky130_fd_sc_hd__dfstp_1
X_10285_ _01757_ _05279_ _05283_ vssd1 vssd1 vccd1 vccd1 _05284_ sky130_fd_sc_hd__or3_1
X_13073_ clknet_leaf_8_clk _00045_ net572 vssd1 vssd1 vccd1 vccd1 cell0.CB_0.config_dataB\[0\]
+ sky130_fd_sc_hd__dfstp_1
XFILLER_3_765 vccd1 vssd1 vccd1 vssd1 sky130_ef_sc_hd__decap_40_12
XFILLER_2_253 vccd1 vssd1 vccd1 vssd1 sky130_ef_sc_hd__decap_40_12
XTAP_TAPCELL_ROW_111_1969 vssd1 vccd1 sky130_fd_sc_hd__tapvpwrvgnd_1
X_12024_ cell1.CB_1.config_dataB\[2\] net460 net891 vssd1 vssd1 vccd1 vccd1 _00461_
+ sky130_fd_sc_hd__mux2_1
XTAP_TAPCELL_ROW_53_1098 vssd1 vccd1 sky130_fd_sc_hd__tapvpwrvgnd_1
XFILLER_19_600 vssd1 vssd1 vccd1 vccd1 sky130_fd_sc_hd__fill_1
XANTENNA__08742__A2 net2 vssd1 vssd1 vccd1 vccd1 sky130_fd_sc_hd__diode_2
XANTENNA__09195__A_N _04222_ vssd1 vssd1 vccd1 vccd1 sky130_fd_sc_hd__diode_2
Xfanout590 net591 vssd1 vssd1 vccd1 vccd1 net590 sky130_fd_sc_hd__buf_2
XFILLER_59_791 vssd1 vssd1 vccd1 vccd1 sky130_fd_sc_hd__fill_1
XANTENNA__07292__A _02346_ vssd1 vssd1 vccd1 vccd1 sky130_fd_sc_hd__diode_2
X_13975_ clknet_leaf_41_clk net1096 net641 vssd1 vssd1 vccd1 vccd1 cell2.LEI0.config_data\[32\]
+ sky130_fd_sc_hd__dfrtp_1
XFILLER_93_558 vssd1 vssd1 vccd1 vccd1 sky130_fd_sc_hd__fill_2
XANTENNA__10301__A2 _05088_ vssd1 vssd1 vccd1 vccd1 sky130_fd_sc_hd__diode_2
X_12926_ cell3.LE_1A.config_data\[14\] net978 net953 vssd1 vssd1 vccd1 vccd1 _01355_
+ sky130_fd_sc_hd__mux2_1
XANTENNA_clkload9_A clknet_4_9_0_clk vssd1 vssd1 vccd1 vccd1 sky130_fd_sc_hd__diode_2
X_12857_ cell2.SB0.route_sel\[99\] cell2.SB0.route_sel\[98\] net833 vssd1 vssd1 vccd1
+ vccd1 _01286_ sky130_fd_sc_hd__mux2_1
XFILLER_92_61 vssd1 vssd1 vccd1 vccd1 sky130_fd_sc_hd__fill_2
XFILLER_61_444 vssd1 vssd1 vccd1 vccd1 sky130_fd_sc_hd__fill_4
X_11808_ cell1.LE_1B.config_data\[9\] net1551 net902 vssd1 vssd1 vccd1 vccd1 _00245_
+ sky130_fd_sc_hd__mux2_1
XPHY_EDGE_ROW_1_Left_144 vssd1 vssd1 vccd1 vccd1 sky130_fd_sc_hd__decap_3
X_12788_ cell2.SB0.route_sel\[30\] cell2.SB0.route_sel\[29\] net817 vssd1 vssd1 vccd1
+ vccd1 _01217_ sky130_fd_sc_hd__mux2_1
XFILLER_42_691 vssd1 vssd1 vccd1 vccd1 sky130_fd_sc_hd__fill_1
X_11739_ net1118 net1065 net808 vssd1 vssd1 vccd1 vccd1 _00177_ sky130_fd_sc_hd__mux2_1
XANTENNA__06808__A2 net360 vssd1 vssd1 vccd1 vccd1 sky130_fd_sc_hd__diode_2
X_14458_ clknet_leaf_67_clk _01430_ net737 vssd1 vssd1 vccd1 vccd1 cell3.LEI0.config_data\[23\]
+ sky130_fd_sc_hd__dfrtp_1
XANTENNA__11014__A0 net49 vssd1 vssd1 vccd1 vccd1 sky130_fd_sc_hd__diode_2
X_14389_ clknet_1_1__leaf_cell3.LE_1B.sel_clk _01361_ net753 vssd1 vssd1 vccd1 vccd1
+ cell3.LE_1B.dff1_out sky130_fd_sc_hd__dfstp_1
X_13409_ clknet_leaf_134_clk _00381_ net555 vssd1 vssd1 vccd1 vccd1 cell0.SB0.route_sel\[50\]
+ sky130_fd_sc_hd__dfstp_1
XANTENNA__07467__A net302 vssd1 vssd1 vccd1 vccd1 sky130_fd_sc_hd__diode_2
XTAP_TAPCELL_ROW_73_1408 vssd1 vccd1 sky130_fd_sc_hd__tapvpwrvgnd_1
X_08950_ bus3_1\[0\] bus3_1\[1\] bus3_1\[2\] bus3_1\[3\] net465 cell1.CB_0.config_dataA\[16\]
+ vssd1 vssd1 vccd1 vccd1 _03982_ sky130_fd_sc_hd__mux4_1
XPHY_EDGE_ROW_135_Right_135 vssd1 vssd1 vccd1 vccd1 sky130_fd_sc_hd__decap_3
X_08881_ net473 _03820_ vssd1 vssd1 vccd1 vccd1 _03913_ sky130_fd_sc_hd__nand2_1
X_07901_ cell0.LEI0.config_data\[2\] _02944_ vssd1 vssd1 vccd1 vccd1 _02945_ sky130_fd_sc_hd__and2b_1
XANTENNA__11276__X net168 vssd1 vssd1 vccd1 vccd1 sky130_fd_sc_hd__diode_2
X_07832_ net519 _02235_ _02875_ net517 vssd1 vssd1 vccd1 vccd1 _02876_ sky130_fd_sc_hd__o211a_1
XANTENNA__07941__A0 bus2_0\[6\] vssd1 vssd1 vccd1 vccd1 sky130_fd_sc_hd__diode_2
XFILLER_110_195 vssd1 vssd1 vccd1 vccd1 sky130_fd_sc_hd__fill_1
X_09502_ _01714_ cell3.SB0.route_sel\[58\] cell3.SB0.route_sel\[62\] cell3.SB0.route_sel\[63\]
+ _04522_ vssd1 vssd1 vccd1 vccd1 _04523_ sky130_fd_sc_hd__o221a_1
XFILLER_2_81 vssd1 vssd1 vccd1 vccd1 sky130_fd_sc_hd__fill_2
X_07763_ cell1.SB0.route_sel\[37\] cell1.SB0.route_sel\[36\] vssd1 vssd1 vccd1 vccd1
+ _02809_ sky130_fd_sc_hd__nand2_1
XFILLER_112_27 vssd1 vssd1 vccd1 vccd1 sky130_fd_sc_hd__fill_1
X_06714_ cell3.CB_1.config_dataA\[2\] vssd1 vssd1 vccd1 vccd1 _01784_ sky130_fd_sc_hd__inv_2
X_07694_ _01931_ _02606_ vssd1 vssd1 vccd1 vccd1 _02741_ sky130_fd_sc_hd__nand2_1
X_09433_ _04423_ _04424_ _04449_ _04455_ vssd1 vssd1 vccd1 vccd1 _04456_ sky130_fd_sc_hd__a31o_1
XFILLER_92_580 vssd1 vssd1 vccd1 vccd1 sky130_fd_sc_hd__fill_8
X_06645_ cell3.SB0.route_sel\[63\] vssd1 vssd1 vccd1 vccd1 _01715_ sky130_fd_sc_hd__inv_2
XFILLER_37_496 vssd1 vssd1 vccd1 vccd1 sky130_fd_sc_hd__fill_8
X_09364_ cell2.SB0.route_sel\[35\] cell2.SB0.route_sel\[34\] _04380_ _04386_ _04387_
+ vssd1 vssd1 vccd1 vccd1 _04388_ sky130_fd_sc_hd__a221o_1
XPHY_EDGE_ROW_56_Left_199 vssd1 vssd1 vccd1 vccd1 sky130_fd_sc_hd__decap_3
XANTENNA__08249__A1 bus1_0\[1\] vssd1 vssd1 vccd1 vccd1 sky130_fd_sc_hd__diode_2
XANTENNA_fanout348_A net349 vssd1 vssd1 vccd1 vccd1 sky130_fd_sc_hd__diode_2
X_06576_ cell2.SB0.route_sel\[114\] vssd1 vssd1 vccd1 vccd1 _01646_ sky130_fd_sc_hd__inv_2
XANTENNA__09446__B1 _04467_ vssd1 vssd1 vccd1 vccd1 sky130_fd_sc_hd__diode_2
X_08315_ bus1_0\[0\] bus1_0\[1\] bus1_0\[2\] bus1_0\[3\] net509 net508 vssd1 vssd1
+ vccd1 vccd1 _03353_ sky130_fd_sc_hd__mux4_1
XANTENNA__09997__A1 bus3_2\[14\] vssd1 vssd1 vccd1 vccd1 sky130_fd_sc_hd__diode_2
X_09295_ _04303_ _04312_ _04320_ vssd1 vssd1 vccd1 vccd1 _04321_ sky130_fd_sc_hd__a21oi_1
XANTENNA_31 net1547 vssd1 vssd1 vccd1 vccd1 sky130_fd_sc_hd__diode_2
XANTENNA_20 net141 vssd1 vssd1 vccd1 vccd1 sky130_fd_sc_hd__diode_2
XANTENNA_42 net196 vssd1 vssd1 vccd1 vccd1 sky130_fd_sc_hd__diode_2
X_08246_ bus1_0\[6\] bus1_0\[7\] net536 vssd1 vssd1 vccd1 vccd1 _03286_ sky130_fd_sc_hd__mux2_1
XTAP_TAPCELL_ROW_115_2036 vssd1 vccd1 sky130_fd_sc_hd__tapvpwrvgnd_1
XTAP_TAPCELL_ROW_99_1791 vssd1 vccd1 sky130_fd_sc_hd__tapvpwrvgnd_1
X_08177_ net542 _02560_ _03216_ vssd1 vssd1 vccd1 vccd1 _03217_ sky130_fd_sc_hd__a21o_1
XANTENNA_fanout303_X net303 vssd1 vssd1 vccd1 vccd1 sky130_fd_sc_hd__diode_2
XFILLER_4_518 vccd1 vssd1 vccd1 vssd1 sky130_ef_sc_hd__decap_40_12
X_07128_ _01847_ _02013_ vssd1 vssd1 vccd1 vccd1 _02190_ sky130_fd_sc_hd__or2_1
XFILLER_137_57 vccd1 vssd1 vccd1 vssd1 sky130_ef_sc_hd__decap_40_12
XFILLER_134_755 vssd1 vssd1 vccd1 vccd1 sky130_fd_sc_hd__fill_1
XANTENNA_fanout884_A net959 vssd1 vssd1 vccd1 vccd1 sky130_fd_sc_hd__diode_2
XFILLER_106_479 vssd1 vssd1 vccd1 vccd1 sky130_fd_sc_hd__fill_1
XFILLER_97_39 vssd1 vssd1 vccd1 vccd1 sky130_fd_sc_hd__fill_8
X_07059_ net343 _02027_ _02121_ vssd1 vssd1 vccd1 vccd1 _02123_ sky130_fd_sc_hd__or3_1
Xoutput160 net160 vssd1 vssd1 vccd1 vccd1 CBeast_out[4] sky130_fd_sc_hd__buf_2
Xoutput182 net182 vssd1 vssd1 vccd1 vccd1 CBnorth_out[24] sky130_fd_sc_hd__buf_2
Xoutput193 net193 vssd1 vssd1 vccd1 vccd1 CBnorth_out[5] sky130_fd_sc_hd__buf_2
Xoutput171 net171 vssd1 vssd1 vccd1 vccd1 CBnorth_out[14] sky130_fd_sc_hd__buf_2
X_10070_ cell2.LE_1B.config_data\[10\] cell2.LE_1B.config_data\[11\] _04956_ vssd1
+ vssd1 vccd1 vccd1 _05074_ sky130_fd_sc_hd__mux2_1
XFILLER_133_287 vssd1 vssd1 vccd1 vccd1 sky130_fd_sc_hd__fill_1
XANTENNA_fanout672_X net672 vssd1 vssd1 vccd1 vccd1 sky130_fd_sc_hd__diode_2
XPHY_EDGE_ROW_102_Right_102 vssd1 vssd1 vccd1 vccd1 sky130_fd_sc_hd__decap_3
XANTENNA__09921__A1 bus3_2\[2\] vssd1 vssd1 vccd1 vccd1 sky130_fd_sc_hd__diode_2
XANTENNA__08724__A2 _03486_ vssd1 vssd1 vccd1 vccd1 sky130_fd_sc_hd__diode_2
XANTENNA__07932__A0 net342 vssd1 vssd1 vccd1 vccd1 sky130_fd_sc_hd__diode_2
XANTENNA__14075__SET_B net672 vssd1 vssd1 vccd1 vccd1 sky130_fd_sc_hd__diode_2
XTAP_TAPCELL_ROW_126_2198 vssd1 vccd1 sky130_fd_sc_hd__tapvpwrvgnd_1
X_10972_ _05862_ _05921_ _05925_ _05918_ cell3.CB_0.config_dataA\[2\] vssd1 vssd1
+ vccd1 vccd1 _05926_ sky130_fd_sc_hd__a2111oi_1
XANTENNA__08488__A1 net30 vssd1 vssd1 vccd1 vccd1 sky130_fd_sc_hd__diode_2
X_13760_ clknet_leaf_111_clk _00732_ net655 vssd1 vssd1 vccd1 vccd1 cell1.SB0.route_sel\[37\]
+ sky130_fd_sc_hd__dfstp_1
X_13691_ clknet_leaf_32_clk _00663_ net620 vssd1 vssd1 vccd1 vccd1 cell2.CB_0.config_dataB\[18\]
+ sky130_fd_sc_hd__dfstp_1
X_12711_ cell3.CB_0.config_dataB\[3\] cell3.CB_0.config_dataB\[2\] net926 vssd1 vssd1
+ vccd1 vccd1 _01140_ sky130_fd_sc_hd__mux2_1
X_12642_ cell3.SB0.route_sel\[107\] cell3.SB0.route_sel\[106\] net923 vssd1 vssd1
+ vccd1 vccd1 _01071_ sky130_fd_sc_hd__mux2_1
XTAP_TAPCELL_ROW_26_697 vssd1 vccd1 sky130_fd_sc_hd__tapvpwrvgnd_1
X_12573_ cell3.SB0.route_sel\[38\] cell3.SB0.route_sel\[37\] net909 vssd1 vssd1 vccd1
+ vccd1 _01002_ sky130_fd_sc_hd__mux2_1
X_14312_ clknet_leaf_43_clk _01284_ net621 vssd1 vssd1 vccd1 vccd1 cell2.SB0.route_sel\[97\]
+ sky130_fd_sc_hd__dfstp_2
X_11524_ cell2.SB0.route_sel\[96\] cell2.SB0.route_sel\[97\] cell2.SB0.route_sel\[100\]
+ _01640_ _06349_ vssd1 vssd1 vccd1 vccd1 _06350_ sky130_fd_sc_hd__o221a_1
XFILLER_7_15 vccd1 vssd1 vccd1 vssd1 sky130_ef_sc_hd__decap_40_12
XFILLER_11_374 vssd1 vssd1 vccd1 vccd1 sky130_fd_sc_hd__fill_1
X_14243_ clknet_leaf_19_clk _01215_ net612 vssd1 vssd1 vccd1 vccd1 cell2.SB0.route_sel\[28\]
+ sky130_fd_sc_hd__dfstp_1
X_11455_ cell1.SB0.route_sel\[42\] _01516_ cell1.SB0.route_sel\[46\] cell1.SB0.route_sel\[47\]
+ _06303_ vssd1 vssd1 vccd1 vccd1 _06304_ sky130_fd_sc_hd__o221a_1
X_10406_ net61 net62 net425 vssd1 vssd1 vccd1 vccd1 _05405_ sky130_fd_sc_hd__mux2_1
X_14174_ clknet_leaf_57_clk _01146_ net721 vssd1 vssd1 vccd1 vccd1 cell3.CB_0.config_dataB\[9\]
+ sky130_fd_sc_hd__dfstp_1
XFILLER_98_606 vssd1 vssd1 vccd1 vccd1 sky130_fd_sc_hd__fill_1
XANTENNA_input66_X net66 vssd1 vssd1 vccd1 vccd1 sky130_fd_sc_hd__diode_2
X_11386_ _01461_ cell0.SB0.route_sel\[57\] _01465_ cell0.SB0.route_sel\[58\] _06257_
+ vssd1 vssd1 vccd1 vccd1 _06258_ sky130_fd_sc_hd__o221a_1
X_10337_ net63 net64 net34 net35 net436 net434 vssd1 vssd1 vccd1 vccd1 _05336_ sky130_fd_sc_hd__mux4_1
XTAP_TAPCELL_ROW_55_1138 vssd1 vccd1 sky130_fd_sc_hd__tapvpwrvgnd_1
XTAP_TAPCELL_ROW_55_1127 vssd1 vccd1 sky130_fd_sc_hd__tapvpwrvgnd_1
XANTENNA__08963__A2 _03817_ vssd1 vssd1 vccd1 vccd1 sky130_fd_sc_hd__diode_2
XFILLER_3_573 vccd1 vssd1 vccd1 vssd1 sky130_ef_sc_hd__decap_40_12
X_13125_ clknet_leaf_124_clk _00097_ net583 vssd1 vssd1 vccd1 vccd1 cell0.CB_1.config_dataB\[2\]
+ sky130_fd_sc_hd__dfstp_2
XFILLER_112_438 vssd1 vssd1 vccd1 vccd1 sky130_fd_sc_hd__fill_1
X_10268_ cell2.LE_0A.config_data\[13\] cell2.LE_0A.config_data\[12\] _05196_ vssd1
+ vssd1 vccd1 vccd1 _05269_ sky130_fd_sc_hd__mux2_1
X_13056_ clknet_leaf_126_clk _00028_ net582 vssd1 vssd1 vccd1 vccd1 cell0.CB_1.config_dataA\[8\]
+ sky130_fd_sc_hd__dfstp_1
XFILLER_140_769 vccd1 vssd1 vccd1 vssd1 sky130_ef_sc_hd__decap_40_12
XFILLER_66_503 vssd1 vssd1 vccd1 vccd1 sky130_fd_sc_hd__fill_1
XANTENNA__11537__A _02630_ vssd1 vssd1 vccd1 vccd1 sky130_fd_sc_hd__diode_2
X_12007_ cell0.SB0.route_sel\[113\] cell0.SB0.route_sel\[112\] net765 vssd1 vssd1
+ vccd1 vccd1 _00444_ sky130_fd_sc_hd__mux2_1
X_10199_ net414 net415 vssd1 vssd1 vccd1 vccd1 _05200_ sky130_fd_sc_hd__and2b_1
XFILLER_78_374 vssd1 vssd1 vccd1 vccd1 sky130_fd_sc_hd__fill_8
XFILLER_19_441 vssd1 vssd1 vccd1 vccd1 sky130_fd_sc_hd__fill_1
X_13958_ clknet_leaf_34_clk _00930_ net636 vssd1 vssd1 vccd1 vccd1 cell2.LEI0.config_data\[15\]
+ sky130_fd_sc_hd__dfrtp_1
XANTENNA__06918__X _01985_ vssd1 vssd1 vccd1 vccd1 sky130_fd_sc_hd__diode_2
XFILLER_19_463 vssd1 vssd1 vccd1 vccd1 sky130_fd_sc_hd__fill_1
X_12909_ net362 net363 net940 vssd1 vssd1 vccd1 vccd1 _01338_ sky130_fd_sc_hd__mux2_1
XANTENNA__11543__Y net209 vssd1 vssd1 vccd1 vccd1 sky130_fd_sc_hd__diode_2
X_13889_ clknet_leaf_40_clk net1252 net643 vssd1 vssd1 vccd1 vccd1 cell2.LE_1A.config_data\[12\]
+ sky130_fd_sc_hd__dfrtp_1
XANTENNA__10825__A3 net25 vssd1 vssd1 vccd1 vccd1 sky130_fd_sc_hd__diode_2
XANTENNA__08565__B _03489_ vssd1 vssd1 vccd1 vccd1 sky130_fd_sc_hd__diode_2
X_06430_ cell0.LEI0.config_data\[44\] vssd1 vssd1 vccd1 vccd1 _01500_ sky130_fd_sc_hd__inv_2
XANTENNA__10038__A1 _04671_ vssd1 vssd1 vccd1 vccd1 sky130_fd_sc_hd__diode_2
XTAP_TAPCELL_ROW_45_984 vssd1 vccd1 sky130_fd_sc_hd__tapvpwrvgnd_1
Xclkbuf_1_1__f_cell0.LE_0B.sel_clk clknet_0_cell0.LE_0B.sel_clk vssd1 vssd1 vccd1
+ vccd1 clknet_1_1__leaf_cell0.LE_0B.sel_clk sky130_fd_sc_hd__clkbuf_16
X_09080_ net478 _04108_ _04109_ vssd1 vssd1 vccd1 vccd1 _04110_ sky130_fd_sc_hd__a21oi_1
X_08100_ net524 _02301_ vssd1 vssd1 vccd1 vccd1 _03142_ sky130_fd_sc_hd__nand2_1
Xinput40 CBnorth_in[16] vssd1 vssd1 vccd1 vccd1 net40 sky130_fd_sc_hd__clkbuf_4
X_08031_ _02887_ _03060_ _03061_ _02890_ _01556_ vssd1 vssd1 vccd1 vccd1 _03073_ sky130_fd_sc_hd__a221o_1
Xinput51 CBnorth_in[26] vssd1 vssd1 vccd1 vccd1 net51 sky130_fd_sc_hd__buf_2
Xinput62 CBnorth_in[7] vssd1 vssd1 vccd1 vccd1 net62 sky130_fd_sc_hd__buf_2
Xinput73 SBsouth_in[17] vssd1 vssd1 vccd1 vccd1 net73 sky130_fd_sc_hd__buf_1
XANTENNA__13502__SET_B net684 vssd1 vssd1 vccd1 vccd1 sky130_fd_sc_hd__diode_2
XANTENNA__07197__A _01931_ vssd1 vssd1 vccd1 vccd1 sky130_fd_sc_hd__diode_2
Xinput95 SBsouth_in[8] vssd1 vssd1 vccd1 vccd1 net95 sky130_fd_sc_hd__clkbuf_2
Xinput84 SBsouth_in[27] vssd1 vssd1 vccd1 vccd1 net84 sky130_fd_sc_hd__dlymetal6s2s_1
XFILLER_107_27 vssd1 vssd1 vccd1 vccd1 sky130_fd_sc_hd__fill_1
X_09982_ _04969_ _04970_ _04972_ _04985_ vssd1 vssd1 vccd1 vccd1 _04986_ sky130_fd_sc_hd__a31oi_2
XFILLER_88_138 vssd1 vssd1 vccd1 vccd1 sky130_fd_sc_hd__fill_2
X_08933_ _03957_ _03960_ _03964_ cell1.CB_0.config_dataA\[13\] vssd1 vssd1 vccd1 vccd1
+ _03965_ sky130_fd_sc_hd__or4b_1
XANTENNA_fanout298_A cell3.CB_1.le_outA vssd1 vssd1 vccd1 vccd1 sky130_fd_sc_hd__diode_2
XANTENNA__09364__C1 _04387_ vssd1 vssd1 vccd1 vccd1 sky130_fd_sc_hd__diode_2
XANTENNA__08706__A2 _03504_ vssd1 vssd1 vccd1 vccd1 sky130_fd_sc_hd__diode_2
XFILLER_123_15 vccd1 vssd1 vccd1 vssd1 sky130_ef_sc_hd__decap_40_12
X_08864_ _03864_ _03872_ _03886_ _03895_ vssd1 vssd1 vccd1 vccd1 _03896_ sky130_fd_sc_hd__o22a_1
XANTENNA__12977__S net756 vssd1 vssd1 vccd1 vccd1 sky130_fd_sc_hd__diode_2
X_08795_ net469 net470 vssd1 vssd1 vccd1 vccd1 _03827_ sky130_fd_sc_hd__and2b_1
X_07815_ net328 _02859_ vssd1 vssd1 vccd1 vccd1 _02860_ sky130_fd_sc_hd__nor2_1
XFILLER_84_377 vssd1 vssd1 vccd1 vccd1 sky130_fd_sc_hd__fill_4
X_07746_ net360 _02014_ bus1_0\[4\] vssd1 vssd1 vccd1 vccd1 _02792_ sky130_fd_sc_hd__o21ai_1
XPHY_EDGE_ROW_64_Left_207 vssd1 vssd1 vccd1 vccd1 sky130_fd_sc_hd__decap_3
XANTENNA__11453__Y net210 vssd1 vssd1 vccd1 vccd1 sky130_fd_sc_hd__diode_2
X_09416_ net60 net306 _04437_ vssd1 vssd1 vccd1 vccd1 _04439_ sky130_fd_sc_hd__mux2_1
XANTENNA_fanout632_A net650 vssd1 vssd1 vccd1 vccd1 sky130_fd_sc_hd__diode_2
X_07677_ net74 _02721_ vssd1 vssd1 vccd1 vccd1 _02725_ sky130_fd_sc_hd__nand2_1
XANTENNA__08475__B _03509_ vssd1 vssd1 vccd1 vccd1 sky130_fd_sc_hd__diode_2
X_06628_ cell3.SB0.route_sel\[33\] vssd1 vssd1 vccd1 vccd1 _01698_ sky130_fd_sc_hd__inv_2
XANTENNA__08890__A1 bus3_1\[1\] vssd1 vssd1 vccd1 vccd1 sky130_fd_sc_hd__diode_2
X_09347_ cell3.SB0.route_sel\[24\] _01694_ vssd1 vssd1 vccd1 vccd1 _04372_ sky130_fd_sc_hd__nand2_1
X_06559_ cell2.SB0.route_sel\[80\] vssd1 vssd1 vccd1 vccd1 _01629_ sky130_fd_sc_hd__inv_2
XFILLER_8_109 vccd1 vssd1 vccd1 vssd1 sky130_ef_sc_hd__decap_40_12
XTAP_TAPCELL_ROW_23_656 vssd1 vccd1 sky130_fd_sc_hd__tapvpwrvgnd_1
X_09278_ cell3.CB_1.config_dataA\[24\] cell3.CB_1.config_dataA\[20\] cell3.CB_1.config_dataA\[21\]
+ vssd1 vssd1 vccd1 vccd1 _04304_ sky130_fd_sc_hd__or3b_2
XANTENNA__08642__A1 net30 vssd1 vssd1 vccd1 vccd1 sky130_fd_sc_hd__diode_2
X_08229_ bus1_0\[12\] bus1_0\[13\] bus1_0\[14\] bus1_0\[15\] net537 cell0.CB_1.config_dataA\[16\]
+ vssd1 vssd1 vccd1 vccd1 _03269_ sky130_fd_sc_hd__mux4_1
XANTENNA__12217__S net827 vssd1 vssd1 vccd1 vccd1 sky130_fd_sc_hd__diode_2
XPHY_EDGE_ROW_73_Left_216 vssd1 vssd1 vccd1 vccd1 sky130_fd_sc_hd__decap_3
X_11240_ cell3.LE_0B.dff0_out cell3.LE_0B.dff1_out cell3.LE_0B.reset_val vssd1 vssd1
+ vccd1 vccd1 cell3.LE_0B.dff_out sky130_fd_sc_hd__mux2_1
X_11171_ _05901_ _06109_ vssd1 vssd1 vccd1 vccd1 _06123_ sky130_fd_sc_hd__nor2_1
XANTENNA__10201__A1 net319 vssd1 vssd1 vccd1 vccd1 sky130_fd_sc_hd__diode_2
X_10122_ net61 net62 net418 vssd1 vssd1 vccd1 vccd1 _05123_ sky130_fd_sc_hd__mux2_1
XANTENNA__08158__B1 _03195_ vssd1 vssd1 vccd1 vccd1 sky130_fd_sc_hd__diode_2
XTAP_TAPCELL_ROW_128_2227 vssd1 vccd1 sky130_fd_sc_hd__tapvpwrvgnd_1
X_10053_ _04197_ _05033_ _05035_ _04260_ cell2.CB_1.config_dataB\[17\] vssd1 vssd1
+ vccd1 vccd1 _05057_ sky130_fd_sc_hd__a221o_1
XPHY_EDGE_ROW_82_Left_225 vssd1 vssd1 vccd1 vccd1 sky130_fd_sc_hd__decap_3
XANTENNA_input26_A CBeast_in[3] vssd1 vssd1 vccd1 vccd1 sky130_fd_sc_hd__diode_2
XTAP_TAPCELL_ROW_50_1057 vssd1 vccd1 sky130_fd_sc_hd__tapvpwrvgnd_1
XTAP_TAPCELL_ROW_141_2427 vssd1 vccd1 sky130_fd_sc_hd__tapvpwrvgnd_1
XTAP_TAPCELL_ROW_141_2416 vssd1 vccd1 sky130_fd_sc_hd__tapvpwrvgnd_1
X_13812_ clknet_leaf_112_clk _00784_ net663 vssd1 vssd1 vccd1 vccd1 cell1.SB0.route_sel\[89\]
+ sky130_fd_sc_hd__dfstp_1
XANTENNA__09658__B1 net316 vssd1 vssd1 vccd1 vccd1 sky130_fd_sc_hd__diode_2
XFILLER_90_336 vssd1 vssd1 vccd1 vccd1 sky130_fd_sc_hd__fill_1
X_10955_ _05904_ _05907_ _05908_ _01805_ vssd1 vssd1 vccd1 vccd1 _05909_ sky130_fd_sc_hd__a2bb2o_1
X_13743_ clknet_leaf_107_clk _00715_ net658 vssd1 vssd1 vccd1 vccd1 cell1.SB0.route_sel\[20\]
+ sky130_fd_sc_hd__dfstp_1
X_13674_ clknet_leaf_30_clk _00646_ net620 vssd1 vssd1 vccd1 vccd1 cell2.CB_0.config_dataB\[1\]
+ sky130_fd_sc_hd__dfstp_1
X_10886_ _05838_ _05841_ _05793_ vssd1 vssd1 vccd1 vccd1 _05842_ sky130_fd_sc_hd__mux2_1
XTAP_TAPCELL_ROW_42_932 vssd1 vccd1 sky130_fd_sc_hd__tapvpwrvgnd_1
XFILLER_92_9 vccd1 vssd1 vccd1 vssd1 sky130_ef_sc_hd__decap_40_12
X_12625_ cell3.SB0.route_sel\[90\] cell3.SB0.route_sel\[89\] net920 vssd1 vssd1 vccd1
+ vccd1 _01054_ sky130_fd_sc_hd__mux2_1
XTAP_TAPCELL_ROW_42_943 vssd1 vccd1 sky130_fd_sc_hd__tapvpwrvgnd_1
XTAP_TAPCELL_ROW_139_2389 vssd1 vccd1 sky130_fd_sc_hd__tapvpwrvgnd_1
X_12556_ cell3.SB0.route_sel\[21\] cell3.SB0.route_sel\[20\] net917 vssd1 vssd1 vccd1
+ vccd1 _00985_ sky130_fd_sc_hd__mux2_1
XPHY_EDGE_ROW_91_Left_234 vssd1 vssd1 vccd1 vccd1 sky130_fd_sc_hd__decap_3
X_11507_ _01928_ _06338_ vssd1 vssd1 vccd1 vccd1 net244 sky130_fd_sc_hd__and2_1
XFILLER_8_643 vssd1 vssd1 vccd1 vccd1 sky130_fd_sc_hd__fill_1
X_12487_ net1427 cell2.LEI0.config_data\[0\] net840 vssd1 vssd1 vccd1 vccd1 _00916_
+ sky130_fd_sc_hd__mux2_1
XANTENNA__10440__B2 cell3.SB0.route_sel\[37\] vssd1 vssd1 vccd1 vccd1 sky130_fd_sc_hd__diode_2
XANTENNA__07288__Y _02346_ vssd1 vssd1 vccd1 vccd1 sky130_fd_sc_hd__diode_2
XANTENNA__09784__X _04790_ vssd1 vssd1 vccd1 vccd1 sky130_fd_sc_hd__diode_2
X_14226_ clknet_leaf_15_clk _01198_ net625 vssd1 vssd1 vccd1 vccd1 cell2.SB0.route_sel\[11\]
+ sky130_fd_sc_hd__dfstp_1
Xhold109 cell0.LE_1A.config_data\[15\] vssd1 vssd1 vccd1 vccd1 net1068 sky130_fd_sc_hd__dlygate4sd3_1
X_11438_ _02557_ _06292_ vssd1 vssd1 vccd1 vccd1 net236 sky130_fd_sc_hd__nor2_2
XANTENNA__09944__B _04608_ vssd1 vssd1 vccd1 vccd1 sky130_fd_sc_hd__diode_2
X_14157_ clknet_leaf_72_clk _01129_ net728 vssd1 vssd1 vccd1 vccd1 cell3.CB_1.config_dataA\[17\]
+ sky130_fd_sc_hd__dfstp_2
X_11369_ _06246_ _02804_ vssd1 vssd1 vccd1 vccd1 net224 sky130_fd_sc_hd__and2b_1
X_13108_ clknet_leaf_5_clk _00080_ net566 vssd1 vssd1 vccd1 vccd1 cell0.CB_0.config_dataA\[10\]
+ sky130_fd_sc_hd__dfstp_1
X_14088_ clknet_leaf_78_clk _01060_ net709 vssd1 vssd1 vccd1 vccd1 cell3.SB0.route_sel\[96\]
+ sky130_fd_sc_hd__dfstp_1
XFILLER_78_171 vssd1 vssd1 vccd1 vccd1 sky130_fd_sc_hd__fill_1
X_13039_ clknet_leaf_121_clk _00011_ net593 vssd1 vssd1 vccd1 vccd1 cell0.LE_1B.config_data\[11\]
+ sky130_fd_sc_hd__dfrtp_1
XFILLER_39_503 vssd1 vssd1 vccd1 vccd1 sky130_fd_sc_hd__fill_1
XFILLER_21_3 vccd1 vssd1 vccd1 vssd1 sky130_ef_sc_hd__decap_40_12
XANTENNA__09361__A2 _04384_ vssd1 vssd1 vccd1 vccd1 sky130_fd_sc_hd__diode_2
XTAP_TAPCELL_ROW_68_1329 vssd1 vccd1 sky130_fd_sc_hd__tapvpwrvgnd_1
X_08580_ cell1.LEI0.config_data\[32\] _03615_ vssd1 vssd1 vccd1 vccd1 _03616_ sky130_fd_sc_hd__nand2b_1
X_07600_ cell1.CB_0.config_dataB\[23\] cell1.CB_0.config_dataB\[22\] vssd1 vssd1 vccd1
+ vccd1 _02650_ sky130_fd_sc_hd__or2_2
XANTENNA__07372__A1 cell0.CB_1.le_outA vssd1 vssd1 vccd1 vccd1 sky130_fd_sc_hd__diode_2
XTAP_TAPCELL_ROW_1_318 vssd1 vccd1 sky130_fd_sc_hd__tapvpwrvgnd_1
XTAP_TAPCELL_ROW_1_329 vssd1 vccd1 sky130_fd_sc_hd__tapvpwrvgnd_1
X_07531_ _01651_ _01652_ net121 cell2.SB0.route_sel\[125\] cell2.SB0.route_sel\[124\]
+ vssd1 vssd1 vccd1 vccd1 _02582_ sky130_fd_sc_hd__o2111a_1
XANTENNA_wire319_X net319 vssd1 vssd1 vccd1 vccd1 sky130_fd_sc_hd__diode_2
XTAP_TAPCELL_ROW_81_1529 vssd1 vccd1 sky130_fd_sc_hd__tapvpwrvgnd_1
XTAP_TAPCELL_ROW_81_1518 vssd1 vccd1 sky130_fd_sc_hd__tapvpwrvgnd_1
X_07462_ cell1.SB0.route_sel\[116\] cell1.SB0.route_sel\[117\] vssd1 vssd1 vccd1 vccd1
+ _02516_ sky130_fd_sc_hd__nand2b_1
XANTENNA__07675__A2 _02720_ vssd1 vssd1 vccd1 vccd1 sky130_fd_sc_hd__diode_2
XANTENNA__11208__A0 _05847_ vssd1 vssd1 vccd1 vccd1 sky130_fd_sc_hd__diode_2
X_07393_ _02164_ _02379_ vssd1 vssd1 vccd1 vccd1 _02448_ sky130_fd_sc_hd__nand2b_1
X_09201_ cell3.CB_1.config_dataB\[24\] cell3.CB_1.config_dataB\[21\] cell3.CB_1.config_dataB\[20\]
+ vssd1 vssd1 vccd1 vccd1 _04228_ sky130_fd_sc_hd__or3b_2
X_06413_ cell0.SB0.route_sel\[117\] vssd1 vssd1 vccd1 vccd1 _01483_ sky130_fd_sc_hd__inv_2
X_09132_ _04161_ vssd1 vssd1 vccd1 vccd1 _04162_ sky130_fd_sc_hd__inv_2
XTAP_TAPCELL_ROW_20_604 vssd1 vccd1 sky130_fd_sc_hd__tapvpwrvgnd_1
XTAP_TAPCELL_ROW_20_615 vssd1 vccd1 sky130_fd_sc_hd__tapvpwrvgnd_1
X_09063_ bus3_1\[12\] bus3_1\[13\] bus3_1\[14\] bus3_1\[15\] net479 net478 vssd1 vssd1
+ vccd1 vccd1 _04093_ sky130_fd_sc_hd__mux4_1
XTAP_TAPCELL_ROW_96_1750 vssd1 vccd1 sky130_fd_sc_hd__tapvpwrvgnd_1
X_08014_ cell0.LEI0.config_data\[17\] _03055_ vssd1 vssd1 vccd1 vccd1 _03056_ sky130_fd_sc_hd__or2_1
XANTENNA__08388__A0 bus1_0\[12\] vssd1 vssd1 vccd1 vccd1 sky130_fd_sc_hd__diode_2
XANTENNA__08927__A2 bus3_1\[14\] vssd1 vssd1 vccd1 vccd1 sky130_fd_sc_hd__diode_2
XANTENNA__06938__A1 net62 vssd1 vssd1 vccd1 vccd1 sky130_fd_sc_hd__diode_2
XFILLER_104_725 vssd1 vssd1 vccd1 vccd1 sky130_fd_sc_hd__fill_1
XANTENNA__10734__A2 _05519_ vssd1 vssd1 vccd1 vccd1 sky130_fd_sc_hd__diode_2
XFILLER_1_329 vssd1 vssd1 vccd1 vccd1 sky130_fd_sc_hd__fill_4
XPHY_EDGE_ROW_139_Left_282 vssd1 vssd1 vccd1 vccd1 sky130_fd_sc_hd__decap_3
XFILLER_134_25 vssd1 vssd1 vccd1 vccd1 sky130_fd_sc_hd__fill_2
X_09965_ _04445_ _04958_ _04967_ _04968_ vssd1 vssd1 vccd1 vccd1 _04969_ sky130_fd_sc_hd__a211o_1
XANTENNA_fanout582_A net584 vssd1 vssd1 vccd1 vccd1 sky130_fd_sc_hd__diode_2
X_09896_ _04901_ _04899_ _04890_ _04889_ vssd1 vssd1 vccd1 vccd1 _04902_ sky130_fd_sc_hd__o2bb2a_1
XANTENNA__09888__A0 bus3_2\[6\] vssd1 vssd1 vccd1 vccd1 sky130_fd_sc_hd__diode_2
X_08916_ net466 _03946_ _03947_ vssd1 vssd1 vccd1 vccd1 _03948_ sky130_fd_sc_hd__a21oi_1
XFILLER_94_29 vccd1 vssd1 vccd1 vssd1 sky130_ef_sc_hd__decap_40_12
XANTENNA__09352__A2 cell3.SB0.route_sel\[37\] vssd1 vssd1 vccd1 vccd1 sky130_fd_sc_hd__diode_2
X_08847_ cell1.SB0.route_sel\[58\] cell1.SB0.route_sel\[59\] vssd1 vssd1 vccd1 vccd1
+ _03879_ sky130_fd_sc_hd__nor2_1
XANTENNA__10498__A1 net335 vssd1 vssd1 vccd1 vccd1 sky130_fd_sc_hd__diode_2
XANTENNA_fanout847_A net854 vssd1 vssd1 vccd1 vccd1 sky130_fd_sc_hd__diode_2
XFILLER_84_152 vssd1 vssd1 vccd1 vccd1 sky130_fd_sc_hd__fill_1
XTAP_TAPCELL_ROW_123_2146 vssd1 vccd1 sky130_fd_sc_hd__tapvpwrvgnd_1
XFILLER_84_185 vssd1 vssd1 vccd1 vccd1 sky130_fd_sc_hd__fill_1
XFILLER_57_399 vssd1 vssd1 vccd1 vccd1 sky130_fd_sc_hd__fill_1
X_08778_ _03804_ _03811_ _03800_ vssd1 vssd1 vccd1 vccd1 _03812_ sky130_fd_sc_hd__mux2_1
XFILLER_27_78 vssd1 vssd1 vccd1 vccd1 sky130_fd_sc_hd__fill_4
XTAP_TAPCELL_ROW_28_726 vssd1 vccd1 sky130_fd_sc_hd__tapvpwrvgnd_1
XTAP_TAPCELL_ROW_123_2157 vssd1 vccd1 sky130_fd_sc_hd__tapvpwrvgnd_1
XANTENNA_fanout635_X net635 vssd1 vssd1 vccd1 vccd1 sky130_fd_sc_hd__diode_2
X_07729_ _01831_ _02775_ vssd1 vssd1 vccd1 vccd1 _02776_ sky130_fd_sc_hd__nor2_1
X_10740_ net21 net22 net24 net25 net371 cell3.CB_1.config_dataB\[1\] vssd1 vssd1 vccd1
+ vccd1 _05696_ sky130_fd_sc_hd__mux4_1
XTAP_TAPCELL_ROW_105_1890 vssd1 vccd1 sky130_fd_sc_hd__tapvpwrvgnd_1
X_10671_ _05616_ _05617_ _05618_ _05624_ _05628_ vssd1 vssd1 vccd1 vccd1 _05629_ sky130_fd_sc_hd__a311oi_1
XANTENNA__10670__A1 _05510_ vssd1 vssd1 vccd1 vccd1 sky130_fd_sc_hd__diode_2
XFILLER_80_380 vssd1 vssd1 vccd1 vccd1 sky130_fd_sc_hd__fill_1
XFILLER_43_33 vssd1 vssd1 vccd1 vccd1 sky130_fd_sc_hd__fill_1
X_12410_ cell2.CB_1.config_dataB\[20\] cell2.CB_1.config_dataB\[19\] net830 vssd1
+ vssd1 vccd1 vccd1 _00843_ sky130_fd_sc_hd__mux2_1
X_13390_ clknet_leaf_133_clk _00362_ net556 vssd1 vssd1 vccd1 vccd1 cell0.SB0.route_sel\[31\]
+ sky130_fd_sc_hd__dfstp_1
XFILLER_138_165 vssd1 vssd1 vccd1 vccd1 sky130_fd_sc_hd__fill_1
XFILLER_127_839 vssd1 vssd1 vccd1 vccd1 sky130_fd_sc_hd__fill_1
X_12341_ cell1.SB0.route_sel\[79\] cell1.SB0.route_sel\[78\] net861 vssd1 vssd1 vccd1
+ vccd1 _00774_ sky130_fd_sc_hd__mux2_1
X_12272_ cell1.SB0.route_sel\[10\] cell1.SB0.route_sel\[9\] net866 vssd1 vssd1 vccd1
+ vccd1 _00705_ sky130_fd_sc_hd__mux2_1
X_11223_ cell3.CB_0.config_dataB\[19\] _06159_ _06170_ _06174_ vssd1 vssd1 vccd1 vccd1
+ _06175_ sky130_fd_sc_hd__o31ai_1
X_14011_ clknet_leaf_79_clk _00983_ net708 vssd1 vssd1 vccd1 vccd1 cell3.SB0.route_sel\[19\]
+ sky130_fd_sc_hd__dfstp_1
XANTENNA__10543__X _05501_ vssd1 vssd1 vccd1 vccd1 sky130_fd_sc_hd__diode_2
XANTENNA__09040__A1 bus3_1\[9\] vssd1 vssd1 vccd1 vccd1 sky130_fd_sc_hd__diode_2
XFILLER_4_189 vssd1 vssd1 vccd1 vccd1 sky130_fd_sc_hd__fill_4
XFILLER_4_27 vssd1 vssd1 vccd1 vccd1 sky130_fd_sc_hd__fill_1
X_11154_ cell3.CB_0.config_dataB\[9\] _06080_ _06094_ _06105_ _01798_ vssd1 vssd1
+ vccd1 vccd1 _06106_ sky130_fd_sc_hd__a32oi_1
XANTENNA__10262__Y _05263_ vssd1 vssd1 vccd1 vccd1 sky130_fd_sc_hd__diode_2
X_11085_ _06037_ _06038_ _05961_ vssd1 vssd1 vccd1 vccd1 _06039_ sky130_fd_sc_hd__mux2_1
X_10105_ cell2.SB0.route_sel\[119\] _01647_ _01649_ cell2.SB0.route_sel\[116\] _05105_
+ vssd1 vssd1 vccd1 vccd1 _05106_ sky130_fd_sc_hd__a221o_1
X_10036_ net400 _04724_ vssd1 vssd1 vccd1 vccd1 _05040_ sky130_fd_sc_hd__nand2_1
XANTENNA_input29_X net29 vssd1 vssd1 vccd1 vccd1 sky130_fd_sc_hd__diode_2
XANTENNA__10489__A1 _03509_ vssd1 vssd1 vccd1 vccd1 sky130_fd_sc_hd__diode_2
XFILLER_76_686 vssd1 vssd1 vccd1 vccd1 sky130_fd_sc_hd__fill_8
XFILLER_76_664 vssd1 vssd1 vccd1 vccd1 sky130_fd_sc_hd__fill_1
XFILLER_36_528 vssd1 vssd1 vccd1 vccd1 sky130_fd_sc_hd__fill_4
X_11987_ cell0.SB0.route_sel\[93\] cell0.SB0.route_sel\[92\] net787 vssd1 vssd1 vccd1
+ vccd1 _00424_ sky130_fd_sc_hd__mux2_1
X_10938_ cell3.SB0.route_sel\[51\] cell3.SB0.route_sel\[50\] _01711_ cell3.SB0.route_sel\[54\]
+ _05891_ vssd1 vssd1 vccd1 vccd1 _05892_ sky130_fd_sc_hd__o221a_1
X_13726_ clknet_leaf_102_clk _00698_ net676 vssd1 vssd1 vccd1 vccd1 cell1.SB0.route_sel\[3\]
+ sky130_fd_sc_hd__dfstp_1
XFILLER_71_391 vssd1 vssd1 vccd1 vccd1 sky130_fd_sc_hd__fill_1
XTAP_TAPCELL_ROW_63_1259 vssd1 vccd1 sky130_fd_sc_hd__tapvpwrvgnd_1
XTAP_TAPCELL_ROW_63_1248 vssd1 vccd1 sky130_fd_sc_hd__tapvpwrvgnd_1
X_10869_ net286 net279 cell3.LEI0.config_data\[45\] vssd1 vssd1 vccd1 vccd1 _05825_
+ sky130_fd_sc_hd__mux2_1
X_13657_ clknet_leaf_48_clk _00629_ net704 vssd1 vssd1 vccd1 vccd1 cell2.CB_1.config_dataA\[9\]
+ sky130_fd_sc_hd__dfstp_1
XANTENNA__09803__A0 bus3_2\[0\] vssd1 vssd1 vccd1 vccd1 sky130_fd_sc_hd__diode_2
X_12608_ cell3.SB0.route_sel\[73\] cell3.SB0.route_sel\[72\] net876 vssd1 vssd1 vccd1
+ vccd1 _01037_ sky130_fd_sc_hd__mux2_1
X_13588_ clknet_leaf_94_clk _00560_ net692 vssd1 vssd1 vccd1 vccd1 cell1.LEI0.config_data\[9\]
+ sky130_fd_sc_hd__dfrtp_1
XFILLER_12_480 vssd1 vssd1 vccd1 vccd1 sky130_fd_sc_hd__fill_1
XANTENNA__10413__A1 cell2.CB_0.le_outB vssd1 vssd1 vccd1 vccd1 sky130_fd_sc_hd__diode_2
X_12539_ cell3.SB0.route_sel\[4\] cell3.SB0.route_sel\[3\] net935 vssd1 vssd1 vccd1
+ vccd1 _00968_ sky130_fd_sc_hd__mux2_1
XANTENNA__10964__A2 _05912_ vssd1 vssd1 vccd1 vccd1 sky130_fd_sc_hd__diode_2
XFILLER_69_3 vssd1 vssd1 vccd1 vccd1 sky130_fd_sc_hd__fill_1
X_14209_ clknet_leaf_56_clk _01181_ net719 vssd1 vssd1 vccd1 vccd1 cell3.CB_0.config_dataA\[19\]
+ sky130_fd_sc_hd__dfstp_1
XTAP_TAPCELL_ROW_78_1480 vssd1 vccd1 sky130_fd_sc_hd__tapvpwrvgnd_1
XANTENNA__11549__X net220 vssd1 vssd1 vccd1 vccd1 sky130_fd_sc_hd__diode_2
XANTENNA__10453__X bus3_2\[8\] vssd1 vssd1 vccd1 vccd1 sky130_fd_sc_hd__diode_2
XFILLER_125_393 vssd1 vssd1 vccd1 vccd1 sky130_fd_sc_hd__fill_1
Xfanout419 cell2.CB_0.config_dataA\[5\] vssd1 vssd1 vccd1 vccd1 net419 sky130_fd_sc_hd__clkbuf_2
Xfanout408 cell2.CB_1.config_dataB\[1\] vssd1 vssd1 vccd1 vccd1 net408 sky130_fd_sc_hd__clkbuf_2
XFILLER_140_385 vssd1 vssd1 vccd1 vccd1 sky130_fd_sc_hd__fill_2
X_09750_ net444 _04608_ _04755_ vssd1 vssd1 vccd1 vccd1 _04756_ sky130_fd_sc_hd__a21o_1
XTAP_TAPCELL_ROW_91_1680 vssd1 vccd1 sky130_fd_sc_hd__tapvpwrvgnd_1
XFILLER_86_417 vssd1 vssd1 vccd1 vccd1 sky130_fd_sc_hd__fill_2
X_06962_ _02026_ _02027_ vssd1 vssd1 vccd1 vccd1 _02028_ sky130_fd_sc_hd__or2_1
XFILLER_104_17 vssd1 vssd1 vccd1 vccd1 sky130_fd_sc_hd__fill_2
X_09681_ cell2.SB0.route_sel\[119\] _01647_ _04694_ vssd1 vssd1 vccd1 vccd1 _04695_
+ sky130_fd_sc_hd__o21ai_2
XFILLER_39_333 vssd1 vssd1 vccd1 vccd1 sky130_fd_sc_hd__fill_2
XANTENNA__08137__A3 _02350_ vssd1 vssd1 vccd1 vccd1 sky130_fd_sc_hd__diode_2
XANTENNA__08858__X _03890_ vssd1 vssd1 vccd1 vccd1 sky130_fd_sc_hd__diode_2
X_08701_ cell1.LEI0.config_data\[11\] _03733_ _03734_ _03731_ vssd1 vssd1 vccd1 vccd1
+ _03735_ sky130_fd_sc_hd__o211a_2
XANTENNA__11284__X net172 vssd1 vssd1 vccd1 vccd1 sky130_fd_sc_hd__diode_2
XANTENNA__09885__A3 bus3_2\[3\] vssd1 vssd1 vccd1 vccd1 sky130_fd_sc_hd__diode_2
XANTENNA__11725__A net755 vssd1 vssd1 vccd1 vccd1 sky130_fd_sc_hd__diode_2
X_08632_ _01668_ cell1.LE_1A.dff_out net352 vssd1 vssd1 vccd1 vccd1 _03667_ sky130_fd_sc_hd__o21ai_1
X_06893_ net80 _01958_ vssd1 vssd1 vccd1 vccd1 _01961_ sky130_fd_sc_hd__nand2_1
XANTENNA__07896__A2 bus2_0\[14\] vssd1 vssd1 vccd1 vccd1 sky130_fd_sc_hd__diode_2
X_08563_ _03517_ _03587_ _03588_ _03514_ cell1.CB_1.config_dataA\[12\] vssd1 vssd1
+ vccd1 vccd1 _03599_ sky130_fd_sc_hd__a221o_1
XFILLER_120_27 vssd1 vssd1 vccd1 vccd1 sky130_fd_sc_hd__fill_1
XANTENNA__09637__A3 _04637_ vssd1 vssd1 vccd1 vccd1 sky130_fd_sc_hd__diode_2
XANTENNA__08845__A1 bus3_1\[1\] vssd1 vssd1 vccd1 vccd1 sky130_fd_sc_hd__diode_2
X_07514_ net89 _02562_ vssd1 vssd1 vccd1 vccd1 _02566_ sky130_fd_sc_hd__nand2_1
X_08494_ net497 _03529_ vssd1 vssd1 vccd1 vccd1 _03530_ sky130_fd_sc_hd__nand2_1
XANTENNA__06856__A0 net61 vssd1 vssd1 vccd1 vccd1 sky130_fd_sc_hd__diode_2
X_07445_ _02473_ _02496_ _02498_ vssd1 vssd1 vccd1 vccd1 _02499_ sky130_fd_sc_hd__o21a_1
XANTENNA_fanout330_A cell1.CB_0.le_outA vssd1 vssd1 vccd1 vccd1 sky130_fd_sc_hd__diode_2
X_07376_ _02143_ _02356_ vssd1 vssd1 vccd1 vccd1 _02432_ sky130_fd_sc_hd__nor2_1
X_09115_ net477 _03820_ vssd1 vssd1 vccd1 vccd1 _04145_ sky130_fd_sc_hd__nand2_1
XANTENNA__07369__B _02424_ vssd1 vssd1 vccd1 vccd1 sky130_fd_sc_hd__diode_2
XFILLER_13_69 vssd1 vssd1 vccd1 vccd1 sky130_fd_sc_hd__fill_8
X_09046_ _03849_ _04054_ _04055_ _03853_ cell1.CB_0.config_dataB\[2\] vssd1 vssd1
+ vccd1 vccd1 _04076_ sky130_fd_sc_hd__a221o_1
Xhold451 cell3.LE_1A.config_data\[1\] vssd1 vssd1 vccd1 vccd1 net1410 sky130_fd_sc_hd__dlygate4sd3_1
Xhold462 cell2.LEI0.config_data\[46\] vssd1 vssd1 vccd1 vccd1 net1421 sky130_fd_sc_hd__dlygate4sd3_1
Xhold440 cell0.LEI0.config_data\[30\] vssd1 vssd1 vccd1 vccd1 net1399 sky130_fd_sc_hd__dlygate4sd3_1
Xhold484 cell3.LEI0.config_data\[26\] vssd1 vssd1 vccd1 vccd1 net1443 sky130_fd_sc_hd__dlygate4sd3_1
XANTENNA__07033__B1 net63 vssd1 vssd1 vccd1 vccd1 sky130_fd_sc_hd__diode_2
Xhold495 cell3.LEI0.config_data\[6\] vssd1 vssd1 vccd1 vccd1 net1454 sky130_fd_sc_hd__dlygate4sd3_1
Xhold473 _01415_ vssd1 vssd1 vccd1 vccd1 net1432 sky130_fd_sc_hd__dlygate4sd3_1
XFILLER_1_137 vccd1 vssd1 vccd1 vssd1 sky130_ef_sc_hd__decap_40_12
Xfanout931 net932 vssd1 vssd1 vccd1 vccd1 net931 sky130_fd_sc_hd__clkbuf_4
XANTENNA__13684__SET_B net619 vssd1 vssd1 vccd1 vccd1 sky130_fd_sc_hd__diode_2
Xfanout942 net943 vssd1 vssd1 vccd1 vccd1 net942 sky130_fd_sc_hd__clkbuf_2
X_09948_ cell2.CB_1.config_dataB\[4\] _04938_ _04951_ vssd1 vssd1 vccd1 vccd1 _04952_
+ sky130_fd_sc_hd__or3_2
Xfanout920 net934 vssd1 vssd1 vccd1 vccd1 net920 sky130_fd_sc_hd__clkbuf_2
Xfanout953 net956 vssd1 vssd1 vccd1 vccd1 net953 sky130_fd_sc_hd__clkbuf_4
XANTENNA__11132__A2 net51 vssd1 vssd1 vccd1 vccd1 sky130_fd_sc_hd__diode_2
XANTENNA_fanout752_X net752 vssd1 vssd1 vccd1 vccd1 sky130_fd_sc_hd__diode_2
X_09879_ net437 net438 _04641_ cell2.CB_1.config_dataA\[17\] vssd1 vssd1 vccd1 vccd1
+ _04885_ sky130_fd_sc_hd__o31ai_1
XANTENNA__08533__A0 net31 vssd1 vssd1 vccd1 vccd1 sky130_fd_sc_hd__diode_2
X_12890_ cell3.CB_1.config_dataB\[4\] cell3.CB_1.config_dataB\[3\] net947 vssd1 vssd1
+ vccd1 vccd1 _01319_ sky130_fd_sc_hd__mux2_1
Xclkbuf_0_cell1.LE_0B.sel_clk cell1.LE_0B.sel_clk vssd1 vssd1 vccd1 vccd1 clknet_0_cell1.LE_0B.sel_clk
+ sky130_fd_sc_hd__clkbuf_16
XANTENNA__07887__A2 bus2_0\[2\] vssd1 vssd1 vccd1 vccd1 sky130_fd_sc_hd__diode_2
X_11910_ cell0.SB0.route_sel\[16\] cell0.SB0.route_sel\[15\] net762 vssd1 vssd1 vccd1
+ vccd1 _00347_ sky130_fd_sc_hd__mux2_1
XANTENNA_input128_A SBwest_in[9] vssd1 vssd1 vccd1 vccd1 sky130_fd_sc_hd__diode_2
X_11841_ cell1.CB_1.config_dataA\[22\] cell1.CB_1.config_dataA\[21\] net885 vssd1
+ vssd1 vccd1 vccd1 _00278_ sky130_fd_sc_hd__mux2_1
XFILLER_26_550 vssd1 vssd1 vccd1 vccd1 sky130_fd_sc_hd__fill_4
X_11772_ net1337 cell0.LEI0.config_data\[21\] net792 vssd1 vssd1 vccd1 vccd1 _00209_
+ sky130_fd_sc_hd__mux2_1
XFILLER_26_572 vssd1 vssd1 vccd1 vccd1 sky130_fd_sc_hd__fill_8
X_10723_ cell3.LE_1A.config_data\[14\] cell3.LE_1A.config_data\[15\] _05600_ vssd1
+ vssd1 vccd1 vccd1 _05681_ sky130_fd_sc_hd__mux2_1
XTAP_TAPCELL_ROW_103_1849 vssd1 vccd1 sky130_fd_sc_hd__tapvpwrvgnd_1
XANTENNA__06847__B1 _01915_ vssd1 vssd1 vccd1 vccd1 sky130_fd_sc_hd__diode_2
X_13511_ clknet_leaf_104_clk _00483_ net676 vssd1 vssd1 vccd1 vccd1 cell1.CB_1.config_dataB\[24\]
+ sky130_fd_sc_hd__dfstp_1
X_10654_ _01790_ _05611_ vssd1 vssd1 vccd1 vccd1 _05612_ sky130_fd_sc_hd__nand2_1
XFILLER_9_237 vssd1 vssd1 vccd1 vccd1 sky130_fd_sc_hd__fill_1
XANTENNA_input93_A SBsouth_in[6] vssd1 vssd1 vccd1 vccd1 sky130_fd_sc_hd__diode_2
X_13442_ clknet_leaf_129_clk _00414_ net579 vssd1 vssd1 vccd1 vccd1 cell0.SB0.route_sel\[83\]
+ sky130_fd_sc_hd__dfstp_1
XTAP_TAPCELL_ROW_136_2348 vssd1 vccd1 sky130_fd_sc_hd__tapvpwrvgnd_1
XANTENNA__11199__A2 _05893_ vssd1 vssd1 vccd1 vccd1 sky130_fd_sc_hd__diode_2
XFILLER_127_603 vssd1 vssd1 vccd1 vccd1 sky130_fd_sc_hd__fill_1
X_10585_ _04617_ _04623_ _04630_ _05542_ vssd1 vssd1 vccd1 vccd1 _05543_ sky130_fd_sc_hd__a211o_2
X_13373_ clknet_leaf_132_clk _00345_ net558 vssd1 vssd1 vccd1 vccd1 cell0.SB0.route_sel\[14\]
+ sky130_fd_sc_hd__dfstp_1
Xclkload29 clknet_leaf_123_clk vssd1 vssd1 vccd1 vccd1 clkload29/X sky130_fd_sc_hd__clkbuf_4
XTAP_TAPCELL_ROW_11_467 vssd1 vccd1 sky130_fd_sc_hd__tapvpwrvgnd_1
X_12324_ cell1.SB0.route_sel\[62\] cell1.SB0.route_sel\[61\] net856 vssd1 vssd1 vccd1
+ vccd1 _00757_ sky130_fd_sc_hd__mux2_1
XTAP_TAPCELL_ROW_11_478 vssd1 vccd1 sky130_fd_sc_hd__tapvpwrvgnd_1
Xclkload18 clknet_leaf_131_clk vssd1 vssd1 vccd1 vccd1 clkload18/Y sky130_fd_sc_hd__clkinv_2
XFILLER_142_617 vssd1 vssd1 vccd1 vccd1 sky130_fd_sc_hd__fill_1
XFILLER_5_443 vssd1 vssd1 vccd1 vccd1 sky130_fd_sc_hd__fill_4
X_12255_ cell2.CB_0.config_dataA\[18\] cell2.CB_0.config_dataA\[17\] net823 vssd1
+ vssd1 vccd1 vccd1 _00688_ sky130_fd_sc_hd__mux2_1
X_12186_ cell2.LE_1B.reset_mode net1503 net851 vssd1 vssd1 vccd1 vccd1 _00619_ sky130_fd_sc_hd__mux2_1
X_11206_ _06154_ _06155_ _06156_ net382 _06157_ vssd1 vssd1 vccd1 vccd1 _06158_ sky130_fd_sc_hd__a221o_1
X_11137_ net386 _06087_ _06088_ cell3.CB_0.config_dataB\[7\] vssd1 vssd1 vccd1 vccd1
+ _06089_ sky130_fd_sc_hd__a211o_1
XANTENNA__08772__A0 cell1.LE_1B.config_data\[15\] vssd1 vssd1 vccd1 vccd1 sky130_fd_sc_hd__diode_2
XFILLER_1_671 vssd1 vssd1 vccd1 vccd1 sky130_fd_sc_hd__fill_1
X_11068_ _06020_ _06021_ _06012_ _06018_ vssd1 vssd1 vccd1 vccd1 _06022_ sky130_fd_sc_hd__o211a_1
XANTENNA__07054__B1_N net96 vssd1 vssd1 vccd1 vccd1 sky130_fd_sc_hd__diode_2
X_10019_ _05010_ _05011_ _05018_ _05022_ vssd1 vssd1 vccd1 vccd1 _05023_ sky130_fd_sc_hd__o211a_1
XFILLER_64_623 vssd1 vssd1 vccd1 vccd1 sky130_fd_sc_hd__fill_1
XFILLER_17_561 vssd1 vssd1 vccd1 vccd1 sky130_fd_sc_hd__fill_1
XTAP_TAPCELL_ROW_19_589 vssd1 vccd1 sky130_fd_sc_hd__tapvpwrvgnd_1
XANTENNA__10634__A1 net398 vssd1 vssd1 vccd1 vccd1 sky130_fd_sc_hd__diode_2
X_13709_ clknet_leaf_25_clk _00681_ net608 vssd1 vssd1 vccd1 vccd1 cell2.CB_0.config_dataA\[11\]
+ sky130_fd_sc_hd__dfstp_1
XANTENNA__06838__B1 bus3_2\[6\] vssd1 vssd1 vccd1 vccd1 sky130_fd_sc_hd__diode_2
XFILLER_20_715 vssd1 vssd1 vccd1 vccd1 sky130_fd_sc_hd__fill_1
X_07230_ _01973_ _02063_ vssd1 vssd1 vccd1 vccd1 _02290_ sky130_fd_sc_hd__nor2_1
XANTENNA__09252__A1 cell3.SB0.route_sel\[21\] vssd1 vssd1 vccd1 vccd1 sky130_fd_sc_hd__diode_2
X_07161_ net328 _01884_ _02058_ vssd1 vssd1 vccd1 vccd1 _02223_ sky130_fd_sc_hd__or3_1
XFILLER_9_771 vssd1 vssd1 vccd1 vccd1 sky130_fd_sc_hd__fill_1
XTAP_TAPCELL_ROW_30_754 vssd1 vccd1 sky130_fd_sc_hd__tapvpwrvgnd_1
XTAP_TAPCELL_ROW_30_765 vssd1 vccd1 sky130_fd_sc_hd__tapvpwrvgnd_1
X_07092_ net325 _02154_ _02152_ vssd1 vssd1 vccd1 vccd1 _02156_ sky130_fd_sc_hd__o21ai_2
XANTENNA__07476__Y _02529_ vssd1 vssd1 vccd1 vccd1 sky130_fd_sc_hd__diode_2
XFILLER_5_81 vccd1 vssd1 vccd1 vssd1 sky130_ef_sc_hd__decap_40_12
XFILLER_115_27 vccd1 vssd1 vccd1 vssd1 sky130_ef_sc_hd__decap_40_12
X_09802_ cell2.CB_1.config_dataA\[3\] _04803_ _04805_ _04807_ vssd1 vssd1 vccd1 vccd1
+ _04808_ sky130_fd_sc_hd__and4_1
XFILLER_140_182 vssd1 vssd1 vccd1 vccd1 sky130_fd_sc_hd__fill_1
X_07994_ bus2_0\[12\] bus2_0\[13\] bus2_0\[14\] bus2_0\[15\] net531 net529 vssd1 vssd1
+ vccd1 vccd1 _03036_ sky130_fd_sc_hd__mux4_1
XANTENNA_fanout280_A cell3.CB_0.le_outB vssd1 vssd1 vccd1 vccd1 sky130_fd_sc_hd__diode_2
X_09733_ _04744_ _04194_ vssd1 vssd1 vccd1 vccd1 bus2_0\[0\] sky130_fd_sc_hd__and2b_4
X_06945_ cell0.CB_1.config_dataA\[24\] cell0.CB_1.config_dataA\[20\] cell0.CB_1.config_dataA\[21\]
+ vssd1 vssd1 vccd1 vccd1 _02011_ sky130_fd_sc_hd__or3_4
XANTENNA__10322__A0 net61 vssd1 vssd1 vccd1 vccd1 sky130_fd_sc_hd__diode_2
XFILLER_131_15 vccd1 vssd1 vccd1 vssd1 sky130_ef_sc_hd__decap_40_12
X_09664_ _04228_ _04646_ vssd1 vssd1 vccd1 vccd1 _04679_ sky130_fd_sc_hd__nor2_1
X_06876_ _01863_ _01943_ vssd1 vssd1 vccd1 vccd1 _01944_ sky130_fd_sc_hd__nor2_1
X_09595_ _02312_ _04609_ _04611_ vssd1 vssd1 vccd1 vccd1 _04612_ sky130_fd_sc_hd__o21ai_2
X_08615_ cell1.LEI0.config_data\[44\] _03650_ vssd1 vssd1 vccd1 vccd1 _03651_ sky130_fd_sc_hd__and2b_1
XTAP_TAPCELL_ROW_120_2105 vssd1 vccd1 sky130_fd_sc_hd__tapvpwrvgnd_1
XFILLER_82_475 vssd1 vssd1 vccd1 vccd1 sky130_fd_sc_hd__fill_1
XTAP_TAPCELL_ROW_38_876 vssd1 vccd1 sky130_fd_sc_hd__tapvpwrvgnd_1
X_08546_ cell1.CB_1.config_dataA\[9\] _03563_ _03576_ _03581_ vssd1 vssd1 vccd1 vccd1
+ _03582_ sky130_fd_sc_hd__o31ai_2
X_08477_ _01502_ cell1.SB0.route_sel\[9\] cell1.SB0.route_sel\[14\] _01504_ _03512_
+ vssd1 vssd1 vccd1 vccd1 _03513_ sky130_fd_sc_hd__a221o_1
XFILLER_24_57 vssd1 vssd1 vccd1 vccd1 sky130_fd_sc_hd__fill_2
X_07428_ net70 _02480_ _02481_ vssd1 vssd1 vccd1 vccd1 _02482_ sky130_fd_sc_hd__a21oi_1
X_07359_ _02121_ _02336_ vssd1 vssd1 vccd1 vccd1 _02415_ sky130_fd_sc_hd__nor2_1
XANTENNA__09243__A1 net41 vssd1 vssd1 vccd1 vccd1 sky130_fd_sc_hd__diode_2
XTAP_TAPCELL_ROW_118_2078 vssd1 vccd1 sky130_fd_sc_hd__tapvpwrvgnd_1
X_10370_ net429 net427 _05097_ vssd1 vssd1 vccd1 vccd1 _05369_ sky130_fd_sc_hd__or3_1
XTAP_TAPCELL_ROW_131_2267 vssd1 vccd1 sky130_fd_sc_hd__tapvpwrvgnd_1
XANTENNA__12225__S net824 vssd1 vssd1 vccd1 vccd1 sky130_fd_sc_hd__diode_2
X_09029_ bus3_1\[6\] bus3_1\[7\] net486 vssd1 vssd1 vccd1 vccd1 _04059_ sky130_fd_sc_hd__mux2_1
XFILLER_2_413 vssd1 vssd1 vccd1 vccd1 sky130_fd_sc_hd__fill_4
XTAP_TAPCELL_ROW_131_2278 vssd1 vccd1 sky130_fd_sc_hd__tapvpwrvgnd_1
Xhold270 cell3.LE_1B.config_data\[11\] vssd1 vssd1 vccd1 vccd1 net1229 sky130_fd_sc_hd__dlygate4sd3_1
X_12040_ cell1.CB_1.config_dataB\[18\] cell1.CB_1.config_dataB\[17\] net892 vssd1
+ vssd1 vccd1 vccd1 _00477_ sky130_fd_sc_hd__mux2_1
XANTENNA__08349__A3 _02350_ vssd1 vssd1 vccd1 vccd1 sky130_fd_sc_hd__diode_2
XFILLER_2_457 vccd1 vssd1 vccd1 vssd1 sky130_ef_sc_hd__decap_40_12
XANTENNA__10253__B _05084_ vssd1 vssd1 vccd1 vccd1 sky130_fd_sc_hd__diode_2
Xhold292 cell2.LE_1A.config_data\[12\] vssd1 vssd1 vccd1 vccd1 net1251 sky130_fd_sc_hd__dlygate4sd3_1
Xhold281 cell0.LE_0B.config_data\[5\] vssd1 vssd1 vccd1 vccd1 net1240 sky130_fd_sc_hd__dlygate4sd3_1
XANTENNA__08754__A0 net29 vssd1 vssd1 vccd1 vccd1 sky130_fd_sc_hd__diode_2
Xfanout750 net133 vssd1 vssd1 vccd1 vccd1 net750 sky130_fd_sc_hd__buf_4
X_13991_ clknet_1_1__leaf_cell2.LE_0A.sel_clk _00963_ net752 vssd1 vssd1 vccd1 vccd1
+ cell2.LE_0A.dff1_out sky130_fd_sc_hd__dfstp_1
Xfanout772 net773 vssd1 vssd1 vccd1 vccd1 net772 sky130_fd_sc_hd__clkbuf_2
XANTENNA__07843__A _02804_ vssd1 vssd1 vccd1 vccd1 sky130_fd_sc_hd__diode_2
Xfanout794 net798 vssd1 vssd1 vccd1 vccd1 net794 sky130_fd_sc_hd__dlymetal6s2s_1
Xfanout761 net768 vssd1 vssd1 vccd1 vccd1 net761 sky130_fd_sc_hd__clkbuf_2
Xfanout783 net787 vssd1 vssd1 vccd1 vccd1 net783 sky130_fd_sc_hd__clkbuf_4
X_12942_ net1215 net1119 net932 vssd1 vssd1 vccd1 vccd1 _01370_ sky130_fd_sc_hd__mux2_1
XFILLER_46_612 vssd1 vssd1 vccd1 vccd1 sky130_fd_sc_hd__fill_1
XFILLER_1_39 vccd1 vssd1 vccd1 vssd1 sky130_ef_sc_hd__decap_40_12
XANTENNA__10864__A1 _05504_ vssd1 vssd1 vccd1 vccd1 sky130_fd_sc_hd__diode_2
X_12873_ cell2.SB0.route_sel\[115\] cell2.SB0.route_sel\[114\] net818 vssd1 vssd1
+ vccd1 vccd1 _01302_ sky130_fd_sc_hd__mux2_1
XTAP_TAPCELL_ROW_47_1018 vssd1 vccd1 sky130_fd_sc_hd__tapvpwrvgnd_1
XTAP_TAPCELL_ROW_47_1007 vssd1 vccd1 sky130_fd_sc_hd__tapvpwrvgnd_1
XFILLER_14_531 vssd1 vssd1 vccd1 vccd1 sky130_fd_sc_hd__fill_1
XTAP_TAPCELL_ROW_16_548 vssd1 vccd1 sky130_fd_sc_hd__tapvpwrvgnd_1
X_11824_ net495 cell1.CB_1.config_dataA\[4\] net891 vssd1 vssd1 vccd1 vccd1 _00261_
+ sky130_fd_sc_hd__mux2_1
XANTENNA__10077__C1 net351 vssd1 vssd1 vccd1 vccd1 sky130_fd_sc_hd__diode_2
X_11755_ cell0.LEI0.config_data\[5\] net1495 net796 vssd1 vssd1 vccd1 vccd1 _00192_
+ sky130_fd_sc_hd__mux2_1
XTAP_TAPCELL_ROW_60_1207 vssd1 vccd1 sky130_fd_sc_hd__tapvpwrvgnd_1
XANTENNA__08285__A2 _02560_ vssd1 vssd1 vccd1 vccd1 sky130_fd_sc_hd__diode_2
X_14474_ clknet_leaf_61_clk _01446_ net738 vssd1 vssd1 vccd1 vccd1 cell3.LEI0.config_data\[39\]
+ sky130_fd_sc_hd__dfrtp_1
X_10706_ _05658_ _05661_ _05663_ cell3.CB_1.config_dataA\[17\] vssd1 vssd1 vccd1 vccd1
+ _05664_ sky130_fd_sc_hd__o22a_1
XANTENNA_input96_X net96 vssd1 vssd1 vccd1 vccd1 sky130_fd_sc_hd__diode_2
X_11686_ net1152 cell0.LE_1A.config_data\[4\] net801 vssd1 vssd1 vccd1 vccd1 _00126_
+ sky130_fd_sc_hd__mux2_1
X_13425_ clknet_leaf_1_clk _00397_ net560 vssd1 vssd1 vccd1 vccd1 cell0.SB0.route_sel\[66\]
+ sky130_fd_sc_hd__dfstp_1
X_10637_ _05592_ _05593_ _05594_ _05590_ vssd1 vssd1 vccd1 vccd1 _05595_ sky130_fd_sc_hd__o31a_1
Xclkload118 clknet_leaf_71_clk vssd1 vssd1 vccd1 vccd1 clkload118/Y sky130_fd_sc_hd__inv_8
Xclkload107 clknet_leaf_80_clk vssd1 vssd1 vccd1 vccd1 clkload107/Y sky130_fd_sc_hd__inv_6
Xclkload129 clknet_leaf_64_clk vssd1 vssd1 vccd1 vccd1 clkload129/Y sky130_fd_sc_hd__inv_12
XPHY_EDGE_ROW_116_Right_116 vssd1 vssd1 vccd1 vccd1 sky130_fd_sc_hd__decap_3
X_10568_ cell3.SB0.route_sel\[96\] _01736_ cell3.SB0.route_sel\[101\] cell3.SB0.route_sel\[100\]
+ vssd1 vssd1 vccd1 vccd1 _05526_ sky130_fd_sc_hd__o22a_1
X_13356_ clknet_leaf_116_clk _00328_ net666 vssd1 vssd1 vccd1 vccd1 cell1.CB_0.config_dataA\[22\]
+ sky130_fd_sc_hd__dfstp_1
XANTENNA__10395__A3 net35 vssd1 vssd1 vccd1 vccd1 sky130_fd_sc_hd__diode_2
X_13287_ clknet_leaf_95_clk _00259_ net687 vssd1 vssd1 vccd1 vccd1 cell1.CB_1.config_dataA\[3\]
+ sky130_fd_sc_hd__dfstp_1
X_12307_ cell1.SB0.route_sel\[45\] cell1.SB0.route_sel\[44\] net858 vssd1 vssd1 vccd1
+ vccd1 _00740_ sky130_fd_sc_hd__mux2_1
X_10499_ _02048_ _03477_ vssd1 vssd1 vccd1 vccd1 _05465_ sky130_fd_sc_hd__nand2b_1
XFILLER_142_447 vssd1 vssd1 vccd1 vccd1 sky130_fd_sc_hd__fill_1
XANTENNA__11259__B _05139_ vssd1 vssd1 vccd1 vccd1 sky130_fd_sc_hd__diode_2
X_12238_ net420 net421 net818 vssd1 vssd1 vccd1 vccd1 _00671_ sky130_fd_sc_hd__mux2_1
X_12169_ net1294 net1298 net850 vssd1 vssd1 vccd1 vccd1 _00602_ sky130_fd_sc_hd__mux2_1
XTAP_TAPCELL_ROW_71_1369 vssd1 vccd1 sky130_fd_sc_hd__tapvpwrvgnd_1
XANTENNA__08849__A _01979_ vssd1 vssd1 vccd1 vccd1 sky130_fd_sc_hd__diode_2
XFILLER_1_490 vccd1 vssd1 vccd1 vssd1 sky130_ef_sc_hd__decap_40_12
X_06730_ cell3.CB_0.config_dataB\[12\] vssd1 vssd1 vccd1 vccd1 _01800_ sky130_fd_sc_hd__inv_2
Xinput5 CBeast_in[13] vssd1 vssd1 vccd1 vccd1 net5 sky130_fd_sc_hd__clkbuf_4
XANTENNA__10855__A1 _05489_ vssd1 vssd1 vccd1 vccd1 sky130_fd_sc_hd__diode_2
X_06661_ cell3.SB0.route_sel\[85\] vssd1 vssd1 vccd1 vccd1 _01731_ sky130_fd_sc_hd__inv_2
XFILLER_64_453 vssd1 vssd1 vccd1 vccd1 sky130_fd_sc_hd__fill_2
XFILLER_92_784 vssd1 vssd1 vccd1 vccd1 sky130_fd_sc_hd__fill_1
XANTENNA__10855__B2 _05483_ vssd1 vssd1 vccd1 vccd1 sky130_fd_sc_hd__diode_2
XFILLER_64_475 vssd1 vssd1 vccd1 vccd1 sky130_fd_sc_hd__fill_1
X_08400_ bus1_0\[6\] bus1_0\[7\] net501 vssd1 vssd1 vccd1 vccd1 _03438_ sky130_fd_sc_hd__mux2_1
XFILLER_25_818 vssd1 vssd1 vccd1 vccd1 sky130_fd_sc_hd__fill_1
XFILLER_37_689 vssd1 vssd1 vccd1 vccd1 sky130_fd_sc_hd__fill_1
X_09380_ _04403_ vssd1 vssd1 vccd1 vccd1 _04404_ sky130_fd_sc_hd__inv_2
X_06592_ cell1.LE_1B.config_data\[16\] vssd1 vssd1 vccd1 vccd1 _01662_ sky130_fd_sc_hd__inv_2
XTAP_TAPCELL_ROW_35_835 vssd1 vccd1 sky130_fd_sc_hd__tapvpwrvgnd_1
XANTENNA__08276__A2 _02277_ vssd1 vssd1 vccd1 vccd1 sky130_fd_sc_hd__diode_2
X_08331_ cell0.CB_1.config_dataB\[2\] _03366_ _03367_ _03368_ vssd1 vssd1 vccd1 vccd1
+ _03369_ sky130_fd_sc_hd__and4_1
X_08262_ _03301_ _03300_ _03231_ vssd1 vssd1 vccd1 vccd1 _03302_ sky130_fd_sc_hd__mux2_1
XFILLER_32_361 vssd1 vssd1 vccd1 vccd1 sky130_fd_sc_hd__fill_1
XFILLER_20_556 vccd1 vssd1 vccd1 vssd1 sky130_ef_sc_hd__decap_40_12
X_07213_ cell0.SB0.route_sel\[88\] cell0.SB0.route_sel\[89\] _02269_ _02272_ vssd1
+ vssd1 vccd1 vccd1 _02273_ sky130_fd_sc_hd__o2bb2a_1
X_08193_ net538 net540 vssd1 vssd1 vccd1 vccd1 _03233_ sky130_fd_sc_hd__and2b_1
XANTENNA__11032__A1 _05916_ vssd1 vssd1 vccd1 vccd1 sky130_fd_sc_hd__diode_2
X_07144_ bus2_0\[10\] _02204_ _02205_ _02201_ vssd1 vssd1 vccd1 vccd1 _02206_ sky130_fd_sc_hd__a211oi_1
XANTENNA__07787__A1 _02827_ vssd1 vssd1 vccd1 vccd1 sky130_fd_sc_hd__diode_2
XANTENNA__08579__A3 net323 vssd1 vssd1 vccd1 vccd1 sky130_fd_sc_hd__diode_2
XFILLER_10_15 vccd1 vssd1 vccd1 vssd1 sky130_ef_sc_hd__decap_40_12
X_07075_ cell1.SB0.route_sel\[78\] cell1.SB0.route_sel\[79\] _02113_ _02138_ vssd1
+ vssd1 vccd1 vccd1 _02139_ sky130_fd_sc_hd__a211o_1
XFILLER_133_458 vssd1 vssd1 vccd1 vccd1 sky130_fd_sc_hd__fill_1
XFILLER_133_447 vssd1 vssd1 vccd1 vccd1 sky130_fd_sc_hd__fill_1
XANTENNA__10791__B1 _04370_ vssd1 vssd1 vccd1 vccd1 sky130_fd_sc_hd__diode_2
XFILLER_114_683 vssd1 vssd1 vccd1 vccd1 sky130_fd_sc_hd__fill_1
XANTENNA__08200__A2 _02039_ vssd1 vssd1 vccd1 vccd1 sky130_fd_sc_hd__diode_2
X_07977_ cell0.LE_0A.config_data\[11\] cell0.LE_0A.config_data\[10\] _02947_ vssd1
+ vssd1 vccd1 vccd1 _03021_ sky130_fd_sc_hd__mux2_1
XANTENNA__07663__A net342 vssd1 vssd1 vccd1 vccd1 sky130_fd_sc_hd__diode_2
XANTENNA__11456__Y net211 vssd1 vssd1 vccd1 vccd1 sky130_fd_sc_hd__diode_2
XANTENNA__11099__A1 net54 vssd1 vssd1 vccd1 vccd1 sky130_fd_sc_hd__diode_2
X_09716_ _04356_ _04649_ vssd1 vssd1 vccd1 vccd1 _04729_ sky130_fd_sc_hd__nor2_1
X_06928_ cell2.CB_1.config_dataA\[24\] cell2.CB_1.config_dataA\[20\] cell2.CB_1.config_dataA\[21\]
+ vssd1 vssd1 vccd1 vccd1 _01995_ sky130_fd_sc_hd__nand3b_1
XFILLER_19_57 vccd1 vssd1 vccd1 vssd1 sky130_ef_sc_hd__decap_40_12
XFILLER_28_612 vssd1 vssd1 vccd1 vccd1 sky130_fd_sc_hd__fill_1
XANTENNA__10846__A1 _05531_ vssd1 vssd1 vccd1 vccd1 sky130_fd_sc_hd__diode_2
XFILLER_27_111 vssd1 vssd1 vccd1 vccd1 sky130_fd_sc_hd__fill_1
XANTENNA_fanout927_A net929 vssd1 vssd1 vccd1 vccd1 sky130_fd_sc_hd__diode_2
X_09647_ cell3.SB0.route_sel\[102\] cell3.SB0.route_sel\[103\] vssd1 vssd1 vccd1 vccd1
+ _04663_ sky130_fd_sc_hd__nor2_1
X_06859_ cell2.SB0.route_sel\[48\] cell2.SB0.route_sel\[49\] _01918_ _01927_ net810
+ vssd1 vssd1 vccd1 vccd1 _01928_ sky130_fd_sc_hd__a311oi_2
XANTENNA_fanout548_X net548 vssd1 vssd1 vccd1 vccd1 sky130_fd_sc_hd__diode_2
X_09578_ _04313_ _04543_ vssd1 vssd1 vccd1 vccd1 _04596_ sky130_fd_sc_hd__nor2_1
XTAP_TAPCELL_ROW_100_1808 vssd1 vccd1 sky130_fd_sc_hd__tapvpwrvgnd_1
XTAP_TAPCELL_ROW_13_507 vssd1 vccd1 sky130_fd_sc_hd__tapvpwrvgnd_1
X_08529_ net494 _03486_ _03564_ net493 vssd1 vssd1 vccd1 vccd1 _03565_ sky130_fd_sc_hd__o211ai_1
XFILLER_70_489 vssd1 vssd1 vccd1 vccd1 sky130_fd_sc_hd__fill_4
X_11540_ _02630_ _06360_ vssd1 vssd1 vccd1 vccd1 net230 sky130_fd_sc_hd__and2b_2
XANTENNA__08781__X cell1.CB_1.le_outB vssd1 vssd1 vccd1 vccd1 sky130_fd_sc_hd__diode_2
XTAP_TAPCELL_ROW_133_2307 vssd1 vccd1 sky130_fd_sc_hd__tapvpwrvgnd_1
XFILLER_7_538 vssd1 vssd1 vccd1 vccd1 sky130_fd_sc_hd__fill_1
X_11471_ _02230_ _06314_ vssd1 vssd1 vccd1 vccd1 net216 sky130_fd_sc_hd__nor2_1
X_10422_ cell2.LE_0B.config_data\[9\] cell2.LE_0B.config_data\[8\] _05344_ vssd1 vssd1
+ vccd1 vccd1 _05421_ sky130_fd_sc_hd__mux2_1
X_14190_ clknet_leaf_60_clk _01162_ net737 vssd1 vssd1 vccd1 vccd1 cell3.CB_0.config_dataA\[0\]
+ sky130_fd_sc_hd__dfstp_1
X_13210_ clknet_leaf_12_clk _00182_ net588 vssd1 vssd1 vccd1 vccd1 cell0.LE_0A.edge_mode
+ sky130_fd_sc_hd__dfstp_1
XFILLER_137_797 vccd1 vssd1 vccd1 vssd1 sky130_ef_sc_hd__decap_40_12
XFILLER_136_274 vssd1 vssd1 vccd1 vccd1 sky130_fd_sc_hd__fill_1
X_10353_ net428 _05144_ vssd1 vssd1 vccd1 vccd1 _05352_ sky130_fd_sc_hd__nand2_1
XANTENNA__10782__A0 _05475_ vssd1 vssd1 vccd1 vccd1 sky130_fd_sc_hd__diode_2
X_13141_ clknet_leaf_124_clk _00113_ net579 vssd1 vssd1 vccd1 vccd1 cell0.CB_1.config_dataB\[18\]
+ sky130_fd_sc_hd__dfstp_1
XFILLER_2_221 vccd1 vssd1 vccd1 vssd1 sky130_ef_sc_hd__decap_40_12
X_13072_ clknet_leaf_111_clk _00044_ net654 vssd1 vssd1 vccd1 vccd1 cell0.CB_1.config_dataA\[24\]
+ sky130_fd_sc_hd__dfstp_1
XANTENNA_input56_A CBnorth_in[30] vssd1 vssd1 vccd1 vccd1 sky130_fd_sc_hd__diode_2
X_10284_ _05139_ _05281_ _05282_ _05136_ vssd1 vssd1 vccd1 vccd1 _05283_ sky130_fd_sc_hd__a2bb2o_1
XFILLER_3_777 vssd1 vssd1 vccd1 vccd1 sky130_fd_sc_hd__fill_4
XFILLER_2_265 vccd1 vssd1 vccd1 vssd1 sky130_ef_sc_hd__decap_40_12
X_12023_ net460 net462 net891 vssd1 vssd1 vccd1 vccd1 _00460_ sky130_fd_sc_hd__mux2_1
XANTENNA__10534__B1 _05489_ vssd1 vssd1 vccd1 vccd1 sky130_fd_sc_hd__diode_2
XFILLER_116_81 vssd1 vssd1 vccd1 vccd1 sky130_fd_sc_hd__fill_1
XANTENNA__08742__A3 net3 vssd1 vssd1 vccd1 vccd1 sky130_fd_sc_hd__diode_2
Xfanout591 net592 vssd1 vssd1 vccd1 vccd1 net591 sky130_fd_sc_hd__dlymetal6s2s_1
XTAP_TAPCELL_ROW_53_1099 vssd1 vccd1 sky130_fd_sc_hd__tapvpwrvgnd_1
Xfanout580 net581 vssd1 vssd1 vccd1 vccd1 net580 sky130_fd_sc_hd__clkbuf_2
XANTENNA_input11_X net11 vssd1 vssd1 vccd1 vccd1 sky130_fd_sc_hd__diode_2
X_13974_ clknet_leaf_41_clk _00946_ net642 vssd1 vssd1 vccd1 vccd1 cell2.LEI0.config_data\[31\]
+ sky130_fd_sc_hd__dfrtp_1
XANTENNA__09152__A0 net317 vssd1 vssd1 vccd1 vccd1 sky130_fd_sc_hd__diode_2
XFILLER_76_96 vssd1 vssd1 vccd1 vccd1 sky130_fd_sc_hd__fill_1
XANTENNA__07860__X _02904_ vssd1 vssd1 vccd1 vccd1 sky130_fd_sc_hd__diode_2
XFILLER_19_645 vssd1 vssd1 vccd1 vccd1 sky130_fd_sc_hd__fill_1
X_12925_ net978 net1101 net953 vssd1 vssd1 vccd1 vccd1 _01354_ sky130_fd_sc_hd__mux2_1
XFILLER_46_475 vssd1 vssd1 vccd1 vccd1 sky130_fd_sc_hd__fill_1
XANTENNA_output212_A net212 vssd1 vssd1 vccd1 vccd1 sky130_fd_sc_hd__diode_2
X_12856_ cell2.SB0.route_sel\[98\] cell2.SB0.route_sel\[97\] net833 vssd1 vssd1 vccd1
+ vccd1 _01285_ sky130_fd_sc_hd__mux2_1
XANTENNA__09455__A1 _04469_ vssd1 vssd1 vccd1 vccd1 sky130_fd_sc_hd__diode_2
X_11807_ net1553 cell1.LE_1B.config_data\[7\] net901 vssd1 vssd1 vccd1 vccd1 _00244_
+ sky130_fd_sc_hd__mux2_1
X_12787_ cell2.SB0.route_sel\[29\] cell2.SB0.route_sel\[28\] net777 vssd1 vssd1 vccd1
+ vccd1 _01216_ sky130_fd_sc_hd__mux2_1
X_11738_ net1065 net999 net808 vssd1 vssd1 vccd1 vccd1 _00176_ sky130_fd_sc_hd__mux2_1
X_14457_ clknet_leaf_67_clk _01429_ net736 vssd1 vssd1 vccd1 vccd1 cell3.LEI0.config_data\[22\]
+ sky130_fd_sc_hd__dfrtp_1
X_11669_ cell0.CB_1.config_dataB\[15\] cell0.CB_1.config_dataB\[14\] net788 vssd1
+ vssd1 vccd1 vccd1 _00110_ sky130_fd_sc_hd__mux2_1
XANTENNA__11014__A1 net50 vssd1 vssd1 vccd1 vccd1 sky130_fd_sc_hd__diode_2
X_14388_ clknet_leaf_66_clk _01360_ net746 vssd1 vssd1 vccd1 vccd1 cell3.LE_1A.reset_mode
+ sky130_fd_sc_hd__dfrtp_1
X_13408_ clknet_leaf_134_clk _00380_ net555 vssd1 vssd1 vccd1 vccd1 cell0.SB0.route_sel\[49\]
+ sky130_fd_sc_hd__dfstp_2
X_13339_ clknet_leaf_83_clk _00311_ net674 vssd1 vssd1 vccd1 vccd1 cell1.CB_0.config_dataA\[5\]
+ sky130_fd_sc_hd__dfstp_1
XTAP_TAPCELL_ROW_73_1409 vssd1 vccd1 sky130_fd_sc_hd__tapvpwrvgnd_1
XFILLER_115_469 vssd1 vssd1 vccd1 vccd1 sky130_fd_sc_hd__fill_1
XPHY_EDGE_ROW_102_Left_245 vssd1 vssd1 vccd1 vccd1 sky130_fd_sc_hd__decap_3
X_08880_ _03911_ vssd1 vssd1 vccd1 vccd1 _03912_ sky130_fd_sc_hd__inv_2
X_07900_ net344 net347 cell0.CB_1.le_outA cell0.CB_1.le_outB cell0.LEI0.config_data\[0\]
+ cell0.LEI0.config_data\[1\] vssd1 vssd1 vccd1 vccd1 _02944_ sky130_fd_sc_hd__mux4_1
XANTENNA__11557__X _06372_ vssd1 vssd1 vccd1 vccd1 sky130_fd_sc_hd__diode_2
X_07831_ net519 _02301_ vssd1 vssd1 vccd1 vccd1 _02875_ sky130_fd_sc_hd__nand2_1
XANTENNA__07941__A1 bus2_0\[7\] vssd1 vssd1 vccd1 vccd1 sky130_fd_sc_hd__diode_2
XTAP_TAPCELL_ROW_88_1630 vssd1 vccd1 sky130_fd_sc_hd__tapvpwrvgnd_1
X_09501_ cell3.SB0.route_sel\[56\] _01713_ vssd1 vssd1 vccd1 vccd1 _04522_ sky130_fd_sc_hd__nand2_1
X_07762_ net360 net358 _02804_ _02806_ vssd1 vssd1 vccd1 vccd1 _02808_ sky130_fd_sc_hd__o211ai_2
X_06713_ cell3.LE_1B.config_data\[16\] vssd1 vssd1 vccd1 vccd1 _01783_ sky130_fd_sc_hd__inv_2
XFILLER_71_209 vssd1 vssd1 vccd1 vccd1 sky130_fd_sc_hd__fill_1
X_07693_ _02738_ _02740_ vssd1 vssd1 vccd1 vccd1 bus1_0\[2\] sky130_fd_sc_hd__nor2_2
X_09432_ _04424_ _04454_ vssd1 vssd1 vccd1 vccd1 _04455_ sky130_fd_sc_hd__nor2_1
X_06644_ cell3.SB0.route_sel\[59\] vssd1 vssd1 vccd1 vccd1 _01714_ sky130_fd_sc_hd__inv_2
XPHY_EDGE_ROW_111_Left_254 vssd1 vssd1 vccd1 vccd1 sky130_fd_sc_hd__decap_3
X_06575_ cell2.SB0.route_sel\[115\] vssd1 vssd1 vccd1 vccd1 _01645_ sky130_fd_sc_hd__inv_2
X_09363_ net314 _04378_ vssd1 vssd1 vccd1 vccd1 _04387_ sky130_fd_sc_hd__and2_1
XANTENNA__11253__A1 _05152_ vssd1 vssd1 vccd1 vccd1 sky130_fd_sc_hd__diode_2
XANTENNA__07457__B1 bus3_1\[14\] vssd1 vssd1 vccd1 vccd1 sky130_fd_sc_hd__diode_2
XANTENNA__08249__A2 bus1_0\[2\] vssd1 vssd1 vccd1 vccd1 sky130_fd_sc_hd__diode_2
X_08314_ _02678_ _03350_ _03351_ _02633_ cell0.CB_1.config_dataB\[2\] vssd1 vssd1
+ vccd1 vccd1 _03352_ sky130_fd_sc_hd__a221o_1
XANTENNA_10 _05992_ vssd1 vssd1 vccd1 vccd1 sky130_fd_sc_hd__diode_2
XANTENNA_32 CBeast_in[16] vssd1 vssd1 vccd1 vccd1 sky130_fd_sc_hd__diode_2
XANTENNA__09997__A2 bus3_2\[13\] vssd1 vssd1 vccd1 vccd1 sky130_fd_sc_hd__diode_2
X_09294_ net551 _04319_ vssd1 vssd1 vccd1 vccd1 _04320_ sky130_fd_sc_hd__nand2_1
XANTENNA_21 net142 vssd1 vssd1 vccd1 vccd1 sky130_fd_sc_hd__diode_2
XANTENNA_43 net1508 vssd1 vssd1 vccd1 vccd1 sky130_fd_sc_hd__diode_2
X_08245_ cell0.CB_1.config_dataA\[18\] cell0.CB_1.config_dataA\[17\] vssd1 vssd1 vccd1
+ vccd1 _03285_ sky130_fd_sc_hd__nor2_1
XANTENNA__11005__A1 net279 vssd1 vssd1 vccd1 vccd1 sky130_fd_sc_hd__diode_2
XFILLER_122_9 vccd1 vssd1 vccd1 vssd1 sky130_ef_sc_hd__decap_40_12
XTAP_TAPCELL_ROW_115_2037 vssd1 vccd1 sky130_fd_sc_hd__tapvpwrvgnd_1
XTAP_TAPCELL_ROW_115_2026 vssd1 vccd1 sky130_fd_sc_hd__tapvpwrvgnd_1
XANTENNA__09749__A2 _04583_ vssd1 vssd1 vccd1 vccd1 sky130_fd_sc_hd__diode_2
X_08176_ net542 _02494_ net541 vssd1 vssd1 vccd1 vccd1 _03216_ sky130_fd_sc_hd__o21ai_1
XTAP_TAPCELL_ROW_99_1792 vssd1 vccd1 sky130_fd_sc_hd__tapvpwrvgnd_1
X_07127_ cell1.SB0.route_sel\[80\] cell1.SB0.route_sel\[81\] vssd1 vssd1 vccd1 vccd1
+ _02189_ sky130_fd_sc_hd__nand2_1
XFILLER_137_69 vccd1 vssd1 vccd1 vssd1 sky130_ef_sc_hd__decap_40_12
XANTENNA_clkbuf_leaf_63_clk_A clknet_4_15_0_clk vssd1 vssd1 vccd1 vccd1 sky130_fd_sc_hd__diode_2
XFILLER_134_778 vssd1 vssd1 vccd1 vccd1 sky130_fd_sc_hd__fill_2
XPHY_EDGE_ROW_120_Left_263 vssd1 vssd1 vccd1 vccd1 sky130_fd_sc_hd__decap_3
XANTENNA__11308__A2 _05475_ vssd1 vssd1 vccd1 vccd1 sky130_fd_sc_hd__diode_2
X_07058_ _02027_ _02121_ vssd1 vssd1 vccd1 vccd1 _02122_ sky130_fd_sc_hd__nor2_1
Xoutput150 net150 vssd1 vssd1 vccd1 vccd1 CBeast_out[24] sky130_fd_sc_hd__buf_2
Xoutput161 net161 vssd1 vssd1 vccd1 vccd1 CBeast_out[5] sky130_fd_sc_hd__buf_2
Xoutput183 net183 vssd1 vssd1 vccd1 vccd1 CBnorth_out[25] sky130_fd_sc_hd__buf_2
Xoutput172 net172 vssd1 vssd1 vccd1 vccd1 CBnorth_out[15] sky130_fd_sc_hd__buf_2
Xoutput194 net194 vssd1 vssd1 vccd1 vccd1 CBnorth_out[6] sky130_fd_sc_hd__buf_2
XANTENNA_input3_X net3 vssd1 vssd1 vccd1 vccd1 sky130_fd_sc_hd__diode_2
XANTENNA__09921__A2 bus3_2\[1\] vssd1 vssd1 vccd1 vccd1 sky130_fd_sc_hd__diode_2
XANTENNA_clkbuf_leaf_78_clk_A clknet_4_12_0_clk vssd1 vssd1 vccd1 vccd1 sky130_fd_sc_hd__diode_2
XANTENNA__08185__B2 _02136_ vssd1 vssd1 vccd1 vccd1 sky130_fd_sc_hd__diode_2
XFILLER_87_397 vssd1 vssd1 vccd1 vccd1 sky130_fd_sc_hd__fill_2
XANTENNA__07932__A1 net346 vssd1 vssd1 vccd1 vccd1 sky130_fd_sc_hd__diode_2
XANTENNA__08001__B _02897_ vssd1 vssd1 vccd1 vccd1 sky130_fd_sc_hd__diode_2
XANTENNA_clkbuf_leaf_121_clk_A clknet_4_3_0_clk vssd1 vssd1 vccd1 vccd1 sky130_fd_sc_hd__diode_2
XTAP_TAPCELL_ROW_126_2199 vssd1 vccd1 sky130_fd_sc_hd__tapvpwrvgnd_1
X_10971_ _05858_ _05924_ vssd1 vssd1 vccd1 vccd1 _05925_ sky130_fd_sc_hd__nor2_1
XANTENNA__10819__A1 _05510_ vssd1 vssd1 vccd1 vccd1 sky130_fd_sc_hd__diode_2
XANTENNA__09685__A1 _02518_ vssd1 vssd1 vccd1 vccd1 sky130_fd_sc_hd__diode_2
XFILLER_71_710 vssd1 vssd1 vccd1 vccd1 sky130_fd_sc_hd__fill_1
X_13690_ clknet_leaf_29_clk _00662_ net622 vssd1 vssd1 vccd1 vccd1 cell2.CB_0.config_dataB\[17\]
+ sky130_fd_sc_hd__dfstp_1
X_12710_ cell3.CB_0.config_dataB\[2\] net388 net926 vssd1 vssd1 vccd1 vccd1 _01139_
+ sky130_fd_sc_hd__mux2_1
XANTENNA_input110_A SBwest_in[21] vssd1 vssd1 vccd1 vccd1 sky130_fd_sc_hd__diode_2
X_12641_ cell3.SB0.route_sel\[106\] cell3.SB0.route_sel\[105\] net921 vssd1 vssd1
+ vccd1 vccd1 _01070_ sky130_fd_sc_hd__mux2_1
XFILLER_15_169 vssd1 vssd1 vccd1 vccd1 sky130_fd_sc_hd__fill_2
XFILLER_102_83 vssd1 vssd1 vccd1 vccd1 sky130_fd_sc_hd__fill_1
XFILLER_71_798 vssd1 vssd1 vccd1 vccd1 sky130_fd_sc_hd__fill_1
XTAP_TAPCELL_ROW_26_698 vssd1 vccd1 sky130_fd_sc_hd__tapvpwrvgnd_1
XFILLER_30_106 vssd1 vssd1 vccd1 vccd1 sky130_fd_sc_hd__fill_1
XANTENNA_clkbuf_leaf_16_clk_A clknet_4_6_0_clk vssd1 vssd1 vccd1 vccd1 sky130_fd_sc_hd__diode_2
X_12572_ cell3.SB0.route_sel\[37\] cell3.SB0.route_sel\[36\] net876 vssd1 vssd1 vccd1
+ vccd1 _01001_ sky130_fd_sc_hd__mux2_1
XFILLER_30_139 vssd1 vssd1 vccd1 vccd1 sky130_fd_sc_hd__fill_1
X_11523_ _01637_ cell2.SB0.route_sel\[98\] vssd1 vssd1 vccd1 vccd1 _06349_ sky130_fd_sc_hd__nand2_1
X_14311_ clknet_leaf_43_clk _01283_ net628 vssd1 vssd1 vccd1 vccd1 cell2.SB0.route_sel\[96\]
+ sky130_fd_sc_hd__dfstp_2
XANTENNA__09400__X _04423_ vssd1 vssd1 vccd1 vccd1 sky130_fd_sc_hd__diode_2
XFILLER_7_324 vssd1 vssd1 vccd1 vccd1 sky130_fd_sc_hd__fill_2
XFILLER_7_27 vccd1 vssd1 vccd1 vssd1 sky130_ef_sc_hd__decap_40_12
XANTENNA__08660__A2 net458 vssd1 vssd1 vccd1 vccd1 sky130_fd_sc_hd__diode_2
X_14242_ clknet_leaf_19_clk _01214_ net611 vssd1 vssd1 vccd1 vccd1 cell2.SB0.route_sel\[27\]
+ sky130_fd_sc_hd__dfstp_1
X_11454_ cell1.SB0.route_sel\[41\] cell1.SB0.route_sel\[40\] vssd1 vssd1 vccd1 vccd1
+ _06303_ sky130_fd_sc_hd__nand2b_1
X_10405_ cell2.CB_0.config_dataB\[18\] cell2.CB_0.config_dataB\[17\] vssd1 vssd1 vccd1
+ vccd1 _05404_ sky130_fd_sc_hd__or2_1
XFILLER_7_368 vssd1 vssd1 vccd1 vccd1 sky130_fd_sc_hd__fill_1
X_14173_ clknet_leaf_56_clk _01145_ net721 vssd1 vssd1 vccd1 vccd1 cell3.CB_0.config_dataB\[8\]
+ sky130_fd_sc_hd__dfstp_1
XANTENNA__10755__A0 net8 vssd1 vssd1 vccd1 vccd1 sky130_fd_sc_hd__diode_2
XFILLER_3_530 vccd1 vssd1 vccd1 vssd1 sky130_ef_sc_hd__decap_40_12
X_11385_ cell0.SB0.route_sel\[62\] cell0.SB0.route_sel\[63\] vssd1 vssd1 vccd1 vccd1
+ _06257_ sky130_fd_sc_hd__or2_1
XANTENNA_input59_X net59 vssd1 vssd1 vccd1 vccd1 sky130_fd_sc_hd__diode_2
X_10336_ _05328_ _05330_ _05333_ _05334_ vssd1 vssd1 vccd1 vccd1 _05335_ sky130_fd_sc_hd__a22o_1
XTAP_TAPCELL_ROW_55_1139 vssd1 vccd1 sky130_fd_sc_hd__tapvpwrvgnd_1
XTAP_TAPCELL_ROW_55_1128 vssd1 vccd1 sky130_fd_sc_hd__tapvpwrvgnd_1
X_13124_ clknet_leaf_124_clk _00096_ net583 vssd1 vssd1 vccd1 vccd1 cell0.CB_1.config_dataB\[1\]
+ sky130_fd_sc_hd__dfstp_1
X_10267_ _05267_ _05232_ _05230_ vssd1 vssd1 vccd1 vccd1 _05268_ sky130_fd_sc_hd__mux2_1
XFILLER_87_51 vssd1 vssd1 vccd1 vccd1 sky130_fd_sc_hd__fill_4
Xclkbuf_4_9_0_clk clknet_0_clk vssd1 vssd1 vccd1 vccd1 clknet_4_9_0_clk sky130_fd_sc_hd__clkbuf_8
X_13055_ clknet_leaf_126_clk _00027_ net582 vssd1 vssd1 vccd1 vccd1 cell0.CB_1.config_dataA\[7\]
+ sky130_fd_sc_hd__dfstp_2
XFILLER_3_585 vccd1 vssd1 vccd1 vssd1 sky130_ef_sc_hd__decap_40_12
X_12006_ cell0.SB0.route_sel\[112\] cell0.SB0.route_sel\[111\] net758 vssd1 vssd1
+ vccd1 vccd1 _00443_ sky130_fd_sc_hd__mux2_1
XANTENNA__11180__A0 _05912_ vssd1 vssd1 vccd1 vccd1 sky130_fd_sc_hd__diode_2
XFILLER_120_450 vssd1 vssd1 vccd1 vccd1 sky130_fd_sc_hd__fill_1
X_10198_ net415 _05107_ _05198_ cell2.CB_0.config_dataA\[11\] vssd1 vssd1 vccd1 vccd1
+ _05199_ sky130_fd_sc_hd__o211a_1
XANTENNA__07923__B2 _02456_ vssd1 vssd1 vccd1 vccd1 sky130_fd_sc_hd__diode_2
XANTENNA__07923__A1 _02388_ vssd1 vssd1 vccd1 vccd1 sky130_fd_sc_hd__diode_2
X_13957_ clknet_leaf_43_clk _00929_ net635 vssd1 vssd1 vccd1 vccd1 cell2.LEI0.config_data\[14\]
+ sky130_fd_sc_hd__dfrtp_1
XFILLER_81_518 vssd1 vssd1 vccd1 vccd1 sky130_fd_sc_hd__fill_1
X_12908_ net363 cell3.CB_1.config_dataB\[21\] net936 vssd1 vssd1 vccd1 vccd1 _01337_
+ sky130_fd_sc_hd__mux2_1
X_13888_ clknet_leaf_40_clk net981 net714 vssd1 vssd1 vccd1 vccd1 cell2.LE_1A.config_data\[11\]
+ sky130_fd_sc_hd__dfrtp_1
XFILLER_99_3 vssd1 vssd1 vccd1 vccd1 sky130_fd_sc_hd__fill_4
XTAP_TAPCELL_ROW_83_1560 vssd1 vccd1 sky130_fd_sc_hd__tapvpwrvgnd_1
X_12839_ cell2.SB0.route_sel\[81\] cell2.SB0.route_sel\[80\] net830 vssd1 vssd1 vccd1
+ vccd1 _01268_ sky130_fd_sc_hd__mux2_1
XTAP_TAPCELL_ROW_45_985 vssd1 vccd1 sky130_fd_sc_hd__tapvpwrvgnd_1
XFILLER_34_489 vssd1 vssd1 vccd1 vccd1 sky130_fd_sc_hd__fill_1
XANTENNA__10456__X bus3_2\[9\] vssd1 vssd1 vccd1 vccd1 sky130_fd_sc_hd__diode_2
Xinput30 CBeast_in[7] vssd1 vssd1 vccd1 vccd1 net30 sky130_fd_sc_hd__clkbuf_4
X_08030_ net533 _01913_ _03071_ net532 vssd1 vssd1 vccd1 vccd1 _03072_ sky130_fd_sc_hd__o211a_1
Xinput52 CBnorth_in[27] vssd1 vssd1 vccd1 vccd1 net52 sky130_fd_sc_hd__buf_2
Xinput41 CBnorth_in[17] vssd1 vssd1 vccd1 vccd1 net41 sky130_fd_sc_hd__clkbuf_4
Xinput63 CBnorth_in[8] vssd1 vssd1 vccd1 vccd1 net63 sky130_fd_sc_hd__buf_2
XANTENNA__08939__A0 bus3_1\[6\] vssd1 vssd1 vccd1 vccd1 sky130_fd_sc_hd__diode_2
XANTENNA__09600__A1 _04612_ vssd1 vssd1 vccd1 vccd1 sky130_fd_sc_hd__diode_2
Xinput96 SBsouth_in[9] vssd1 vssd1 vccd1 vccd1 net96 sky130_fd_sc_hd__clkbuf_2
Xinput74 SBsouth_in[18] vssd1 vssd1 vccd1 vccd1 net74 sky130_fd_sc_hd__buf_1
Xinput85 SBsouth_in[28] vssd1 vssd1 vccd1 vccd1 net85 sky130_fd_sc_hd__dlymetal6s2s_1
XANTENNA__07206__A3 net99 vssd1 vssd1 vccd1 vccd1 sky130_fd_sc_hd__diode_2
X_09981_ cell2.CB_1.config_dataB\[8\] _04976_ _04980_ _04984_ cell2.CB_1.config_dataB\[9\]
+ vssd1 vssd1 vccd1 vccd1 _04985_ sky130_fd_sc_hd__a41o_1
X_08932_ _03962_ _03963_ vssd1 vssd1 vccd1 vccd1 _03964_ sky130_fd_sc_hd__nor2_1
X_08863_ _03827_ _03890_ _03894_ _03831_ _01679_ vssd1 vssd1 vccd1 vccd1 _03895_ sky130_fd_sc_hd__a221o_1
XFILLER_123_27 vccd1 vssd1 vccd1 vssd1 sky130_ef_sc_hd__decap_40_12
X_07814_ _01885_ _02151_ vssd1 vssd1 vccd1 vccd1 _02859_ sky130_fd_sc_hd__or2_1
X_08794_ _03825_ vssd1 vssd1 vccd1 vccd1 _03826_ sky130_fd_sc_hd__inv_2
XFILLER_38_751 vssd1 vssd1 vccd1 vccd1 sky130_fd_sc_hd__fill_1
X_07745_ _02011_ net348 _01848_ vssd1 vssd1 vccd1 vccd1 _02791_ sky130_fd_sc_hd__and3b_1
X_09415_ _01923_ _02180_ vssd1 vssd1 vccd1 vccd1 _04438_ sky130_fd_sc_hd__nor2_1
X_07676_ _01505_ _01506_ vssd1 vssd1 vccd1 vccd1 _02724_ sky130_fd_sc_hd__nor2_1
X_06627_ cell3.SB0.route_sel\[29\] vssd1 vssd1 vccd1 vccd1 _01697_ sky130_fd_sc_hd__inv_2
XANTENNA__08890__A2 bus3_1\[2\] vssd1 vssd1 vccd1 vccd1 sky130_fd_sc_hd__diode_2
X_09346_ _04354_ _04362_ _04370_ vssd1 vssd1 vccd1 vccd1 _04371_ sky130_fd_sc_hd__a21oi_2
X_06558_ cell2.SB0.route_sel\[77\] vssd1 vssd1 vccd1 vccd1 _01628_ sky130_fd_sc_hd__inv_2
XTAP_TAPCELL_ROW_23_646 vssd1 vccd1 sky130_fd_sc_hd__tapvpwrvgnd_1
XTAP_TAPCELL_ROW_23_657 vssd1 vccd1 sky130_fd_sc_hd__tapvpwrvgnd_1
XFILLER_139_837 vssd1 vssd1 vccd1 vccd1 sky130_fd_sc_hd__fill_2
XFILLER_138_303 vssd1 vssd1 vccd1 vccd1 sky130_fd_sc_hd__fill_1
X_09277_ _04278_ _04301_ _04302_ vssd1 vssd1 vccd1 vccd1 _04303_ sky130_fd_sc_hd__a21o_1
X_06489_ cell0.CB_0.config_dataB\[12\] vssd1 vssd1 vccd1 vccd1 _01559_ sky130_fd_sc_hd__inv_2
X_08228_ net536 net535 vssd1 vssd1 vccd1 vccd1 _03268_ sky130_fd_sc_hd__or2_1
XFILLER_4_305 vssd1 vssd1 vccd1 vccd1 sky130_fd_sc_hd__fill_1
XFILLER_20_194 vssd1 vssd1 vccd1 vccd1 sky130_fd_sc_hd__fill_2
XFILLER_134_531 vssd1 vssd1 vccd1 vccd1 sky130_fd_sc_hd__fill_1
XFILLER_106_222 vssd1 vssd1 vccd1 vccd1 sky130_fd_sc_hd__fill_1
X_08159_ net542 _01956_ vssd1 vssd1 vccd1 vccd1 _03199_ sky130_fd_sc_hd__nand2_1
X_11170_ _05893_ _05890_ net385 vssd1 vssd1 vccd1 vccd1 _06122_ sky130_fd_sc_hd__mux2_1
XANTENNA__10201__A2 _05113_ vssd1 vssd1 vccd1 vccd1 sky130_fd_sc_hd__diode_2
XFILLER_121_225 vssd1 vssd1 vccd1 vccd1 sky130_fd_sc_hd__fill_1
X_10121_ cell2.CB_0.config_dataA\[8\] cell2.CB_0.config_dataA\[7\] vssd1 vssd1 vccd1
+ vccd1 _05122_ sky130_fd_sc_hd__nor2_1
XFILLER_79_117 vssd1 vssd1 vccd1 vccd1 sky130_fd_sc_hd__fill_1
XFILLER_0_522 vssd1 vssd1 vccd1 vccd1 sky130_fd_sc_hd__fill_2
X_10052_ _04399_ _05034_ _05035_ _04445_ vssd1 vssd1 vccd1 vccd1 _05056_ sky130_fd_sc_hd__a2bb2o_1
XFILLER_76_802 vssd1 vssd1 vccd1 vccd1 sky130_fd_sc_hd__fill_1
XFILLER_0_533 vssd1 vssd1 vccd1 vccd1 sky130_fd_sc_hd__fill_2
XFILLER_0_544 vssd1 vssd1 vccd1 vccd1 sky130_fd_sc_hd__fill_4
XANTENNA__11162__A0 _05847_ vssd1 vssd1 vccd1 vccd1 sky130_fd_sc_hd__diode_2
XTAP_TAPCELL_ROW_128_2228 vssd1 vccd1 sky130_fd_sc_hd__tapvpwrvgnd_1
XANTENNA__11701__A2 net548 vssd1 vssd1 vccd1 vccd1 sky130_fd_sc_hd__diode_2
XFILLER_48_504 vssd1 vssd1 vccd1 vccd1 sky130_fd_sc_hd__fill_1
XTAP_TAPCELL_ROW_50_1058 vssd1 vccd1 sky130_fd_sc_hd__tapvpwrvgnd_1
XTAP_TAPCELL_ROW_141_2428 vssd1 vccd1 sky130_fd_sc_hd__tapvpwrvgnd_1
XTAP_TAPCELL_ROW_141_2417 vssd1 vccd1 sky130_fd_sc_hd__tapvpwrvgnd_1
XANTENNA_input19_A CBeast_in[26] vssd1 vssd1 vccd1 vccd1 sky130_fd_sc_hd__diode_2
XTAP_TAPCELL_ROW_3_360 vssd1 vccd1 sky130_fd_sc_hd__tapvpwrvgnd_1
X_13811_ clknet_leaf_112_clk _00783_ net661 vssd1 vssd1 vccd1 vccd1 cell1.SB0.route_sel\[88\]
+ sky130_fd_sc_hd__dfstp_1
XANTENNA__09658__B2 _02447_ vssd1 vssd1 vccd1 vccd1 sky130_fd_sc_hd__diode_2
XANTENNA__12662__A0 net262 vssd1 vssd1 vccd1 vccd1 sky130_fd_sc_hd__diode_2
XANTENNA_input113_X net113 vssd1 vssd1 vccd1 vccd1 sky130_fd_sc_hd__diode_2
X_13742_ clknet_leaf_107_clk _00714_ net659 vssd1 vssd1 vccd1 vccd1 cell1.SB0.route_sel\[19\]
+ sky130_fd_sc_hd__dfstp_1
XFILLER_16_423 vssd1 vssd1 vccd1 vccd1 sky130_fd_sc_hd__fill_1
X_10954_ net40 net41 net42 net43 net379 net378 vssd1 vssd1 vccd1 vccd1 _05908_ sky130_fd_sc_hd__mux4_1
XANTENNA__11092__B net272 vssd1 vssd1 vccd1 vccd1 sky130_fd_sc_hd__diode_2
XANTENNA__08330__A1 _02422_ vssd1 vssd1 vccd1 vccd1 sky130_fd_sc_hd__diode_2
X_13673_ clknet_leaf_35_clk _00645_ net636 vssd1 vssd1 vccd1 vccd1 cell2.CB_0.config_dataB\[0\]
+ sky130_fd_sc_hd__dfstp_1
X_10885_ _05839_ _05840_ _05758_ vssd1 vssd1 vccd1 vccd1 _05841_ sky130_fd_sc_hd__mux2_1
X_12624_ cell3.SB0.route_sel\[89\] cell3.SB0.route_sel\[88\] net920 vssd1 vssd1 vccd1
+ vccd1 _01053_ sky130_fd_sc_hd__mux2_1
XTAP_TAPCELL_ROW_65_1290 vssd1 vccd1 sky130_fd_sc_hd__tapvpwrvgnd_1
XTAP_TAPCELL_ROW_42_944 vssd1 vccd1 sky130_fd_sc_hd__tapvpwrvgnd_1
XTAP_TAPCELL_ROW_42_933 vssd1 vccd1 sky130_fd_sc_hd__tapvpwrvgnd_1
X_12555_ cell3.SB0.route_sel\[20\] cell3.SB0.route_sel\[19\] net917 vssd1 vssd1 vccd1
+ vccd1 _00984_ sky130_fd_sc_hd__mux2_1
XANTENNA__08094__A0 bus2_0\[0\] vssd1 vssd1 vccd1 vccd1 sky130_fd_sc_hd__diode_2
X_11506_ _01612_ cell2.SB0.route_sel\[50\] _01615_ cell2.SB0.route_sel\[53\] _06337_
+ vssd1 vssd1 vccd1 vccd1 _06338_ sky130_fd_sc_hd__a221o_1
XFILLER_12_695 vssd1 vssd1 vccd1 vccd1 sky130_fd_sc_hd__fill_4
XANTENNA__08633__A2 _03666_ vssd1 vssd1 vccd1 vccd1 sky130_fd_sc_hd__diode_2
X_12486_ cell2.LEI0.config_data\[0\] cell2.LE_1A.reset_mode net846 vssd1 vssd1 vccd1
+ vccd1 _00915_ sky130_fd_sc_hd__mux2_1
X_14225_ clknet_leaf_16_clk _01197_ net626 vssd1 vssd1 vccd1 vccd1 cell2.SB0.route_sel\[10\]
+ sky130_fd_sc_hd__dfstp_1
X_11437_ cell0.SB0.route_sel\[120\] cell0.SB0.route_sel\[121\] cell0.SB0.route_sel\[123\]
+ _01489_ _06291_ vssd1 vssd1 vccd1 vccd1 _06292_ sky130_fd_sc_hd__o221a_1
XFILLER_8_699 vssd1 vssd1 vccd1 vccd1 sky130_fd_sc_hd__fill_1
XANTENNA__13068__SET_B net584 vssd1 vssd1 vccd1 vccd1 sky130_fd_sc_hd__diode_2
X_14156_ clknet_leaf_72_clk _01128_ net728 vssd1 vssd1 vccd1 vccd1 cell3.CB_1.config_dataA\[16\]
+ sky130_fd_sc_hd__dfstp_1
X_11368_ _01603_ cell0.SB0.route_sel\[34\] cell0.SB0.route_sel\[33\] _01814_ _06245_
+ vssd1 vssd1 vccd1 vccd1 _06246_ sky130_fd_sc_hd__o221a_1
X_10319_ _05156_ _05312_ _05313_ _05152_ cell2.CB_0.config_dataB\[2\] vssd1 vssd1
+ vccd1 vccd1 _05318_ sky130_fd_sc_hd__a221o_1
X_13107_ clknet_leaf_5_clk _00079_ net566 vssd1 vssd1 vccd1 vccd1 cell0.CB_0.config_dataA\[9\]
+ sky130_fd_sc_hd__dfstp_1
XANTENNA__09346__B1 _04370_ vssd1 vssd1 vccd1 vccd1 sky130_fd_sc_hd__diode_2
X_14087_ clknet_leaf_78_clk _01059_ net710 vssd1 vssd1 vccd1 vccd1 cell3.SB0.route_sel\[95\]
+ sky130_fd_sc_hd__dfstp_1
X_11299_ net287 _05505_ _04359_ vssd1 vssd1 vccd1 vccd1 _06214_ sky130_fd_sc_hd__mux2_1
XFILLER_79_640 vssd1 vssd1 vccd1 vccd1 sky130_fd_sc_hd__fill_1
XFILLER_3_393 vccd1 vssd1 vccd1 vssd1 sky130_ef_sc_hd__decap_40_12
XANTENNA__10171__B _05148_ vssd1 vssd1 vccd1 vccd1 sky130_fd_sc_hd__diode_2
XFILLER_85_109 vssd1 vssd1 vccd1 vccd1 sky130_fd_sc_hd__fill_2
X_13038_ clknet_leaf_120_clk _00010_ net593 vssd1 vssd1 vccd1 vccd1 cell0.LE_1B.config_data\[10\]
+ sky130_fd_sc_hd__dfrtp_1
XFILLER_94_643 vssd1 vssd1 vccd1 vccd1 sky130_fd_sc_hd__fill_1
XFILLER_78_183 vssd1 vssd1 vccd1 vccd1 sky130_fd_sc_hd__fill_1
XTAP_TAPCELL_ROW_1_319 vssd1 vccd1 sky130_fd_sc_hd__tapvpwrvgnd_1
XANTENNA__07761__A _02804_ vssd1 vssd1 vccd1 vccd1 sky130_fd_sc_hd__diode_2
X_07530_ _02579_ _02581_ vssd1 vssd1 vccd1 vccd1 bus1_0\[15\] sky130_fd_sc_hd__and2_2
XTAP_TAPCELL_ROW_81_1519 vssd1 vccd1 sky130_fd_sc_hd__tapvpwrvgnd_1
X_07461_ cell1.SB0.route_sel\[113\] cell1.SB0.route_sel\[112\] _02507_ _02514_ net881
+ vssd1 vssd1 vccd1 vccd1 _02515_ sky130_fd_sc_hd__a311o_2
XFILLER_34_275 vssd1 vssd1 vccd1 vccd1 sky130_fd_sc_hd__fill_1
X_07392_ _02162_ _02376_ vssd1 vssd1 vccd1 vccd1 _02447_ sky130_fd_sc_hd__nor2_2
X_09200_ _04225_ _04227_ vssd1 vssd1 vccd1 vccd1 bus3_1\[0\] sky130_fd_sc_hd__and2_2
X_06412_ cell0.SB0.route_sel\[112\] vssd1 vssd1 vccd1 vccd1 _01482_ sky130_fd_sc_hd__inv_2
X_09131_ cell1.LEI0.config_data\[41\] _04159_ _04160_ _04157_ vssd1 vssd1 vccd1 vccd1
+ _04161_ sky130_fd_sc_hd__o211a_1
XTAP_TAPCELL_ROW_20_605 vssd1 vccd1 sky130_fd_sc_hd__tapvpwrvgnd_1
X_09062_ _03853_ _04090_ _04091_ _03849_ cell1.CB_0.config_dataB\[12\] vssd1 vssd1
+ vccd1 vccd1 _04092_ sky130_fd_sc_hd__a221o_1
XANTENNA__12318__S net863 vssd1 vssd1 vccd1 vccd1 sky130_fd_sc_hd__diode_2
XFILLER_30_470 vssd1 vssd1 vccd1 vccd1 sky130_fd_sc_hd__fill_2
XFILLER_136_829 vssd1 vssd1 vccd1 vccd1 sky130_fd_sc_hd__fill_1
XFILLER_8_81 vssd1 vssd1 vccd1 vccd1 sky130_fd_sc_hd__fill_2
XFILLER_118_27 vssd1 vssd1 vccd1 vccd1 sky130_fd_sc_hd__fill_1
XFILLER_116_531 vssd1 vssd1 vccd1 vccd1 sky130_fd_sc_hd__fill_1
XTAP_TAPCELL_ROW_96_1751 vssd1 vccd1 sky130_fd_sc_hd__tapvpwrvgnd_1
X_08013_ net342 net346 net350 net338 cell0.LEI0.config_data\[15\] cell0.LEI0.config_data\[16\]
+ vssd1 vssd1 vccd1 vccd1 _03055_ sky130_fd_sc_hd__mux4_1
XANTENNA__08927__A3 bus3_1\[15\] vssd1 vssd1 vccd1 vccd1 sky130_fd_sc_hd__diode_2
XFILLER_2_809 vssd1 vssd1 vccd1 vccd1 sky130_fd_sc_hd__fill_2
XANTENNA__08388__A1 bus1_0\[13\] vssd1 vssd1 vccd1 vccd1 sky130_fd_sc_hd__diode_2
Xmax_cap341 _02208_ vssd1 vssd1 vccd1 vccd1 net341 sky130_fd_sc_hd__clkbuf_2
X_09964_ net407 net405 _04399_ cell2.CB_1.config_dataB\[7\] vssd1 vssd1 vccd1 vccd1
+ _04968_ sky130_fd_sc_hd__o31ai_1
X_09895_ net437 net438 _04399_ _04900_ cell2.CB_1.config_dataA\[17\] vssd1 vssd1 vccd1
+ vccd1 _04901_ sky130_fd_sc_hd__o311a_1
XANTENNA__09888__A1 bus3_2\[7\] vssd1 vssd1 vccd1 vccd1 sky130_fd_sc_hd__diode_2
XANTENNA_fanout575_A net602 vssd1 vssd1 vccd1 vccd1 sky130_fd_sc_hd__diode_2
X_08915_ bus3_1\[5\] _03940_ _03941_ bus3_1\[4\] cell1.CB_0.config_dataA\[13\] vssd1
+ vssd1 vccd1 vccd1 _03947_ sky130_fd_sc_hd__a221o_1
X_08846_ _03877_ vssd1 vssd1 vccd1 vccd1 _03878_ sky130_fd_sc_hd__inv_2
Xclkbuf_1_0__f_cell2.LE_0A.sel_clk clknet_0_cell2.LE_0A.sel_clk vssd1 vssd1 vccd1
+ vccd1 clknet_1_0__leaf_cell2.LE_0A.sel_clk sky130_fd_sc_hd__clkbuf_16
XANTENNA_fanout742_A net749 vssd1 vssd1 vccd1 vccd1 sky130_fd_sc_hd__diode_2
XTAP_TAPCELL_ROW_123_2147 vssd1 vccd1 sky130_fd_sc_hd__tapvpwrvgnd_1
X_08777_ _03807_ _03810_ _03767_ vssd1 vssd1 vccd1 vccd1 _03811_ sky130_fd_sc_hd__mux2_1
XFILLER_27_57 vccd1 vssd1 vccd1 vssd1 sky130_ef_sc_hd__decap_40_12
XTAP_TAPCELL_ROW_28_727 vssd1 vccd1 sky130_fd_sc_hd__tapvpwrvgnd_1
XTAP_TAPCELL_ROW_123_2158 vssd1 vccd1 sky130_fd_sc_hd__tapvpwrvgnd_1
X_07728_ _01972_ _02649_ vssd1 vssd1 vccd1 vccd1 _02775_ sky130_fd_sc_hd__nand2_1
XANTENNA__08863__A2 _03890_ vssd1 vssd1 vccd1 vccd1 sky130_fd_sc_hd__diode_2
X_07659_ _01592_ _01593_ net119 cell0.SB0.route_sel\[21\] cell0.SB0.route_sel\[20\]
+ vssd1 vssd1 vccd1 vccd1 _02707_ sky130_fd_sc_hd__o2111a_1
XTAP_TAPCELL_ROW_105_1880 vssd1 vccd1 sky130_fd_sc_hd__tapvpwrvgnd_1
X_10670_ _05510_ _05602_ _05626_ _05627_ cell3.CB_1.config_dataA\[12\] vssd1 vssd1
+ vccd1 vccd1 _05628_ sky130_fd_sc_hd__a2111oi_1
XANTENNA__06874__A1 _01937_ vssd1 vssd1 vccd1 vccd1 sky130_fd_sc_hd__diode_2
X_09329_ _04326_ _04352_ _04353_ vssd1 vssd1 vccd1 vccd1 _04354_ sky130_fd_sc_hd__a21o_2
XANTENNA__12228__S net824 vssd1 vssd1 vccd1 vccd1 sky130_fd_sc_hd__diode_2
XANTENNA__09110__B _03881_ vssd1 vssd1 vccd1 vccd1 sky130_fd_sc_hd__diode_2
X_12340_ cell1.SB0.route_sel\[78\] cell1.SB0.route_sel\[77\] net861 vssd1 vssd1 vccd1
+ vccd1 _00773_ sky130_fd_sc_hd__mux2_1
X_12271_ cell1.SB0.route_sel\[9\] cell1.SB0.route_sel\[8\] net866 vssd1 vssd1 vccd1
+ vccd1 _00704_ sky130_fd_sc_hd__mux2_1
X_11222_ _06148_ _06171_ _06173_ cell3.LEI0.config_data\[41\] vssd1 vssd1 vccd1 vccd1
+ _06174_ sky130_fd_sc_hd__o22a_1
X_14010_ clknet_leaf_79_clk _00982_ net708 vssd1 vssd1 vccd1 vccd1 cell3.SB0.route_sel\[18\]
+ sky130_fd_sc_hd__dfstp_1
XFILLER_5_669 vssd1 vssd1 vccd1 vccd1 sky130_fd_sc_hd__fill_2
XANTENNA__06750__A net756 vssd1 vssd1 vccd1 vccd1 sky130_fd_sc_hd__diode_2
XANTENNA__09040__A2 bus3_1\[10\] vssd1 vssd1 vccd1 vccd1 sky130_fd_sc_hd__diode_2
XTAP_TAPCELL_ROW_8_430 vssd1 vccd1 sky130_fd_sc_hd__tapvpwrvgnd_1
X_11153_ net285 net279 net297 net290 cell3.LEI0.config_data\[15\] cell3.LEI0.config_data\[16\]
+ vssd1 vssd1 vccd1 vccd1 _06105_ sky130_fd_sc_hd__mux4_1
XFILLER_1_831 vssd1 vssd1 vccd1 vccd1 sky130_fd_sc_hd__fill_4
X_11084_ cell3.LE_0A.config_data\[4\] cell3.LE_0A.config_data\[5\] _05930_ vssd1 vssd1
+ vccd1 vccd1 _06038_ sky130_fd_sc_hd__mux2_1
XANTENNA__11135__A0 _05874_ vssd1 vssd1 vccd1 vccd1 sky130_fd_sc_hd__diode_2
XFILLER_122_589 vssd1 vssd1 vccd1 vccd1 sky130_fd_sc_hd__fill_1
X_10104_ cell2.SB0.route_sel\[115\] cell2.SB0.route_sel\[114\] vssd1 vssd1 vccd1 vccd1
+ _05105_ sky130_fd_sc_hd__nor2_1
XFILLER_88_470 vssd1 vssd1 vccd1 vccd1 sky130_fd_sc_hd__fill_1
X_10035_ _04527_ _05034_ _05035_ _04555_ vssd1 vssd1 vccd1 vccd1 _05039_ sky130_fd_sc_hd__a2bb2o_1
XANTENNA__07852__Y _02896_ vssd1 vssd1 vccd1 vccd1 sky130_fd_sc_hd__diode_2
XFILLER_84_41 vccd1 vssd1 vccd1 vssd1 sky130_ef_sc_hd__decap_40_12
XFILLER_48_367 vssd1 vssd1 vccd1 vccd1 sky130_fd_sc_hd__fill_1
XFILLER_84_74 vssd1 vssd1 vccd1 vccd1 sky130_fd_sc_hd__fill_1
XFILLER_29_570 vssd1 vssd1 vccd1 vccd1 sky130_fd_sc_hd__fill_1
XANTENNA__12635__A0 cell3.SB0.route_sel\[100\] vssd1 vssd1 vccd1 vccd1 sky130_fd_sc_hd__diode_2
XFILLER_84_85 vssd1 vssd1 vccd1 vccd1 sky130_fd_sc_hd__fill_8
X_11986_ cell0.SB0.route_sel\[92\] cell0.SB0.route_sel\[91\] net787 vssd1 vssd1 vccd1
+ vccd1 _00423_ sky130_fd_sc_hd__mux2_1
X_10937_ cell3.SB0.route_sel\[52\] _01712_ vssd1 vssd1 vccd1 vccd1 _05891_ sky130_fd_sc_hd__nand2_1
XANTENNA__08854__A2 _03885_ vssd1 vssd1 vccd1 vccd1 sky130_fd_sc_hd__diode_2
X_13725_ clknet_leaf_102_clk _00697_ net676 vssd1 vssd1 vccd1 vccd1 cell1.SB0.route_sel\[2\]
+ sky130_fd_sc_hd__dfstp_1
X_13656_ clknet_leaf_49_clk _00628_ net714 vssd1 vssd1 vccd1 vccd1 cell2.CB_1.config_dataA\[8\]
+ sky130_fd_sc_hd__dfstp_1
XTAP_TAPCELL_ROW_63_1249 vssd1 vccd1 sky130_fd_sc_hd__tapvpwrvgnd_1
XFILLER_16_297 vssd1 vssd1 vccd1 vccd1 sky130_fd_sc_hd__fill_8
XANTENNA__11390__X net259 vssd1 vssd1 vccd1 vccd1 sky130_fd_sc_hd__diode_2
XFILLER_31_212 vssd1 vssd1 vccd1 vccd1 sky130_fd_sc_hd__fill_1
X_10868_ cell3.CB_1.config_dataB\[18\] _05801_ _05809_ _05823_ vssd1 vssd1 vccd1 vccd1
+ _05824_ sky130_fd_sc_hd__a31o_1
X_12607_ cell3.SB0.route_sel\[72\] cell3.SB0.route_sel\[71\] net909 vssd1 vssd1 vccd1
+ vccd1 _01036_ sky130_fd_sc_hd__mux2_1
X_10799_ net298 net291 cell3.LEI0.config_data\[21\] vssd1 vssd1 vccd1 vccd1 _05755_
+ sky130_fd_sc_hd__mux2_1
XANTENNA__10949__B1 _05901_ vssd1 vssd1 vccd1 vccd1 sky130_fd_sc_hd__diode_2
XANTENNA__09803__A1 bus3_2\[2\] vssd1 vssd1 vccd1 vccd1 sky130_fd_sc_hd__diode_2
X_13587_ clknet_leaf_94_clk _00559_ net692 vssd1 vssd1 vccd1 vccd1 cell1.LEI0.config_data\[8\]
+ sky130_fd_sc_hd__dfrtp_1
XFILLER_31_289 vssd1 vssd1 vccd1 vccd1 sky130_fd_sc_hd__fill_1
XANTENNA__10413__A2 net318 vssd1 vssd1 vccd1 vccd1 sky130_fd_sc_hd__diode_2
X_12538_ cell3.SB0.route_sel\[3\] cell3.SB0.route_sel\[2\] net935 vssd1 vssd1 vccd1
+ vccd1 _00967_ sky130_fd_sc_hd__mux2_1
XFILLER_12_492 vssd1 vssd1 vccd1 vccd1 sky130_fd_sc_hd__fill_8
X_12469_ cell2.LE_0A.config_data\[6\] net1043 net813 vssd1 vssd1 vccd1 vccd1 _00899_
+ sky130_fd_sc_hd__mux2_1
X_14208_ clknet_leaf_56_clk _01180_ net719 vssd1 vssd1 vccd1 vccd1 cell3.CB_0.config_dataA\[18\]
+ sky130_fd_sc_hd__dfstp_1
XTAP_TAPCELL_ROW_78_1481 vssd1 vccd1 sky130_fd_sc_hd__tapvpwrvgnd_1
XANTENNA__12166__A2 net548 vssd1 vssd1 vccd1 vccd1 sky130_fd_sc_hd__diode_2
XFILLER_141_821 vccd1 vssd1 vccd1 vssd1 sky130_ef_sc_hd__decap_40_12
X_14139_ clknet_leaf_63_clk _01111_ net748 vssd1 vssd1 vccd1 vccd1 cell3.LE_1B.reset_mode
+ sky130_fd_sc_hd__dfrtp_1
Xfanout409 cell2.CB_1.config_dataB\[0\] vssd1 vssd1 vccd1 vccd1 net409 sky130_fd_sc_hd__buf_2
XTAP_TAPCELL_ROW_91_1670 vssd1 vccd1 sky130_fd_sc_hd__tapvpwrvgnd_1
X_06961_ cell0.CB_0.config_dataA\[22\] cell0.CB_0.config_dataA\[23\] vssd1 vssd1 vccd1
+ vccd1 _02027_ sky130_fd_sc_hd__nand2b_2
X_09680_ cell2.SB0.route_sel\[112\] _01644_ cell2.SB0.route_sel\[117\] cell2.SB0.route_sel\[116\]
+ vssd1 vssd1 vccd1 vccd1 _04694_ sky130_fd_sc_hd__o22a_1
X_08700_ cell1.CB_1.config_dataB\[4\] _03703_ _03722_ vssd1 vssd1 vccd1 vccd1 _03734_
+ sky130_fd_sc_hd__nand3_1
XFILLER_104_29 vssd1 vssd1 vccd1 vccd1 sky130_fd_sc_hd__fill_4
X_08631_ cell1.LE_1A.dff0_out cell1.LE_1A.dff1_out cell1.LE_1A.reset_val vssd1 vssd1
+ vccd1 vccd1 cell1.LE_1A.dff_out sky130_fd_sc_hd__mux2_1
X_06892_ _01934_ _01957_ _01959_ vssd1 vssd1 vccd1 vccd1 _01960_ sky130_fd_sc_hd__o21ai_1
XFILLER_67_698 vssd1 vssd1 vccd1 vccd1 sky130_fd_sc_hd__fill_1
XANTENNA__07896__A3 bus2_0\[15\] vssd1 vssd1 vccd1 vccd1 sky130_fd_sc_hd__diode_2
XFILLER_82_679 vssd1 vssd1 vccd1 vccd1 sky130_fd_sc_hd__fill_4
XFILLER_70_819 vssd1 vssd1 vccd1 vccd1 sky130_fd_sc_hd__fill_1
X_08562_ net491 _03504_ _03597_ net490 vssd1 vssd1 vccd1 vccd1 _03598_ sky130_fd_sc_hd__o211a_1
X_07513_ _01551_ _01552_ vssd1 vssd1 vccd1 vccd1 _02565_ sky130_fd_sc_hd__nor2_1
X_08493_ _03527_ _03528_ _01979_ vssd1 vssd1 vccd1 vccd1 _03529_ sky130_fd_sc_hd__a21boi_4
XANTENNA__08845__A2 bus3_1\[2\] vssd1 vssd1 vccd1 vccd1 sky130_fd_sc_hd__diode_2
X_07444_ cell1.SB0.route_sel\[119\] cell1.SB0.route_sel\[118\] net349 _02473_ _02497_
+ vssd1 vssd1 vccd1 vccd1 _02498_ sky130_fd_sc_hd__a221oi_1
XFILLER_13_15 vccd1 vssd1 vccd1 vssd1 sky130_ef_sc_hd__decap_40_12
XFILLER_129_15 vccd1 vssd1 vccd1 vssd1 sky130_ef_sc_hd__decap_40_12
XFILLER_50_587 vssd1 vssd1 vccd1 vccd1 sky130_fd_sc_hd__fill_1
XANTENNA_fanout323_A cell1.CB_1.le_outB vssd1 vssd1 vccd1 vccd1 sky130_fd_sc_hd__diode_2
X_07375_ cell1.SB0.route_sel\[109\] cell1.SB0.route_sel\[108\] net86 vssd1 vssd1 vccd1
+ vccd1 _02431_ sky130_fd_sc_hd__a21bo_1
XTAP_TAPCELL_ROW_33_796 vssd1 vccd1 sky130_fd_sc_hd__tapvpwrvgnd_1
X_09114_ cell1.CB_0.config_dataB\[17\] _04135_ _04139_ _04143_ vssd1 vssd1 vccd1 vccd1
+ _04144_ sky130_fd_sc_hd__o211a_1
X_09045_ net485 _03844_ vssd1 vssd1 vccd1 vccd1 _04075_ sky130_fd_sc_hd__nand2_1
XANTENNA__11459__Y net212 vssd1 vssd1 vccd1 vccd1 sky130_fd_sc_hd__diode_2
Xhold452 _01342_ vssd1 vssd1 vccd1 vccd1 net1411 sky130_fd_sc_hd__dlygate4sd3_1
Xhold430 cell3.LEI0.config_data\[19\] vssd1 vssd1 vccd1 vccd1 net1389 sky130_fd_sc_hd__dlygate4sd3_1
Xhold463 _00962_ vssd1 vssd1 vccd1 vccd1 net1422 sky130_fd_sc_hd__dlygate4sd3_1
Xhold441 cell1.LEI0.config_data\[24\] vssd1 vssd1 vccd1 vccd1 net1400 sky130_fd_sc_hd__dlygate4sd3_1
XFILLER_1_105 vssd1 vssd1 vccd1 vccd1 sky130_fd_sc_hd__fill_4
Xhold474 cell3.LEI0.config_data\[13\] vssd1 vssd1 vccd1 vccd1 net1433 sky130_fd_sc_hd__dlygate4sd3_1
XFILLER_89_223 vssd1 vssd1 vccd1 vccd1 sky130_fd_sc_hd__fill_1
Xhold496 cell0.LEI0.config_data\[36\] vssd1 vssd1 vccd1 vccd1 net1455 sky130_fd_sc_hd__dlygate4sd3_1
Xhold485 cell1.LEI0.config_data\[43\] vssd1 vssd1 vccd1 vccd1 net1444 sky130_fd_sc_hd__dlygate4sd3_1
XFILLER_1_149 vccd1 vssd1 vccd1 vssd1 sky130_ef_sc_hd__decap_40_12
Xfanout932 net933 vssd1 vssd1 vccd1 vccd1 net932 sky130_fd_sc_hd__clkbuf_4
XANTENNA__11117__B1 _04370_ vssd1 vssd1 vccd1 vccd1 sky130_fd_sc_hd__diode_2
Xfanout943 net944 vssd1 vssd1 vccd1 vccd1 net943 sky130_fd_sc_hd__buf_2
Xfanout921 net923 vssd1 vssd1 vccd1 vccd1 net921 sky130_fd_sc_hd__clkbuf_4
X_09947_ cell2.CB_1.config_dataB\[2\] _04949_ _04950_ _04942_ _04947_ vssd1 vssd1
+ vccd1 vccd1 _04951_ sky130_fd_sc_hd__o311a_1
Xfanout910 net912 vssd1 vssd1 vccd1 vccd1 net910 sky130_fd_sc_hd__clkbuf_4
XANTENNA__07584__A2 _02630_ vssd1 vssd1 vccd1 vccd1 sky130_fd_sc_hd__diode_2
Xfanout954 net956 vssd1 vssd1 vccd1 vccd1 net954 sky130_fd_sc_hd__clkbuf_4
XANTENNA__07672__Y _02720_ vssd1 vssd1 vccd1 vccd1 sky130_fd_sc_hd__diode_2
XANTENNA__11132__A3 net52 vssd1 vssd1 vccd1 vccd1 sky130_fd_sc_hd__diode_2
X_09878_ net438 _04696_ _04883_ net437 vssd1 vssd1 vccd1 vccd1 _04884_ sky130_fd_sc_hd__o211a_1
XANTENNA__08533__A1 net32 vssd1 vssd1 vccd1 vccd1 sky130_fd_sc_hd__diode_2
XTAP_TAPCELL_ROW_107_1920 vssd1 vccd1 sky130_fd_sc_hd__tapvpwrvgnd_1
XANTENNA__07887__A3 bus2_0\[3\] vssd1 vssd1 vccd1 vccd1 sky130_fd_sc_hd__diode_2
X_08829_ _03860_ vssd1 vssd1 vccd1 vccd1 _03861_ sky130_fd_sc_hd__inv_2
XFILLER_18_529 vssd1 vssd1 vccd1 vccd1 sky130_fd_sc_hd__fill_2
XFILLER_57_197 vssd1 vssd1 vccd1 vccd1 sky130_fd_sc_hd__fill_1
X_11840_ cell1.CB_1.config_dataA\[21\] cell1.CB_1.config_dataA\[20\] net885 vssd1
+ vssd1 vccd1 vccd1 _00277_ sky130_fd_sc_hd__mux2_1
XFILLER_72_167 vssd1 vssd1 vccd1 vccd1 sky130_fd_sc_hd__fill_1
X_11771_ cell0.LEI0.config_data\[21\] net990 net792 vssd1 vssd1 vccd1 vccd1 _00208_
+ sky130_fd_sc_hd__mux2_1
X_10722_ cell3.LE_1A.config_data\[13\] _05600_ _05679_ _05562_ vssd1 vssd1 vccd1 vccd1
+ _05680_ sky130_fd_sc_hd__a211o_1
XFILLER_13_212 vssd1 vssd1 vccd1 vccd1 sky130_fd_sc_hd__fill_1
X_13510_ clknet_leaf_102_clk _00482_ net676 vssd1 vssd1 vccd1 vccd1 cell1.CB_1.config_dataB\[23\]
+ sky130_fd_sc_hd__dfstp_1
X_10653_ net17 net18 net19 net20 net393 cell3.CB_1.config_dataA\[11\] vssd1 vssd1
+ vccd1 vccd1 _05611_ sky130_fd_sc_hd__mux4_1
X_13441_ clknet_leaf_130_clk _00413_ net578 vssd1 vssd1 vccd1 vccd1 cell0.SB0.route_sel\[82\]
+ sky130_fd_sc_hd__dfstp_1
XTAP_TAPCELL_ROW_136_2349 vssd1 vccd1 sky130_fd_sc_hd__tapvpwrvgnd_1
XANTENNA__11199__A3 _05890_ vssd1 vssd1 vccd1 vccd1 sky130_fd_sc_hd__diode_2
XFILLER_127_615 vssd1 vssd1 vccd1 vccd1 sky130_fd_sc_hd__fill_1
X_10584_ cell3.SB0.route_sel\[88\] _01732_ cell3.SB0.route_sel\[92\] cell3.SB0.route_sel\[93\]
+ _05541_ vssd1 vssd1 vccd1 vccd1 _05542_ sky130_fd_sc_hd__o221a_1
X_13372_ clknet_leaf_127_clk _00344_ net576 vssd1 vssd1 vccd1 vccd1 cell0.SB0.route_sel\[13\]
+ sky130_fd_sc_hd__dfstp_1
XANTENNA_input86_A SBsouth_in[29] vssd1 vssd1 vccd1 vccd1 sky130_fd_sc_hd__diode_2
Xclkload19 clknet_leaf_132_clk vssd1 vssd1 vccd1 vccd1 clkload19/Y sky130_fd_sc_hd__clkinv_4
X_12323_ cell1.SB0.route_sel\[61\] cell1.SB0.route_sel\[60\] net856 vssd1 vssd1 vccd1
+ vccd1 _00756_ sky130_fd_sc_hd__mux2_1
XTAP_TAPCELL_ROW_11_468 vssd1 vccd1 sky130_fd_sc_hd__tapvpwrvgnd_1
XTAP_TAPCELL_ROW_11_479 vssd1 vccd1 sky130_fd_sc_hd__tapvpwrvgnd_1
XANTENNA__07272__A1 _02327_ vssd1 vssd1 vccd1 vccd1 sky130_fd_sc_hd__diode_2
XANTENNA__07576__A cell0.CB_0.le_outB vssd1 vssd1 vccd1 vccd1 sky130_fd_sc_hd__diode_2
XANTENNA__06751__Y _01821_ vssd1 vssd1 vccd1 vccd1 sky130_fd_sc_hd__diode_2
X_12254_ cell2.CB_0.config_dataA\[17\] net411 net823 vssd1 vssd1 vccd1 vccd1 _00687_
+ sky130_fd_sc_hd__mux2_1
X_12185_ net1503 cell2.LE_1B.edge_mode net851 vssd1 vssd1 vccd1 vccd1 _00618_ sky130_fd_sc_hd__mux2_1
X_11205_ net40 _06145_ _06147_ net41 cell3.CB_0.config_dataB\[17\] vssd1 vssd1 vccd1
+ vccd1 _06157_ sky130_fd_sc_hd__a221o_1
XANTENNA__08221__A0 net342 vssd1 vssd1 vccd1 vccd1 sky130_fd_sc_hd__diode_2
XANTENNA_input41_X net41 vssd1 vssd1 vccd1 vccd1 sky130_fd_sc_hd__diode_2
X_11136_ _05879_ _06079_ _06080_ _05884_ vssd1 vssd1 vccd1 vccd1 _06088_ sky130_fd_sc_hd__a2bb2o_1
XFILLER_122_386 vssd1 vssd1 vccd1 vccd1 sky130_fd_sc_hd__fill_1
XANTENNA_output242_A net242 vssd1 vssd1 vccd1 vccd1 sky130_fd_sc_hd__diode_2
X_11067_ _05921_ _05999_ _06019_ net372 cell3.CB_0.config_dataA\[17\] vssd1 vssd1
+ vccd1 vccd1 _06021_ sky130_fd_sc_hd__a221o_1
XFILLER_95_51 vssd1 vssd1 vccd1 vccd1 sky130_fd_sc_hd__fill_4
XFILLER_0_182 vssd1 vssd1 vccd1 vccd1 sky130_fd_sc_hd__fill_8
X_10018_ _04445_ _04996_ _05020_ _05021_ vssd1 vssd1 vccd1 vccd1 _05022_ sky130_fd_sc_hd__a211o_1
XFILLER_63_178 vssd1 vssd1 vccd1 vccd1 sky130_fd_sc_hd__fill_1
X_13708_ clknet_leaf_28_clk _00680_ net617 vssd1 vssd1 vccd1 vccd1 cell2.CB_0.config_dataA\[10\]
+ sky130_fd_sc_hd__dfstp_1
X_11969_ cell0.SB0.route_sel\[75\] cell0.SB0.route_sel\[74\] net766 vssd1 vssd1 vccd1
+ vccd1 _00406_ sky130_fd_sc_hd__mux2_1
XANTENNA__10634__A2 _05501_ vssd1 vssd1 vccd1 vccd1 sky130_fd_sc_hd__diode_2
X_13639_ clknet_leaf_38_clk _00611_ net648 vssd1 vssd1 vccd1 vccd1 cell2.LE_1B.config_data\[11\]
+ sky130_fd_sc_hd__dfrtp_1
XFILLER_81_3 vssd1 vssd1 vccd1 vccd1 sky130_fd_sc_hd__fill_1
XANTENNA__13690__SET_B net622 vssd1 vssd1 vccd1 vccd1 sky130_fd_sc_hd__diode_2
XTAP_TAPCELL_ROW_30_755 vssd1 vccd1 sky130_fd_sc_hd__tapvpwrvgnd_1
X_07160_ _02216_ _02220_ _02221_ _02217_ _02215_ vssd1 vssd1 vccd1 vccd1 _02222_ sky130_fd_sc_hd__a32o_1
X_07091_ bus3_1\[9\] _02154_ vssd1 vssd1 vccd1 vccd1 _02155_ sky130_fd_sc_hd__and2_1
XFILLER_9_783 vssd1 vssd1 vccd1 vccd1 sky130_fd_sc_hd__fill_1
XTAP_TAPCELL_ROW_93_1710 vssd1 vccd1 sky130_fd_sc_hd__tapvpwrvgnd_1
XFILLER_117_169 vssd1 vssd1 vccd1 vccd1 sky130_fd_sc_hd__fill_1
X_09801_ _04806_ vssd1 vssd1 vccd1 vccd1 _04807_ sky130_fd_sc_hd__inv_2
XFILLER_99_587 vssd1 vssd1 vccd1 vccd1 sky130_fd_sc_hd__fill_1
XFILLER_87_705 vccd1 vssd1 vccd1 vssd1 sky130_ef_sc_hd__decap_40_12
XFILLER_5_93 vccd1 vssd1 vccd1 vssd1 sky130_ef_sc_hd__decap_40_12
XFILLER_115_39 vccd1 vssd1 vccd1 vssd1 sky130_ef_sc_hd__decap_40_12
XFILLER_86_248 vssd1 vssd1 vccd1 vccd1 sky130_fd_sc_hd__fill_2
X_09732_ _01564_ cell2.SB0.route_sel\[1\] cell2.SB0.route_sel\[7\] cell2.SB0.route_sel\[6\]
+ _04743_ vssd1 vssd1 vccd1 vccd1 _04744_ sky130_fd_sc_hd__o221a_1
X_07993_ _03028_ _03031_ _03033_ _03034_ vssd1 vssd1 vccd1 vccd1 _03035_ sky130_fd_sc_hd__o22a_1
XANTENNA_clkload10_A clknet_4_10_0_clk vssd1 vssd1 vccd1 vccd1 sky130_fd_sc_hd__diode_2
XFILLER_101_559 vssd1 vssd1 vccd1 vccd1 sky130_fd_sc_hd__fill_1
X_06944_ _02010_ _02008_ vssd1 vssd1 vccd1 vccd1 bus2_0\[7\] sky130_fd_sc_hd__and2b_2
XANTENNA__08515__A1 _03517_ vssd1 vssd1 vccd1 vccd1 sky130_fd_sc_hd__diode_2
XANTENNA__10322__A1 net62 vssd1 vssd1 vccd1 vccd1 sky130_fd_sc_hd__diode_2
X_09663_ _04230_ _04649_ vssd1 vssd1 vccd1 vccd1 _04678_ sky130_fd_sc_hd__or2_1
X_06875_ cell0.CB_0.config_dataA\[24\] cell0.CB_0.config_dataA\[20\] cell0.CB_0.config_dataA\[21\]
+ vssd1 vssd1 vccd1 vccd1 _01943_ sky130_fd_sc_hd__nand3b_2
XANTENNA__08515__B2 _03514_ vssd1 vssd1 vccd1 vccd1 sky130_fd_sc_hd__diode_2
XFILLER_131_27 vccd1 vssd1 vccd1 vssd1 sky130_ef_sc_hd__decap_40_12
X_09594_ net318 _02311_ _04610_ cell3.SB0.route_sel\[93\] cell3.SB0.route_sel\[92\]
+ vssd1 vssd1 vccd1 vccd1 _04611_ sky130_fd_sc_hd__o2111a_1
XFILLER_82_421 vssd1 vssd1 vccd1 vccd1 sky130_fd_sc_hd__fill_8
XFILLER_54_134 vssd1 vssd1 vccd1 vccd1 sky130_fd_sc_hd__fill_1
X_08614_ net331 net326 net336 net323 cell1.LEI0.config_data\[42\] cell1.LEI0.config_data\[43\]
+ vssd1 vssd1 vccd1 vccd1 _03650_ sky130_fd_sc_hd__mux4_1
XTAP_TAPCELL_ROW_120_2106 vssd1 vccd1 sky130_fd_sc_hd__tapvpwrvgnd_1
XFILLER_70_627 vssd1 vssd1 vccd1 vccd1 sky130_fd_sc_hd__fill_1
X_08545_ cell1.LEI0.config_data\[20\] _03578_ _03580_ vssd1 vssd1 vccd1 vccd1 _03581_
+ sky130_fd_sc_hd__or3_2
XTAP_TAPCELL_ROW_38_877 vssd1 vccd1 sky130_fd_sc_hd__tapvpwrvgnd_1
XFILLER_51_841 vssd1 vssd1 vccd1 vccd1 sky130_fd_sc_hd__fill_1
Xclkbuf_leaf_128_clk clknet_4_2_0_clk vssd1 vssd1 vccd1 vccd1 clknet_leaf_128_clk
+ sky130_fd_sc_hd__clkbuf_8
XANTENNA__08109__X _03151_ vssd1 vssd1 vccd1 vccd1 sky130_fd_sc_hd__diode_2
X_08476_ cell1.SB0.route_sel\[13\] cell1.SB0.route_sel\[12\] vssd1 vssd1 vccd1 vccd1
+ _03512_ sky130_fd_sc_hd__nor2_1
X_07427_ _01484_ _01485_ net102 cell0.SB0.route_sel\[116\] cell0.SB0.route_sel\[117\]
+ vssd1 vssd1 vccd1 vccd1 _02481_ sky130_fd_sc_hd__o2111a_1
X_07358_ _02412_ _02413_ _02409_ _02410_ vssd1 vssd1 vccd1 vccd1 _02414_ sky130_fd_sc_hd__a2bb2o_1
XFILLER_7_709 vccd1 vssd1 vccd1 vssd1 sky130_ef_sc_hd__decap_40_12
XANTENNA__10389__A1 _05111_ vssd1 vssd1 vccd1 vccd1 sky130_fd_sc_hd__diode_2
XTAP_TAPCELL_ROW_118_2079 vssd1 vccd1 sky130_fd_sc_hd__tapvpwrvgnd_1
XANTENNA__07254__A1 net317 vssd1 vssd1 vccd1 vccd1 sky130_fd_sc_hd__diode_2
XFILLER_40_57 vssd1 vssd1 vccd1 vccd1 sky130_fd_sc_hd__fill_1
X_07289_ cell0.SB0.route_sel\[103\] cell0.SB0.route_sel\[102\] vssd1 vssd1 vccd1 vccd1
+ _02347_ sky130_fd_sc_hd__nand2b_1
X_09028_ cell1.CB_0.config_dataB\[3\] cell1.CB_0.config_dataB\[2\] vssd1 vssd1 vccd1
+ vccd1 _04058_ sky130_fd_sc_hd__nor2_1
Xhold271 cell2.LE_1B.config_data\[9\] vssd1 vssd1 vccd1 vccd1 net1230 sky130_fd_sc_hd__dlygate4sd3_1
XTAP_TAPCELL_ROW_131_2279 vssd1 vccd1 sky130_fd_sc_hd__tapvpwrvgnd_1
XTAP_TAPCELL_ROW_131_2268 vssd1 vccd1 sky130_fd_sc_hd__tapvpwrvgnd_1
Xhold260 cell3.LE_1A.config_data\[14\] vssd1 vssd1 vccd1 vccd1 net1219 sky130_fd_sc_hd__dlygate4sd3_1
Xhold293 _00861_ vssd1 vssd1 vccd1 vccd1 net1252 sky130_fd_sc_hd__dlygate4sd3_1
Xhold282 _00148_ vssd1 vssd1 vccd1 vccd1 net1241 sky130_fd_sc_hd__dlygate4sd3_1
XFILLER_2_469 vssd1 vssd1 vccd1 vccd1 sky130_fd_sc_hd__fill_4
XANTENNA__08754__A1 net30 vssd1 vssd1 vccd1 vccd1 sky130_fd_sc_hd__diode_2
Xfanout740 net741 vssd1 vssd1 vccd1 vccd1 net740 sky130_fd_sc_hd__clkbuf_4
Xfanout751 net754 vssd1 vssd1 vccd1 vccd1 net751 sky130_fd_sc_hd__clkbuf_4
X_13990_ clknet_leaf_43_clk net1422 net632 vssd1 vssd1 vccd1 vccd1 cell2.CB_0.config_data_inA
+ sky130_fd_sc_hd__dfrtp_1
Xfanout773 net780 vssd1 vssd1 vccd1 vccd1 net773 sky130_fd_sc_hd__buf_2
Xfanout762 net768 vssd1 vssd1 vccd1 vccd1 net762 sky130_fd_sc_hd__clkbuf_4
Xfanout784 net786 vssd1 vssd1 vccd1 vccd1 net784 sky130_fd_sc_hd__clkbuf_4
X_12941_ net1119 net1017 net933 vssd1 vssd1 vccd1 vccd1 _01369_ sky130_fd_sc_hd__mux2_1
XANTENNA__11105__A3 _05883_ vssd1 vssd1 vccd1 vccd1 sky130_fd_sc_hd__diode_2
Xfanout795 net798 vssd1 vssd1 vccd1 vccd1 net795 sky130_fd_sc_hd__clkbuf_4
XFILLER_46_635 vssd1 vssd1 vccd1 vccd1 sky130_fd_sc_hd__fill_1
X_12872_ cell2.SB0.route_sel\[114\] cell2.SB0.route_sel\[113\] net812 vssd1 vssd1
+ vccd1 vccd1 _01301_ sky130_fd_sc_hd__mux2_1
XTAP_TAPCELL_ROW_47_1019 vssd1 vccd1 sky130_fd_sc_hd__tapvpwrvgnd_1
XTAP_TAPCELL_ROW_47_1008 vssd1 vccd1 sky130_fd_sc_hd__tapvpwrvgnd_1
XANTENNA__12066__A1 cell1.LE_1A.config_data\[16\] vssd1 vssd1 vccd1 vccd1 sky130_fd_sc_hd__diode_2
X_11823_ cell1.CB_1.config_dataA\[4\] cell1.CB_1.config_dataA\[3\] net899 vssd1 vssd1
+ vccd1 vccd1 _00260_ sky130_fd_sc_hd__mux2_1
XFILLER_81_20 vccd1 vssd1 vccd1 vssd1 sky130_ef_sc_hd__decap_40_12
XFILLER_60_137 vssd1 vssd1 vccd1 vccd1 sky130_fd_sc_hd__fill_1
Xclkbuf_leaf_119_clk clknet_4_3_0_clk vssd1 vssd1 vccd1 vccd1 clknet_leaf_119_clk
+ sky130_fd_sc_hd__clkbuf_8
XFILLER_121_82 vssd1 vssd1 vccd1 vccd1 sky130_fd_sc_hd__fill_1
XTAP_TAPCELL_ROW_60_1208 vssd1 vccd1 sky130_fd_sc_hd__tapvpwrvgnd_1
X_11754_ cell0.LEI0.config_data\[4\] net1490 net796 vssd1 vssd1 vccd1 vccd1 _00191_
+ sky130_fd_sc_hd__mux2_1
XANTENNA__11813__A1 net1525 vssd1 vssd1 vccd1 vccd1 sky130_fd_sc_hd__diode_2
XTAP_TAPCELL_ROW_16_549 vssd1 vccd1 sky130_fd_sc_hd__tapvpwrvgnd_1
X_14473_ clknet_leaf_61_clk _01445_ net738 vssd1 vssd1 vccd1 vccd1 cell3.LEI0.config_data\[38\]
+ sky130_fd_sc_hd__dfrtp_1
X_10705_ _05662_ vssd1 vssd1 vccd1 vccd1 _05663_ sky130_fd_sc_hd__inv_2
X_11685_ net1247 cell0.LE_1A.config_data\[3\] net801 vssd1 vssd1 vccd1 vccd1 _00125_
+ sky130_fd_sc_hd__mux2_1
XFILLER_14_587 vssd1 vssd1 vccd1 vccd1 sky130_fd_sc_hd__fill_1
XFILLER_14_598 vssd1 vssd1 vccd1 vccd1 sky130_fd_sc_hd__fill_1
X_10636_ _05513_ _05566_ _01784_ vssd1 vssd1 vccd1 vccd1 _05594_ sky130_fd_sc_hd__o21ai_1
X_13424_ clknet_leaf_1_clk _00396_ net560 vssd1 vssd1 vccd1 vccd1 cell0.SB0.route_sel\[65\]
+ sky130_fd_sc_hd__dfstp_1
XANTENNA_output192_A net192 vssd1 vssd1 vccd1 vccd1 sky130_fd_sc_hd__diode_2
Xclkload108 clknet_leaf_81_clk vssd1 vssd1 vccd1 vccd1 clkload108/Y sky130_fd_sc_hd__clkinv_4
Xclkload119 clknet_leaf_73_clk vssd1 vssd1 vccd1 vccd1 clkload119/Y sky130_fd_sc_hd__inv_6
XANTENNA_input89_X net89 vssd1 vssd1 vccd1 vccd1 sky130_fd_sc_hd__diode_2
X_10567_ net395 _05519_ _05524_ vssd1 vssd1 vccd1 vccd1 _05525_ sky130_fd_sc_hd__o21ai_1
X_13355_ clknet_leaf_116_clk _00327_ net666 vssd1 vssd1 vccd1 vccd1 cell1.CB_0.config_dataA\[21\]
+ sky130_fd_sc_hd__dfstp_1
XFILLER_6_753 vssd1 vssd1 vccd1 vccd1 sky130_fd_sc_hd__fill_2
X_13286_ clknet_leaf_95_clk _00258_ net687 vssd1 vssd1 vccd1 vccd1 cell1.CB_1.config_dataA\[2\]
+ sky130_fd_sc_hd__dfstp_1
X_12306_ cell1.SB0.route_sel\[44\] cell1.SB0.route_sel\[43\] net863 vssd1 vssd1 vccd1
+ vccd1 _00739_ sky130_fd_sc_hd__mux2_1
X_10498_ _05464_ net335 _01965_ vssd1 vssd1 vccd1 vccd1 net163 sky130_fd_sc_hd__mux2_1
X_12237_ net422 cell2.CB_0.config_data_inA net826 vssd1 vssd1 vccd1 vccd1 _00670_
+ sky130_fd_sc_hd__mux2_1
XTAP_TAPCELL_ROW_75_1440 vssd1 vccd1 sky130_fd_sc_hd__tapvpwrvgnd_1
XFILLER_69_727 vssd1 vssd1 vccd1 vccd1 sky130_fd_sc_hd__fill_1
X_12168_ net1298 net1207 net850 vssd1 vssd1 vccd1 vccd1 _00601_ sky130_fd_sc_hd__mux2_1
XANTENNA__08849__B _03880_ vssd1 vssd1 vccd1 vccd1 sky130_fd_sc_hd__diode_2
X_11119_ _05924_ _06047_ _01795_ vssd1 vssd1 vccd1 vccd1 _06071_ sky130_fd_sc_hd__o21ai_1
XFILLER_84_719 vssd1 vssd1 vccd1 vccd1 sky130_fd_sc_hd__fill_2
X_12099_ cell1.LE_0A.config_data\[4\] net964 net877 vssd1 vssd1 vccd1 vccd1 _00533_
+ sky130_fd_sc_hd__mux2_1
XANTENNA__11275__B _05084_ vssd1 vssd1 vccd1 vccd1 sky130_fd_sc_hd__diode_2
Xinput6 CBeast_in[14] vssd1 vssd1 vccd1 vccd1 net6 sky130_fd_sc_hd__clkbuf_4
XFILLER_83_218 vssd1 vssd1 vccd1 vccd1 sky130_fd_sc_hd__fill_1
X_06660_ cell3.SB0.route_sel\[87\] vssd1 vssd1 vccd1 vccd1 _01730_ sky130_fd_sc_hd__inv_2
XFILLER_24_307 vssd1 vssd1 vccd1 vccd1 sky130_fd_sc_hd__fill_1
XFILLER_36_145 vssd1 vssd1 vccd1 vccd1 sky130_fd_sc_hd__fill_1
XTAP_TAPCELL_ROW_86_1591 vssd1 vccd1 sky130_fd_sc_hd__tapvpwrvgnd_1
XANTENNA__10459__X bus3_2\[10\] vssd1 vssd1 vccd1 vccd1 sky130_fd_sc_hd__diode_2
XTAP_TAPCELL_ROW_35_836 vssd1 vccd1 sky130_fd_sc_hd__tapvpwrvgnd_1
X_06591_ cell1.CB_1.config_dataB\[19\] vssd1 vssd1 vccd1 vccd1 _01661_ sky130_fd_sc_hd__inv_2
X_08330_ _02422_ _02424_ _03350_ vssd1 vssd1 vccd1 vccd1 _03368_ sky130_fd_sc_hd__o21ai_1
X_08261_ cell0.LE_1A.config_data\[1\] cell0.LE_1A.config_data\[0\] _03198_ vssd1 vssd1
+ vccd1 vccd1 _03301_ sky130_fd_sc_hd__mux2_1
XFILLER_20_502 vssd1 vssd1 vccd1 vccd1 sky130_fd_sc_hd__fill_8
X_07212_ _01834_ _02270_ _02271_ _02268_ vssd1 vssd1 vccd1 vccd1 _02272_ sky130_fd_sc_hd__o211a_1
X_08192_ cell0.LE_1A.config_data\[7\] cell0.LE_1A.config_data\[6\] _03198_ vssd1 vssd1
+ vccd1 vccd1 _03232_ sky130_fd_sc_hd__mux2_1
XFILLER_20_568 vssd1 vssd1 vccd1 vccd1 sky130_fd_sc_hd__fill_1
X_07143_ _01828_ _01867_ _02032_ vssd1 vssd1 vccd1 vccd1 _02205_ sky130_fd_sc_hd__nor3_1
XFILLER_10_27 vssd1 vssd1 vccd1 vccd1 sky130_fd_sc_hd__fill_1
X_07074_ cell1.SB0.route_sel\[77\] cell1.SB0.route_sel\[76\] vssd1 vssd1 vccd1 vccd1
+ _02138_ sky130_fd_sc_hd__nand2_1
XFILLER_126_27 vssd1 vssd1 vccd1 vccd1 sky130_fd_sc_hd__fill_1
XANTENNA__10791__A1 _04354_ vssd1 vssd1 vccd1 vccd1 sky130_fd_sc_hd__diode_2
XFILLER_142_15 vccd1 vssd1 vccd1 vssd1 sky130_ef_sc_hd__decap_40_12
X_07976_ cell0.LE_0A.config_data\[9\] cell0.LE_0A.config_data\[8\] _02947_ vssd1 vssd1
+ vccd1 vccd1 _03020_ sky130_fd_sc_hd__mux2_1
XANTENNA__11099__A2 net56 vssd1 vssd1 vccd1 vccd1 sky130_fd_sc_hd__diode_2
XFILLER_101_378 vssd1 vssd1 vccd1 vccd1 sky130_fd_sc_hd__fill_1
X_09715_ net363 cell3.CB_1.config_dataB\[23\] _04358_ vssd1 vssd1 vccd1 vccd1 _04728_
+ sky130_fd_sc_hd__and3_1
X_06927_ _01906_ _01993_ bus3_2\[7\] vssd1 vssd1 vccd1 vccd1 _01994_ sky130_fd_sc_hd__o21a_1
XFILLER_19_69 vssd1 vssd1 vccd1 vccd1 sky130_fd_sc_hd__fill_4
X_09646_ _04634_ _04653_ _04661_ net552 vssd1 vssd1 vccd1 vccd1 _04662_ sky130_fd_sc_hd__o211a_2
X_06858_ cell2.SB0.route_sel\[48\] cell2.SB0.route_sel\[49\] _01926_ vssd1 vssd1 vccd1
+ vccd1 _01927_ sky130_fd_sc_hd__a21oi_1
XANTENNA__10846__A2 _05519_ vssd1 vssd1 vccd1 vccd1 sky130_fd_sc_hd__diode_2
XANTENNA_fanout822_A net824 vssd1 vssd1 vccd1 vccd1 sky130_fd_sc_hd__diode_2
X_09577_ _04588_ _04594_ _04590_ vssd1 vssd1 vccd1 vccd1 _04595_ sky130_fd_sc_hd__a21oi_1
XFILLER_70_424 vssd1 vssd1 vccd1 vccd1 sky130_fd_sc_hd__fill_1
X_06789_ _01458_ _01459_ net125 cell0.SB0.route_sel\[52\] cell0.SB0.route_sel\[53\]
+ vssd1 vssd1 vccd1 vccd1 _01859_ sky130_fd_sc_hd__o2111a_1
XANTENNA__08494__B _03529_ vssd1 vssd1 vccd1 vccd1 sky130_fd_sc_hd__diode_2
XFILLER_35_57 vccd1 vssd1 vccd1 vssd1 sky130_ef_sc_hd__decap_40_12
XTAP_TAPCELL_ROW_100_1809 vssd1 vccd1 sky130_fd_sc_hd__tapvpwrvgnd_1
X_08528_ net495 _03489_ vssd1 vssd1 vccd1 vccd1 _03564_ sky130_fd_sc_hd__nand2_1
XFILLER_35_79 vssd1 vssd1 vccd1 vccd1 sky130_fd_sc_hd__fill_1
XANTENNA__08672__A0 net31 vssd1 vssd1 vccd1 vccd1 sky130_fd_sc_hd__diode_2
XFILLER_11_502 vssd1 vssd1 vccd1 vccd1 sky130_fd_sc_hd__fill_2
XTAP_TAPCELL_ROW_13_508 vssd1 vccd1 sky130_fd_sc_hd__tapvpwrvgnd_1
X_08459_ _02444_ _03493_ _03474_ vssd1 vssd1 vccd1 vccd1 _03495_ sky130_fd_sc_hd__o21ai_1
XFILLER_50_170 vssd1 vssd1 vccd1 vccd1 sky130_fd_sc_hd__fill_1
XPHY_EDGE_ROW_14_Right_14 vssd1 vssd1 vccd1 vccd1 sky130_fd_sc_hd__decap_3
XTAP_TAPCELL_ROW_133_2308 vssd1 vccd1 sky130_fd_sc_hd__tapvpwrvgnd_1
XFILLER_129_3 vccd1 vssd1 vccd1 vssd1 sky130_ef_sc_hd__decap_40_12
XFILLER_51_78 vssd1 vssd1 vccd1 vccd1 sky130_fd_sc_hd__fill_1
X_11470_ cell1.SB0.route_sel\[82\] _01534_ cell1.SB0.route_sel\[86\] cell1.SB0.route_sel\[87\]
+ _06313_ vssd1 vssd1 vccd1 vccd1 _06314_ sky130_fd_sc_hd__o221a_1
X_10421_ _05418_ _05419_ _05309_ vssd1 vssd1 vccd1 vccd1 _05420_ sky130_fd_sc_hd__mux2_1
XANTENNA__13836__SET_B net674 vssd1 vssd1 vccd1 vccd1 sky130_fd_sc_hd__diode_2
XFILLER_136_253 vssd1 vssd1 vccd1 vccd1 sky130_fd_sc_hd__fill_1
X_10352_ net428 net426 _05139_ _05349_ cell2.CB_0.config_dataB\[12\] vssd1 vssd1 vccd1
+ vccd1 _05351_ sky130_fd_sc_hd__o311a_1
XFILLER_109_489 vssd1 vssd1 vccd1 vccd1 sky130_fd_sc_hd__fill_4
X_13140_ clknet_leaf_124_clk _00112_ net579 vssd1 vssd1 vccd1 vccd1 cell0.CB_1.config_dataB\[17\]
+ sky130_fd_sc_hd__dfstp_1
XANTENNA__10782__A1 _05478_ vssd1 vssd1 vccd1 vccd1 sky130_fd_sc_hd__diode_2
XANTENNA__13278__D net1526 vssd1 vssd1 vccd1 vccd1 sky130_fd_sc_hd__diode_2
X_13071_ clknet_leaf_111_clk _00043_ net654 vssd1 vssd1 vccd1 vccd1 cell0.CB_1.config_dataA\[23\]
+ sky130_fd_sc_hd__dfstp_2
X_10283_ cell2.CB_0.config_dataB\[6\] net432 vssd1 vssd1 vccd1 vccd1 _05282_ sky130_fd_sc_hd__and2b_1
XTAP_TAPCELL_ROW_57_1170 vssd1 vccd1 sky130_fd_sc_hd__tapvpwrvgnd_1
XFILLER_2_233 vccd1 vssd1 vccd1 vssd1 sky130_ef_sc_hd__decap_40_12
X_12022_ cell1.CB_1.config_dataB\[0\] cell1.CB_1.config_dataA\[24\] net886 vssd1 vssd1
+ vccd1 vccd1 _00459_ sky130_fd_sc_hd__mux2_1
XANTENNA_input49_A CBnorth_in[24] vssd1 vssd1 vccd1 vccd1 sky130_fd_sc_hd__diode_2
XANTENNA__10534__A1 _05483_ vssd1 vssd1 vccd1 vccd1 sky130_fd_sc_hd__diode_2
XFILLER_78_546 vssd1 vssd1 vccd1 vccd1 sky130_fd_sc_hd__fill_1
XFILLER_2_277 vccd1 vssd1 vccd1 vssd1 sky130_ef_sc_hd__decap_40_12
XPHY_EDGE_ROW_23_Right_23 vssd1 vssd1 vccd1 vccd1 sky130_fd_sc_hd__decap_3
X_13973_ clknet_leaf_41_clk _00945_ net642 vssd1 vssd1 vccd1 vccd1 cell2.LEI0.config_data\[30\]
+ sky130_fd_sc_hd__dfrtp_1
Xfanout592 net601 vssd1 vssd1 vccd1 vccd1 net592 sky130_fd_sc_hd__clkbuf_2
Xfanout570 net571 vssd1 vssd1 vccd1 vccd1 net570 sky130_fd_sc_hd__buf_2
Xfanout581 net602 vssd1 vssd1 vccd1 vccd1 net581 sky130_fd_sc_hd__buf_2
X_12924_ cell3.LE_1A.config_data\[12\] net1079 net942 vssd1 vssd1 vccd1 vccd1 _01353_
+ sky130_fd_sc_hd__mux2_1
XFILLER_46_432 vssd1 vssd1 vccd1 vccd1 sky130_fd_sc_hd__fill_1
XFILLER_18_145 vssd1 vssd1 vccd1 vccd1 sky130_fd_sc_hd__fill_1
X_12855_ cell2.SB0.route_sel\[97\] cell2.SB0.route_sel\[96\] net826 vssd1 vssd1 vccd1
+ vccd1 _01284_ sky130_fd_sc_hd__mux2_1
XFILLER_92_41 vccd1 vssd1 vccd1 vssd1 sky130_ef_sc_hd__decap_40_12
XANTENNA_output205_A net205 vssd1 vssd1 vccd1 vccd1 sky130_fd_sc_hd__diode_2
X_12786_ cell2.SB0.route_sel\[28\] cell2.SB0.route_sel\[27\] net817 vssd1 vssd1 vccd1
+ vccd1 _01215_ sky130_fd_sc_hd__mux2_1
X_11806_ cell1.LE_1B.config_data\[7\] cell1.LE_1B.config_data\[6\] net901 vssd1 vssd1
+ vccd1 vccd1 _00243_ sky130_fd_sc_hd__mux2_1
XPHY_EDGE_ROW_32_Right_32 vssd1 vssd1 vccd1 vccd1 sky130_fd_sc_hd__decap_3
XFILLER_33_137 vssd1 vssd1 vccd1 vccd1 sky130_fd_sc_hd__fill_1
XFILLER_33_159 vssd1 vssd1 vccd1 vccd1 sky130_fd_sc_hd__fill_4
X_11737_ net999 net988 net808 vssd1 vssd1 vccd1 vccd1 _00175_ sky130_fd_sc_hd__mux2_1
X_14456_ clknet_leaf_67_clk _01428_ net736 vssd1 vssd1 vccd1 vccd1 cell3.LEI0.config_data\[21\]
+ sky130_fd_sc_hd__dfrtp_1
X_11668_ cell0.CB_1.config_dataB\[14\] cell0.CB_1.config_dataB\[13\] net787 vssd1
+ vssd1 vccd1 vccd1 _00109_ sky130_fd_sc_hd__mux2_1
XANTENNA__11014__A2 net51 vssd1 vssd1 vccd1 vccd1 sky130_fd_sc_hd__diode_2
X_14387_ clknet_leaf_66_clk _01359_ net743 vssd1 vssd1 vccd1 vccd1 cell3.LE_1A.reset_val
+ sky130_fd_sc_hd__dfrtp_1
X_10619_ _01785_ _05543_ _05576_ net396 vssd1 vssd1 vccd1 vccd1 _05577_ sky130_fd_sc_hd__o211a_1
X_13407_ clknet_leaf_134_clk _00379_ net555 vssd1 vssd1 vccd1 vccd1 cell0.SB0.route_sel\[48\]
+ sky130_fd_sc_hd__dfstp_2
X_11599_ cell0.CB_1.config_dataA\[20\] cell0.CB_1.config_dataA\[19\] net790 vssd1
+ vssd1 vccd1 vccd1 _00040_ sky130_fd_sc_hd__mux2_1
X_13338_ clknet_leaf_83_clk _00310_ net674 vssd1 vssd1 vccd1 vccd1 cell1.CB_0.config_dataA\[4\]
+ sky130_fd_sc_hd__dfstp_1
X_13269_ clknet_leaf_93_clk net1449 net693 vssd1 vssd1 vccd1 vccd1 cell1.LE_1B.config_data\[5\]
+ sky130_fd_sc_hd__dfrtp_1
XPHY_EDGE_ROW_41_Right_41 vssd1 vssd1 vccd1 vccd1 sky130_fd_sc_hd__decap_3
X_07830_ _02388_ _02869_ _02870_ _02456_ _01571_ vssd1 vssd1 vccd1 vccd1 _02874_ sky130_fd_sc_hd__a221o_1
XFILLER_84_516 vssd1 vssd1 vccd1 vccd1 sky130_fd_sc_hd__fill_8
X_07761_ _02804_ _02806_ vssd1 vssd1 vccd1 vccd1 _02807_ sky130_fd_sc_hd__nand2_4
X_06712_ cell3.CB_1.config_dataB\[12\] vssd1 vssd1 vccd1 vccd1 _01782_ sky130_fd_sc_hd__inv_2
XTAP_TAPCELL_ROW_88_1631 vssd1 vccd1 sky130_fd_sc_hd__tapvpwrvgnd_1
X_09500_ _04506_ _04513_ _04520_ vssd1 vssd1 vccd1 vccd1 _04521_ sky130_fd_sc_hd__a21oi_2
XFILLER_2_83 vssd1 vssd1 vccd1 vccd1 sky130_fd_sc_hd__fill_1
XFILLER_37_421 vssd1 vssd1 vccd1 vccd1 sky130_fd_sc_hd__fill_1
XFILLER_112_29 vccd1 vssd1 vccd1 vssd1 sky130_ef_sc_hd__decap_40_12
XFILLER_80_711 vssd1 vssd1 vccd1 vccd1 sky130_fd_sc_hd__fill_1
X_07692_ cell1.SB0.route_sel\[16\] cell1.SB0.route_sel\[17\] _01505_ cell1.SB0.route_sel\[19\]
+ _02739_ vssd1 vssd1 vccd1 vccd1 _02740_ sky130_fd_sc_hd__o221a_1
X_09431_ net295 _04452_ _04453_ _04451_ vssd1 vssd1 vccd1 vccd1 _04454_ sky130_fd_sc_hd__a22o_1
X_06643_ cell3.SB0.route_sel\[57\] vssd1 vssd1 vccd1 vccd1 _01713_ sky130_fd_sc_hd__inv_2
XFILLER_52_435 vssd1 vssd1 vccd1 vccd1 sky130_fd_sc_hd__fill_1
XPHY_EDGE_ROW_50_Right_50 vssd1 vssd1 vccd1 vccd1 sky130_fd_sc_hd__decap_3
XANTENNA__11225__S _06076_ vssd1 vssd1 vccd1 vccd1 sky130_fd_sc_hd__diode_2
X_06574_ cell2.SB0.route_sel\[113\] vssd1 vssd1 vccd1 vccd1 _01644_ sky130_fd_sc_hd__inv_2
X_09362_ _01906_ _02082_ bus3_2\[4\] vssd1 vssd1 vccd1 vccd1 _04386_ sky130_fd_sc_hd__o21ai_1
XFILLER_80_755 vssd1 vssd1 vccd1 vccd1 sky130_fd_sc_hd__fill_1
XANTENNA__08654__A0 net4 vssd1 vssd1 vccd1 vccd1 sky130_fd_sc_hd__diode_2
XANTENNA__08249__A3 bus1_0\[3\] vssd1 vssd1 vccd1 vccd1 sky130_fd_sc_hd__diode_2
X_08313_ net509 net508 vssd1 vssd1 vccd1 vccd1 _03351_ sky130_fd_sc_hd__nor2_1
XANTENNA_11 _06141_ vssd1 vssd1 vccd1 vccd1 sky130_fd_sc_hd__diode_2
XANTENNA__09997__A3 bus3_2\[15\] vssd1 vssd1 vccd1 vccd1 sky130_fd_sc_hd__diode_2
XANTENNA__10917__X _05871_ vssd1 vssd1 vccd1 vccd1 sky130_fd_sc_hd__diode_2
X_09293_ cell3.SB0.route_sel\[16\] cell3.SB0.route_sel\[17\] _04318_ vssd1 vssd1 vccd1
+ vccd1 _04319_ sky130_fd_sc_hd__a21o_1
XANTENNA_22 net143 vssd1 vssd1 vccd1 vccd1 sky130_fd_sc_hd__diode_2
XANTENNA_33 CBeast_in[23] vssd1 vssd1 vccd1 vccd1 sky130_fd_sc_hd__diode_2
XANTENNA_44 net1508 vssd1 vssd1 vccd1 vccd1 sky130_fd_sc_hd__diode_2
XFILLER_20_365 vssd1 vssd1 vccd1 vccd1 sky130_fd_sc_hd__fill_1
X_08244_ _03282_ _03283_ cell0.CB_1.config_dataA\[17\] vssd1 vssd1 vccd1 vccd1 _03284_
+ sky130_fd_sc_hd__or3b_1
XTAP_TAPCELL_ROW_115_2027 vssd1 vccd1 sky130_fd_sc_hd__tapvpwrvgnd_1
X_08175_ _03200_ _03204_ _03207_ _03210_ _03206_ vssd1 vssd1 vccd1 vccd1 _03215_ sky130_fd_sc_hd__o221a_1
XFILLER_21_15 vccd1 vssd1 vccd1 vssd1 sky130_ef_sc_hd__decap_40_12
XFILLER_137_15 vccd1 vssd1 vccd1 vssd1 sky130_ef_sc_hd__decap_40_12
XTAP_TAPCELL_ROW_115_2038 vssd1 vccd1 sky130_fd_sc_hd__tapvpwrvgnd_1
XTAP_TAPCELL_ROW_99_1793 vssd1 vccd1 sky130_fd_sc_hd__tapvpwrvgnd_1
X_07126_ _02186_ _02188_ vssd1 vssd1 vccd1 vccd1 bus2_0\[9\] sky130_fd_sc_hd__and2_2
XANTENNA__08957__A1 _03849_ vssd1 vssd1 vccd1 vccd1 sky130_fd_sc_hd__diode_2
XANTENNA__08957__B2 _03853_ vssd1 vssd1 vccd1 vccd1 sky130_fd_sc_hd__diode_2
XFILLER_133_223 vssd1 vssd1 vccd1 vccd1 sky130_fd_sc_hd__fill_1
XANTENNA__10084__B _05084_ vssd1 vssd1 vccd1 vccd1 sky130_fd_sc_hd__diode_2
Xoutput151 net151 vssd1 vssd1 vccd1 vccd1 CBeast_out[25] sky130_fd_sc_hd__buf_2
X_07057_ cell0.CB_0.config_dataA\[24\] cell0.CB_0.config_dataA\[21\] cell0.CB_0.config_dataA\[20\]
+ vssd1 vssd1 vccd1 vccd1 _02121_ sky130_fd_sc_hd__or3b_4
Xoutput140 net140 vssd1 vssd1 vccd1 vccd1 CBeast_out[15] sky130_fd_sc_hd__buf_2
XANTENNA__08709__A1 net27 vssd1 vssd1 vccd1 vccd1 sky130_fd_sc_hd__diode_2
Xoutput184 net184 vssd1 vssd1 vccd1 vccd1 CBnorth_out[26] sky130_fd_sc_hd__buf_2
Xoutput195 net195 vssd1 vssd1 vccd1 vccd1 CBnorth_out[7] sky130_fd_sc_hd__buf_2
Xoutput173 net173 vssd1 vssd1 vccd1 vccd1 CBnorth_out[16] sky130_fd_sc_hd__buf_2
XANTENNA_fanout772_A net773 vssd1 vssd1 vccd1 vccd1 sky130_fd_sc_hd__diode_2
XANTENNA__08709__B2 net28 vssd1 vssd1 vccd1 vccd1 sky130_fd_sc_hd__diode_2
Xoutput162 net162 vssd1 vssd1 vccd1 vccd1 CBeast_out[6] sky130_fd_sc_hd__buf_2
XTAP_TAPCELL_ROW_110_1960 vssd1 vccd1 sky130_fd_sc_hd__tapvpwrvgnd_1
XANTENNA__09921__A3 bus3_2\[3\] vssd1 vssd1 vccd1 vccd1 sky130_fd_sc_hd__diode_2
XFILLER_87_376 vssd1 vssd1 vccd1 vccd1 sky130_fd_sc_hd__fill_1
XANTENNA__07932__A2 net350 vssd1 vssd1 vccd1 vccd1 sky130_fd_sc_hd__diode_2
X_07959_ _03001_ _03002_ _02999_ vssd1 vssd1 vccd1 vccd1 _03003_ sky130_fd_sc_hd__o21ai_1
XANTENNA__09685__A2 _04697_ vssd1 vssd1 vccd1 vccd1 sky130_fd_sc_hd__diode_2
X_10970_ _04205_ _04214_ _04224_ _05923_ vssd1 vssd1 vccd1 vccd1 _05924_ sky130_fd_sc_hd__o211a_4
XANTENNA__07145__B1 _02203_ vssd1 vssd1 vccd1 vccd1 sky130_fd_sc_hd__diode_2
X_09629_ _02378_ _04642_ _04644_ vssd1 vssd1 vccd1 vccd1 _04645_ sky130_fd_sc_hd__o21a_1
XFILLER_70_210 vssd1 vssd1 vccd1 vccd1 sky130_fd_sc_hd__fill_1
X_12640_ cell3.SB0.route_sel\[105\] cell3.SB0.route_sel\[104\] net921 vssd1 vssd1
+ vccd1 vccd1 _01069_ sky130_fd_sc_hd__mux2_1
XANTENNA_input103_A SBwest_in[15] vssd1 vssd1 vccd1 vccd1 sky130_fd_sc_hd__diode_2
XFILLER_62_44 vssd1 vssd1 vccd1 vccd1 sky130_fd_sc_hd__fill_1
Xclkbuf_leaf_50_clk clknet_4_12_0_clk vssd1 vssd1 vccd1 vccd1 clknet_leaf_50_clk sky130_fd_sc_hd__clkbuf_8
X_14310_ clknet_leaf_16_clk _01282_ net626 vssd1 vssd1 vccd1 vccd1 cell2.SB0.route_sel\[95\]
+ sky130_fd_sc_hd__dfstp_1
X_12571_ cell3.SB0.route_sel\[36\] cell3.SB0.route_sel\[35\] net911 vssd1 vssd1 vccd1
+ vccd1 _01000_ sky130_fd_sc_hd__mux2_1
XFILLER_11_310 vssd1 vssd1 vccd1 vccd1 sky130_fd_sc_hd__fill_2
XTAP_TAPCELL_ROW_26_699 vssd1 vccd1 sky130_fd_sc_hd__tapvpwrvgnd_1
XANTENNA__06753__A net308 vssd1 vssd1 vccd1 vccd1 sky130_fd_sc_hd__diode_2
X_11522_ _06348_ _02320_ vssd1 vssd1 vccd1 vccd1 net249 sky130_fd_sc_hd__and2b_2
XANTENNA__10546__Y _05504_ vssd1 vssd1 vccd1 vccd1 sky130_fd_sc_hd__diode_2
XANTENNA__10452__B1 cell3.SB0.route_sel\[69\] vssd1 vssd1 vccd1 vccd1 sky130_fd_sc_hd__diode_2
X_14241_ clknet_leaf_19_clk _01213_ net611 vssd1 vssd1 vccd1 vccd1 cell2.SB0.route_sel\[26\]
+ sky130_fd_sc_hd__dfstp_1
XFILLER_7_39 vccd1 vssd1 vccd1 vssd1 sky130_ef_sc_hd__decap_40_12
XANTENNA__08660__A3 _03498_ vssd1 vssd1 vccd1 vccd1 sky130_fd_sc_hd__diode_2
X_11453_ _02820_ _06302_ vssd1 vssd1 vccd1 vccd1 net210 sky130_fd_sc_hd__nor2_1
X_14172_ clknet_leaf_57_clk _01144_ net721 vssd1 vssd1 vccd1 vccd1 cell3.CB_0.config_dataB\[7\]
+ sky130_fd_sc_hd__dfstp_1
X_10404_ _05397_ _05399_ _05401_ _05402_ vssd1 vssd1 vccd1 vccd1 _05403_ sky130_fd_sc_hd__o2bb2a_1
XFILLER_7_358 vssd1 vssd1 vccd1 vccd1 sky130_fd_sc_hd__fill_1
XANTENNA__10755__A1 net9 vssd1 vssd1 vccd1 vccd1 sky130_fd_sc_hd__diode_2
X_11384_ _06256_ _01874_ vssd1 vssd1 vccd1 vccd1 net258 sky130_fd_sc_hd__and2b_1
XANTENNA__06959__B1 _02020_ vssd1 vssd1 vccd1 vccd1 sky130_fd_sc_hd__diode_2
X_13123_ clknet_leaf_125_clk _00095_ net584 vssd1 vssd1 vccd1 vccd1 cell0.CB_1.config_dataB\[0\]
+ sky130_fd_sc_hd__dfstp_1
X_10335_ _05093_ _05313_ _05332_ cell2.CB_0.config_dataB\[2\] vssd1 vssd1 vccd1 vccd1
+ _05334_ sky130_fd_sc_hd__a211oi_1
XTAP_TAPCELL_ROW_55_1129 vssd1 vccd1 sky130_fd_sc_hd__tapvpwrvgnd_1
XFILLER_3_542 vccd1 vssd1 vccd1 vssd1 sky130_ef_sc_hd__decap_40_12
XFILLER_11_81 vssd1 vssd1 vccd1 vccd1 sky130_fd_sc_hd__fill_4
X_10266_ _05265_ _05266_ _05164_ vssd1 vssd1 vccd1 vccd1 _05267_ sky130_fd_sc_hd__mux2_1
X_13054_ clknet_leaf_126_clk _00026_ net582 vssd1 vssd1 vccd1 vccd1 cell0.CB_1.config_dataA\[6\]
+ sky130_fd_sc_hd__dfstp_1
XFILLER_3_597 vccd1 vssd1 vccd1 vssd1 sky130_ef_sc_hd__decap_40_12
XFILLER_78_354 vssd1 vssd1 vccd1 vccd1 sky130_fd_sc_hd__fill_1
XFILLER_78_332 vssd1 vssd1 vccd1 vccd1 sky130_fd_sc_hd__fill_1
XANTENNA__08176__A2 _02494_ vssd1 vssd1 vccd1 vccd1 sky130_fd_sc_hd__diode_2
X_12005_ cell0.SB0.route_sel\[111\] cell0.SB0.route_sel\[110\] net758 vssd1 vssd1
+ vccd1 vccd1 _00442_ sky130_fd_sc_hd__mux2_1
XANTENNA__11180__A1 _05916_ vssd1 vssd1 vccd1 vccd1 sky130_fd_sc_hd__diode_2
X_10197_ net415 _05103_ vssd1 vssd1 vccd1 vccd1 _05198_ sky130_fd_sc_hd__nand2_1
XFILLER_93_302 vssd1 vssd1 vccd1 vccd1 sky130_fd_sc_hd__fill_1
XFILLER_38_218 vssd1 vssd1 vccd1 vccd1 sky130_fd_sc_hd__fill_1
XFILLER_94_847 vssd1 vssd1 vccd1 vccd1 sky130_fd_sc_hd__fill_1
XANTENNA__09125__A1 _03853_ vssd1 vssd1 vccd1 vccd1 sky130_fd_sc_hd__diode_2
XTAP_TAPCELL_ROW_6_391 vssd1 vccd1 sky130_fd_sc_hd__tapvpwrvgnd_1
X_13956_ clknet_leaf_43_clk net1371 net635 vssd1 vssd1 vccd1 vccd1 cell2.LEI0.config_data\[13\]
+ sky130_fd_sc_hd__dfrtp_1
XANTENNA__09125__B2 _03849_ vssd1 vssd1 vccd1 vccd1 sky130_fd_sc_hd__diode_2
XANTENNA__08619__S _03546_ vssd1 vssd1 vccd1 vccd1 sky130_fd_sc_hd__diode_2
X_13887_ clknet_leaf_53_clk _00859_ net714 vssd1 vssd1 vccd1 vccd1 cell2.LE_1A.config_data\[10\]
+ sky130_fd_sc_hd__dfrtp_1
X_12907_ cell3.CB_1.config_dataB\[21\] cell3.CB_1.config_dataB\[20\] net936 vssd1
+ vssd1 vccd1 vccd1 _01336_ sky130_fd_sc_hd__mux2_1
XANTENNA__10691__A0 net21 vssd1 vssd1 vccd1 vccd1 sky130_fd_sc_hd__diode_2
X_12838_ cell2.SB0.route_sel\[80\] cell2.SB0.route_sel\[79\] net798 vssd1 vssd1 vccd1
+ vccd1 _01267_ sky130_fd_sc_hd__mux2_1
XFILLER_62_755 vssd1 vssd1 vccd1 vccd1 sky130_fd_sc_hd__fill_1
XTAP_TAPCELL_ROW_83_1550 vssd1 vccd1 sky130_fd_sc_hd__tapvpwrvgnd_1
XTAP_TAPCELL_ROW_45_986 vssd1 vccd1 sky130_fd_sc_hd__tapvpwrvgnd_1
XFILLER_15_682 vssd1 vssd1 vccd1 vccd1 sky130_fd_sc_hd__fill_1
Xclkbuf_leaf_41_clk clknet_4_7_0_clk vssd1 vssd1 vccd1 vccd1 clknet_leaf_41_clk sky130_fd_sc_hd__clkbuf_8
X_12769_ cell2.SB0.route_sel\[11\] cell2.SB0.route_sel\[10\] net831 vssd1 vssd1 vccd1
+ vccd1 _01198_ sky130_fd_sc_hd__mux2_1
Xinput20 CBeast_in[27] vssd1 vssd1 vccd1 vccd1 net20 sky130_fd_sc_hd__buf_2
X_14439_ clknet_leaf_59_clk net1459 net734 vssd1 vssd1 vccd1 vccd1 cell3.LEI0.config_data\[4\]
+ sky130_fd_sc_hd__dfrtp_1
Xinput31 CBeast_in[8] vssd1 vssd1 vccd1 vccd1 net31 sky130_fd_sc_hd__clkbuf_4
Xinput53 CBnorth_in[28] vssd1 vssd1 vccd1 vccd1 net53 sky130_fd_sc_hd__clkbuf_4
Xinput42 CBnorth_in[18] vssd1 vssd1 vccd1 vccd1 net42 sky130_fd_sc_hd__clkbuf_4
Xinput64 CBnorth_in[9] vssd1 vssd1 vccd1 vccd1 net64 sky130_fd_sc_hd__buf_2
XANTENNA__08939__A1 bus3_1\[7\] vssd1 vssd1 vccd1 vccd1 sky130_fd_sc_hd__diode_2
Xinput75 SBsouth_in[19] vssd1 vssd1 vccd1 vccd1 net75 sky130_fd_sc_hd__buf_1
Xinput86 SBsouth_in[29] vssd1 vssd1 vccd1 vccd1 net86 sky130_fd_sc_hd__clkbuf_2
Xinput97 SBwest_in[0] vssd1 vssd1 vccd1 vccd1 net97 sky130_fd_sc_hd__buf_1
X_09980_ _04555_ _04958_ _04982_ _04983_ cell2.CB_1.config_dataB\[7\] vssd1 vssd1
+ vccd1 vccd1 _04984_ sky130_fd_sc_hd__a2111o_1
XFILLER_131_727 vssd1 vssd1 vccd1 vccd1 sky130_fd_sc_hd__fill_1
X_08931_ _03849_ _03940_ _03941_ _03853_ cell1.CB_0.config_dataA\[12\] vssd1 vssd1
+ vccd1 vccd1 _03963_ sky130_fd_sc_hd__a221o_1
X_08862_ _03891_ _03892_ _03893_ _02820_ vssd1 vssd1 vccd1 vccd1 _03894_ sky130_fd_sc_hd__a31o_4
XFILLER_84_302 vssd1 vssd1 vccd1 vccd1 sky130_fd_sc_hd__fill_1
XFILLER_69_376 vssd1 vssd1 vccd1 vccd1 sky130_fd_sc_hd__fill_2
X_07813_ _02850_ _02852_ _02857_ _02851_ vssd1 vssd1 vccd1 vccd1 _02858_ sky130_fd_sc_hd__a22o_1
XFILLER_123_39 vccd1 vssd1 vccd1 vssd1 sky130_ef_sc_hd__decap_40_12
XFILLER_84_346 vssd1 vssd1 vccd1 vccd1 sky130_fd_sc_hd__fill_1
X_08793_ _02444_ _03824_ vssd1 vssd1 vccd1 vccd1 _03825_ sky130_fd_sc_hd__nor2_1
X_07744_ cell0.SB0.route_sel\[33\] cell0.SB0.route_sel\[32\] vssd1 vssd1 vccd1 vccd1
+ _02790_ sky130_fd_sc_hd__nand2_1
XFILLER_37_240 vssd1 vssd1 vccd1 vccd1 sky130_fd_sc_hd__fill_1
X_07675_ _02701_ _02720_ _02722_ vssd1 vssd1 vccd1 vccd1 _02723_ sky130_fd_sc_hd__a21o_1
XFILLER_16_26 vssd1 vssd1 vccd1 vccd1 sky130_fd_sc_hd__fill_2
X_09414_ _01920_ _02178_ vssd1 vssd1 vccd1 vccd1 _04437_ sky130_fd_sc_hd__nor2_1
X_06626_ cell3.SB0.route_sel\[31\] vssd1 vssd1 vccd1 vccd1 _01696_ sky130_fd_sc_hd__inv_2
XANTENNA_fanout353_A _02609_ vssd1 vssd1 vccd1 vccd1 sky130_fd_sc_hd__diode_2
XFILLER_25_446 vssd1 vssd1 vccd1 vccd1 sky130_fd_sc_hd__fill_2
XANTENNA__08890__A3 bus3_1\[3\] vssd1 vssd1 vccd1 vccd1 sky130_fd_sc_hd__diode_2
XANTENNA_fanout618_A net619 vssd1 vssd1 vccd1 vccd1 sky130_fd_sc_hd__diode_2
Xclkbuf_leaf_32_clk clknet_4_5_0_clk vssd1 vssd1 vccd1 vccd1 clknet_leaf_32_clk sky130_fd_sc_hd__clkbuf_8
X_09345_ _04355_ _04368_ _04369_ net930 vssd1 vssd1 vccd1 vccd1 _04370_ sky130_fd_sc_hd__a31o_2
X_06557_ cell2.SB0.route_sel\[78\] vssd1 vssd1 vccd1 vccd1 _01627_ sky130_fd_sc_hd__inv_2
XTAP_TAPCELL_ROW_23_647 vssd1 vccd1 sky130_fd_sc_hd__tapvpwrvgnd_1
X_09276_ cell3.SB0.route_sel\[19\] cell3.SB0.route_sel\[18\] vssd1 vssd1 vccd1 vccd1
+ _04302_ sky130_fd_sc_hd__nand2_1
X_06488_ cell0.CB_0.config_dataB\[7\] vssd1 vssd1 vccd1 vccd1 _01558_ sky130_fd_sc_hd__inv_2
XTAP_TAPCELL_ROW_23_658 vssd1 vccd1 sky130_fd_sc_hd__tapvpwrvgnd_1
XFILLER_20_184 vssd1 vssd1 vccd1 vccd1 sky130_fd_sc_hd__fill_1
X_08227_ net536 net535 vssd1 vssd1 vccd1 vccd1 _03267_ sky130_fd_sc_hd__nor2_1
XFILLER_5_829 vssd1 vssd1 vccd1 vccd1 sky130_fd_sc_hd__fill_1
XFILLER_106_201 vssd1 vssd1 vccd1 vccd1 sky130_fd_sc_hd__fill_1
X_08158_ cell0.LEI0.config_data\[8\] _03197_ _03195_ _03194_ vssd1 vssd1 vccd1 vccd1
+ _03198_ sky130_fd_sc_hd__o211a_4
XFILLER_4_339 vssd1 vssd1 vccd1 vccd1 sky130_fd_sc_hd__fill_4
X_07109_ _02132_ _02171_ vssd1 vssd1 vccd1 vccd1 _02172_ sky130_fd_sc_hd__nor2_4
X_08089_ _03124_ _03127_ _03129_ _03130_ vssd1 vssd1 vccd1 vccd1 _03131_ sky130_fd_sc_hd__o22a_1
X_10120_ _05117_ _05120_ cell2.CB_0.config_dataA\[8\] vssd1 vssd1 vccd1 vccd1 _05121_
+ sky130_fd_sc_hd__or3b_1
X_10051_ net401 _04472_ _05054_ cell2.CB_1.config_dataB\[16\] vssd1 vssd1 vccd1 vccd1
+ _05055_ sky130_fd_sc_hd__o211a_1
XFILLER_0_556 vssd1 vssd1 vccd1 vccd1 sky130_fd_sc_hd__fill_4
Xclkbuf_leaf_99_clk clknet_4_10_0_clk vssd1 vssd1 vccd1 vccd1 clknet_leaf_99_clk sky130_fd_sc_hd__clkbuf_8
XTAP_TAPCELL_ROW_128_2229 vssd1 vccd1 sky130_fd_sc_hd__tapvpwrvgnd_1
XFILLER_102_462 vssd1 vssd1 vccd1 vccd1 sky130_fd_sc_hd__fill_1
XTAP_TAPCELL_ROW_50_1059 vssd1 vccd1 sky130_fd_sc_hd__tapvpwrvgnd_1
XANTENNA__09107__A1 bus3_1\[4\] vssd1 vssd1 vccd1 vccd1 sky130_fd_sc_hd__diode_2
XTAP_TAPCELL_ROW_141_2418 vssd1 vccd1 sky130_fd_sc_hd__tapvpwrvgnd_1
XANTENNA__09107__B2 bus3_1\[5\] vssd1 vssd1 vccd1 vccd1 sky130_fd_sc_hd__diode_2
XTAP_TAPCELL_ROW_3_350 vssd1 vccd1 sky130_fd_sc_hd__tapvpwrvgnd_1
X_13810_ clknet_leaf_112_clk _00782_ net661 vssd1 vssd1 vccd1 vccd1 cell1.SB0.route_sel\[87\]
+ sky130_fd_sc_hd__dfstp_1
XTAP_TAPCELL_ROW_141_2429 vssd1 vccd1 sky130_fd_sc_hd__tapvpwrvgnd_1
X_10953_ net378 _05905_ _05906_ vssd1 vssd1 vccd1 vccd1 _05907_ sky130_fd_sc_hd__a21oi_1
X_13741_ clknet_leaf_107_clk _00713_ net659 vssd1 vssd1 vccd1 vccd1 cell1.SB0.route_sel\[18\]
+ sky130_fd_sc_hd__dfstp_1
XFILLER_29_785 vssd1 vssd1 vccd1 vccd1 sky130_fd_sc_hd__fill_1
XANTENNA__08330__A2 _02424_ vssd1 vssd1 vccd1 vccd1 sky130_fd_sc_hd__diode_2
X_10884_ cell3.LE_1B.config_data\[8\] cell3.LE_1B.config_data\[9\] net292 vssd1 vssd1
+ vccd1 vccd1 _05840_ sky130_fd_sc_hd__mux2_1
X_13672_ clknet_leaf_14_clk _00644_ net629 vssd1 vssd1 vccd1 vccd1 cell2.CB_1.config_dataA\[24\]
+ sky130_fd_sc_hd__dfstp_1
Xclkbuf_leaf_23_clk clknet_4_4_0_clk vssd1 vssd1 vccd1 vccd1 clknet_leaf_23_clk sky130_fd_sc_hd__clkbuf_8
X_12623_ cell3.SB0.route_sel\[88\] cell3.SB0.route_sel\[87\] net917 vssd1 vssd1 vccd1
+ vccd1 _01052_ sky130_fd_sc_hd__mux2_1
XTAP_TAPCELL_ROW_65_1280 vssd1 vccd1 sky130_fd_sc_hd__tapvpwrvgnd_1
XTAP_TAPCELL_ROW_42_945 vssd1 vccd1 sky130_fd_sc_hd__tapvpwrvgnd_1
XTAP_TAPCELL_ROW_42_934 vssd1 vccd1 sky130_fd_sc_hd__tapvpwrvgnd_1
X_12554_ cell3.SB0.route_sel\[19\] cell3.SB0.route_sel\[18\] net919 vssd1 vssd1 vccd1
+ vccd1 _00983_ sky130_fd_sc_hd__mux2_1
XANTENNA__08094__A1 bus2_0\[1\] vssd1 vssd1 vccd1 vccd1 sky130_fd_sc_hd__diode_2
XFILLER_129_337 vssd1 vssd1 vccd1 vccd1 sky130_fd_sc_hd__fill_1
X_11505_ cell2.SB0.route_sel\[48\] cell2.SB0.route_sel\[49\] vssd1 vssd1 vccd1 vccd1
+ _06337_ sky130_fd_sc_hd__nor2_1
XFILLER_8_645 vccd1 vssd1 vccd1 vssd1 sky130_ef_sc_hd__decap_40_12
XFILLER_7_111 vssd1 vssd1 vccd1 vccd1 sky130_fd_sc_hd__fill_1
X_12485_ net966 net549 _06384_ vssd1 vssd1 vccd1 vccd1 _00914_ sky130_fd_sc_hd__a21bo_1
X_14224_ clknet_leaf_15_clk _01196_ net624 vssd1 vssd1 vccd1 vccd1 cell2.SB0.route_sel\[9\]
+ sky130_fd_sc_hd__dfstp_1
XANTENNA_input71_X net71 vssd1 vssd1 vccd1 vccd1 sky130_fd_sc_hd__diode_2
X_11436_ cell0.SB0.route_sel\[124\] cell0.SB0.route_sel\[125\] vssd1 vssd1 vccd1 vccd1
+ _06291_ sky130_fd_sc_hd__nand2b_1
X_14155_ clknet_leaf_71_clk _01127_ net730 vssd1 vssd1 vccd1 vccd1 cell3.CB_1.config_dataA\[15\]
+ sky130_fd_sc_hd__dfstp_1
XANTENNA__09594__A1 net318 vssd1 vssd1 vccd1 vccd1 sky130_fd_sc_hd__diode_2
X_11367_ cell0.SB0.route_sel\[39\] cell0.SB0.route_sel\[38\] vssd1 vssd1 vccd1 vccd1
+ _06245_ sky130_fd_sc_hd__or2_1
X_10318_ net435 _05148_ _05316_ net433 vssd1 vssd1 vccd1 vccd1 _05317_ sky130_fd_sc_hd__o211a_1
X_14086_ clknet_leaf_78_clk _01058_ net710 vssd1 vssd1 vccd1 vccd1 cell3.SB0.route_sel\[94\]
+ sky130_fd_sc_hd__dfstp_1
X_13106_ clknet_leaf_5_clk _00078_ net566 vssd1 vssd1 vccd1 vccd1 cell0.CB_0.config_dataA\[8\]
+ sky130_fd_sc_hd__dfstp_1
XANTENNA__09346__A1 _04354_ vssd1 vssd1 vccd1 vccd1 sky130_fd_sc_hd__diode_2
X_11298_ _04306_ _06213_ _04310_ vssd1 vssd1 vccd1 vccd1 net143 sky130_fd_sc_hd__a21oi_2
X_13037_ clknet_leaf_120_clk _00009_ net596 vssd1 vssd1 vccd1 vccd1 cell0.LE_1B.config_data\[9\]
+ sky130_fd_sc_hd__dfrtp_1
XANTENNA__11153__A1 net279 vssd1 vssd1 vccd1 vccd1 sky130_fd_sc_hd__diode_2
XFILLER_121_760 vssd1 vssd1 vccd1 vccd1 sky130_fd_sc_hd__fill_1
X_10249_ net412 _05103_ vssd1 vssd1 vccd1 vccd1 _05250_ sky130_fd_sc_hd__nand2_1
XFILLER_78_162 vssd1 vssd1 vccd1 vccd1 sky130_fd_sc_hd__fill_1
XFILLER_67_847 vssd1 vssd1 vccd1 vccd1 sky130_fd_sc_hd__fill_1
XFILLER_94_666 vssd1 vssd1 vccd1 vccd1 sky130_fd_sc_hd__fill_1
XFILLER_19_240 vssd1 vssd1 vccd1 vccd1 sky130_fd_sc_hd__fill_2
XFILLER_81_327 vssd1 vssd1 vccd1 vccd1 sky130_fd_sc_hd__fill_1
XANTENNA_clkbuf_leaf_62_clk_A clknet_4_15_0_clk vssd1 vssd1 vccd1 vccd1 sky130_fd_sc_hd__diode_2
X_13939_ clknet_leaf_43_clk _00911_ net635 vssd1 vssd1 vccd1 vccd1 cell2.LE_0A.reset_val
+ sky130_fd_sc_hd__dfrtp_1
X_07460_ cell1.SB0.route_sel\[113\] cell1.SB0.route_sel\[112\] _02513_ vssd1 vssd1
+ vccd1 vccd1 _02514_ sky130_fd_sc_hd__a21oi_1
X_06411_ cell0.SB0.route_sel\[107\] vssd1 vssd1 vccd1 vccd1 _01481_ sky130_fd_sc_hd__inv_2
X_07391_ _02444_ _02446_ vssd1 vssd1 vccd1 vccd1 bus1_0\[13\] sky130_fd_sc_hd__and2b_2
Xclkbuf_leaf_14_clk clknet_4_3_0_clk vssd1 vssd1 vccd1 vccd1 clknet_leaf_14_clk sky130_fd_sc_hd__clkbuf_8
X_09130_ cell1.CB_0.config_dataB\[18\] _04130_ cell1.CB_0.config_dataB\[17\] cell1.CB_0.config_dataB\[19\]
+ vssd1 vssd1 vccd1 vccd1 _04160_ sky130_fd_sc_hd__or4b_1
XANTENNA__08085__B2 _02890_ vssd1 vssd1 vccd1 vccd1 sky130_fd_sc_hd__diode_2
XTAP_TAPCELL_ROW_20_606 vssd1 vccd1 sky130_fd_sc_hd__tapvpwrvgnd_1
XANTENNA_clkbuf_leaf_77_clk_A clknet_4_14_0_clk vssd1 vssd1 vccd1 vccd1 sky130_fd_sc_hd__diode_2
X_09061_ net478 net480 vssd1 vssd1 vccd1 vccd1 _04091_ sky130_fd_sc_hd__and2b_1
X_08012_ cell0.CB_0.config_dataB\[9\] _03030_ vssd1 vssd1 vccd1 vccd1 _03054_ sky130_fd_sc_hd__nand2_1
XANTENNA_clkbuf_leaf_120_clk_A clknet_4_3_0_clk vssd1 vssd1 vccd1 vccd1 sky130_fd_sc_hd__diode_2
XPHY_EDGE_ROW_7_Left_150 vssd1 vssd1 vccd1 vccd1 sky130_fd_sc_hd__decap_3
XFILLER_128_381 vssd1 vssd1 vccd1 vccd1 sky130_fd_sc_hd__fill_1
XTAP_TAPCELL_ROW_96_1752 vssd1 vccd1 sky130_fd_sc_hd__tapvpwrvgnd_1
XTAP_TAPCELL_ROW_96_1741 vssd1 vccd1 sky130_fd_sc_hd__tapvpwrvgnd_1
XANTENNA__08388__A2 bus1_0\[14\] vssd1 vssd1 vccd1 vccd1 sky130_fd_sc_hd__diode_2
XFILLER_116_598 vssd1 vssd1 vccd1 vccd1 sky130_fd_sc_hd__fill_8
XFILLER_116_587 vssd1 vssd1 vccd1 vccd1 sky130_fd_sc_hd__fill_1
X_09963_ net406 _04472_ _04966_ net405 vssd1 vssd1 vccd1 vccd1 _04967_ sky130_fd_sc_hd__o211a_1
XPHY_EDGE_ROW_4_Right_4 vssd1 vssd1 vccd1 vccd1 sky130_fd_sc_hd__decap_3
X_08914_ bus3_1\[6\] bus3_1\[7\] net468 vssd1 vssd1 vccd1 vccd1 _03946_ sky130_fd_sc_hd__mux2_1
XFILLER_134_27 vssd1 vssd1 vccd1 vccd1 sky130_fd_sc_hd__fill_1
XANTENNA__11144__B2 net46 vssd1 vssd1 vccd1 vccd1 sky130_fd_sc_hd__diode_2
XANTENNA__11144__A1 net45 vssd1 vssd1 vccd1 vccd1 sky130_fd_sc_hd__diode_2
X_09894_ _04445_ _04875_ vssd1 vssd1 vccd1 vccd1 _04900_ sky130_fd_sc_hd__nand2_1
XFILLER_85_611 vssd1 vssd1 vccd1 vccd1 sky130_fd_sc_hd__fill_2
XANTENNA_clkbuf_leaf_15_clk_A clknet_4_6_0_clk vssd1 vssd1 vccd1 vccd1 sky130_fd_sc_hd__diode_2
X_08845_ bus3_1\[0\] bus3_1\[1\] bus3_1\[2\] bus3_1\[3\] net471 net469 vssd1 vssd1
+ vccd1 vccd1 _03877_ sky130_fd_sc_hd__mux4_1
XANTENNA_fanout568_A net575 vssd1 vssd1 vccd1 vccd1 sky130_fd_sc_hd__diode_2
X_08776_ _03808_ _03809_ _03702_ vssd1 vssd1 vccd1 vccd1 _03810_ sky130_fd_sc_hd__mux2_1
X_07727_ _02773_ vssd1 vssd1 vccd1 vccd1 _02774_ sky130_fd_sc_hd__inv_2
XTAP_TAPCELL_ROW_28_728 vssd1 vccd1 sky130_fd_sc_hd__tapvpwrvgnd_1
XANTENNA_fanout735_A net742 vssd1 vssd1 vccd1 vccd1 sky130_fd_sc_hd__diode_2
XTAP_TAPCELL_ROW_123_2159 vssd1 vccd1 sky130_fd_sc_hd__tapvpwrvgnd_1
XTAP_TAPCELL_ROW_123_2148 vssd1 vccd1 sky130_fd_sc_hd__tapvpwrvgnd_1
X_07658_ cell0.SB0.route_sel\[20\] cell0.SB0.route_sel\[21\] vssd1 vssd1 vccd1 vccd1
+ _02706_ sky130_fd_sc_hd__nand2_1
XTAP_TAPCELL_ROW_105_1881 vssd1 vccd1 sky130_fd_sc_hd__tapvpwrvgnd_1
X_06609_ cell1.CB_0.config_dataA\[7\] vssd1 vssd1 vccd1 vccd1 _01679_ sky130_fd_sc_hd__inv_2
XANTENNA_fanout902_A net907 vssd1 vssd1 vccd1 vccd1 sky130_fd_sc_hd__diode_2
XFILLER_13_449 vssd1 vssd1 vccd1 vccd1 sky130_fd_sc_hd__fill_1
X_07589_ net449 net450 _02046_ vssd1 vssd1 vccd1 vccd1 _02639_ sky130_fd_sc_hd__or3_1
XANTENNA__11480__Y net219 vssd1 vssd1 vccd1 vccd1 sky130_fd_sc_hd__diode_2
Xclkbuf_4_8_0_clk clknet_0_clk vssd1 vssd1 vccd1 vccd1 clknet_4_8_0_clk sky130_fd_sc_hd__clkbuf_8
XANTENNA__10818__A _05513_ vssd1 vssd1 vccd1 vccd1 sky130_fd_sc_hd__diode_2
X_09328_ cell3.SB0.route_sel\[27\] cell3.SB0.route_sel\[26\] vssd1 vssd1 vccd1 vccd1
+ _04353_ sky130_fd_sc_hd__nand2_1
XANTENNA__08076__A1 net346 vssd1 vssd1 vccd1 vccd1 sky130_fd_sc_hd__diode_2
XTAP_TAPCELL_ROW_138_2380 vssd1 vccd1 sky130_fd_sc_hd__tapvpwrvgnd_1
X_09259_ _02712_ _02716_ _02893_ _02713_ vssd1 vssd1 vccd1 vccd1 _04285_ sky130_fd_sc_hd__a31o_1
XFILLER_111_3 vccd1 vssd1 vccd1 vssd1 sky130_ef_sc_hd__decap_40_12
XFILLER_107_510 vssd1 vssd1 vccd1 vccd1 sky130_fd_sc_hd__fill_1
XFILLER_5_615 vssd1 vssd1 vccd1 vccd1 sky130_fd_sc_hd__fill_1
X_12270_ cell1.SB0.route_sel\[8\] cell1.SB0.route_sel\[7\] net866 vssd1 vssd1 vccd1
+ vccd1 _00703_ sky130_fd_sc_hd__mux2_1
XFILLER_135_841 vssd1 vssd1 vccd1 vccd1 sky130_fd_sc_hd__fill_1
X_11221_ _06172_ vssd1 vssd1 vccd1 vccd1 _06173_ sky130_fd_sc_hd__inv_2
X_11152_ _06102_ _06103_ _06093_ _06100_ vssd1 vssd1 vccd1 vccd1 _06104_ sky130_fd_sc_hd__o211a_1
XANTENNA__10186__A2 _05088_ vssd1 vssd1 vccd1 vccd1 sky130_fd_sc_hd__diode_2
XANTENNA__09040__A3 bus3_1\[11\] vssd1 vssd1 vccd1 vccd1 sky130_fd_sc_hd__diode_2
XANTENNA__12580__A0 cell3.SB0.route_sel\[45\] vssd1 vssd1 vccd1 vccd1 sky130_fd_sc_hd__diode_2
XFILLER_4_29 vccd1 vssd1 vccd1 vssd1 sky130_ef_sc_hd__decap_40_12
X_10103_ net419 _05103_ vssd1 vssd1 vccd1 vccd1 _05104_ sky130_fd_sc_hd__nand2_1
XFILLER_108_94 vssd1 vssd1 vccd1 vccd1 sky130_fd_sc_hd__fill_1
XTAP_TAPCELL_ROW_8_431 vssd1 vccd1 sky130_fd_sc_hd__tapvpwrvgnd_1
XFILLER_0_320 vssd1 vssd1 vccd1 vccd1 sky130_fd_sc_hd__fill_2
X_11083_ cell3.LE_0A.config_data\[6\] cell3.LE_0A.config_data\[7\] _05930_ vssd1 vssd1
+ vccd1 vccd1 _06037_ sky130_fd_sc_hd__mux2_1
XANTENNA__11135__A1 _05871_ vssd1 vssd1 vccd1 vccd1 sky130_fd_sc_hd__diode_2
XANTENNA_input31_A CBeast_in[8] vssd1 vssd1 vccd1 vccd1 sky130_fd_sc_hd__diode_2
X_10034_ net400 _04583_ vssd1 vssd1 vccd1 vccd1 _05038_ sky130_fd_sc_hd__or2_1
XFILLER_76_633 vssd1 vssd1 vccd1 vccd1 sky130_fd_sc_hd__fill_2
XANTENNA__08000__B2 _02890_ vssd1 vssd1 vccd1 vccd1 sky130_fd_sc_hd__diode_2
XFILLER_124_71 vssd1 vssd1 vccd1 vccd1 sky130_fd_sc_hd__fill_1
XANTENNA__08677__B _03465_ vssd1 vssd1 vccd1 vccd1 sky130_fd_sc_hd__diode_2
XANTENNA__10646__A0 net21 vssd1 vssd1 vccd1 vccd1 sky130_fd_sc_hd__diode_2
XFILLER_91_658 vssd1 vssd1 vccd1 vccd1 sky130_fd_sc_hd__fill_8
XTAP_TAPCELL_ROW_67_1320 vssd1 vccd1 sky130_fd_sc_hd__tapvpwrvgnd_1
X_11985_ cell0.SB0.route_sel\[91\] cell0.SB0.route_sel\[90\] net791 vssd1 vssd1 vccd1
+ vccd1 _00422_ sky130_fd_sc_hd__mux2_1
X_10936_ _05889_ _04521_ vssd1 vssd1 vccd1 vccd1 _05890_ sky130_fd_sc_hd__nand2b_4
X_13724_ clknet_leaf_105_clk _00696_ net660 vssd1 vssd1 vccd1 vccd1 cell1.SB0.route_sel\[1\]
+ sky130_fd_sc_hd__dfstp_1
XFILLER_32_714 vssd1 vssd1 vccd1 vccd1 sky130_fd_sc_hd__fill_1
XFILLER_140_81 vssd1 vssd1 vccd1 vccd1 sky130_fd_sc_hd__fill_2
X_13655_ clknet_leaf_53_clk _00627_ net714 vssd1 vssd1 vccd1 vccd1 cell2.CB_1.config_dataA\[7\]
+ sky130_fd_sc_hd__dfstp_2
X_10867_ _05821_ _05822_ _05812_ _05819_ vssd1 vssd1 vccd1 vccd1 _05823_ sky130_fd_sc_hd__o211a_1
XANTENNA__09853__A1_N _04399_ vssd1 vssd1 vccd1 vccd1 sky130_fd_sc_hd__diode_2
X_12606_ cell3.SB0.route_sel\[71\] cell3.SB0.route_sel\[70\] net909 vssd1 vssd1 vccd1
+ vccd1 _01035_ sky130_fd_sc_hd__mux2_1
X_10798_ cell3.LEI0.config_data\[22\] _05753_ vssd1 vssd1 vccd1 vccd1 _05754_ sky130_fd_sc_hd__nor2_1
XANTENNA__09803__A2 bus3_2\[1\] vssd1 vssd1 vccd1 vccd1 sky130_fd_sc_hd__diode_2
X_13586_ clknet_leaf_95_clk _00558_ net692 vssd1 vssd1 vccd1 vccd1 cell1.LEI0.config_data\[7\]
+ sky130_fd_sc_hd__dfrtp_1
XANTENNA__08606__A3 _03498_ vssd1 vssd1 vccd1 vccd1 sky130_fd_sc_hd__diode_2
X_12537_ cell3.SB0.route_sel\[2\] cell3.SB0.route_sel\[1\] net935 vssd1 vssd1 vccd1
+ vccd1 _00966_ sky130_fd_sc_hd__mux2_1
X_12468_ net1043 net1055 net813 vssd1 vssd1 vccd1 vccd1 _00898_ sky130_fd_sc_hd__mux2_1
XFILLER_8_475 vssd1 vssd1 vccd1 vccd1 sky130_fd_sc_hd__fill_1
X_14207_ clknet_leaf_56_clk _01179_ net719 vssd1 vssd1 vccd1 vccd1 cell3.CB_0.config_dataA\[17\]
+ sky130_fd_sc_hd__dfstp_1
XTAP_TAPCELL_ROW_78_1482 vssd1 vccd1 sky130_fd_sc_hd__tapvpwrvgnd_1
XTAP_TAPCELL_ROW_78_1471 vssd1 vccd1 sky130_fd_sc_hd__tapvpwrvgnd_1
X_11419_ cell0.SB0.route_sel\[101\] _01477_ _01478_ cell0.SB0.route_sel\[98\] _06279_
+ vssd1 vssd1 vccd1 vccd1 _06280_ sky130_fd_sc_hd__a221o_1
XFILLER_141_833 vssd1 vssd1 vccd1 vccd1 sky130_fd_sc_hd__fill_4
X_14138_ clknet_leaf_66_clk _01110_ net746 vssd1 vssd1 vccd1 vccd1 cell3.LE_1B.reset_val
+ sky130_fd_sc_hd__dfrtp_1
X_12399_ cell2.CB_1.config_dataB\[9\] cell2.CB_1.config_dataB\[8\] net848 vssd1 vssd1
+ vccd1 vccd1 _00832_ sky130_fd_sc_hd__mux2_1
XFILLER_4_681 vccd1 vssd1 vccd1 vssd1 sky130_ef_sc_hd__decap_40_12
XTAP_TAPCELL_ROW_91_1671 vssd1 vccd1 sky130_fd_sc_hd__tapvpwrvgnd_1
XFILLER_86_419 vssd1 vssd1 vccd1 vccd1 sky130_fd_sc_hd__fill_1
X_14069_ clknet_leaf_46_clk _01041_ net629 vssd1 vssd1 vccd1 vccd1 cell3.SB0.route_sel\[77\]
+ sky130_fd_sc_hd__dfstp_1
XANTENNA__08790__A2 _03817_ vssd1 vssd1 vccd1 vccd1 sky130_fd_sc_hd__diode_2
X_06960_ cell0.CB_0.config_dataA\[24\] cell0.CB_0.config_dataA\[20\] cell0.CB_0.config_dataA\[21\]
+ vssd1 vssd1 vccd1 vccd1 _02026_ sky130_fd_sc_hd__or3_2
Xclkbuf_leaf_3_clk clknet_4_1_0_clk vssd1 vssd1 vccd1 vccd1 clknet_leaf_3_clk sky130_fd_sc_hd__clkbuf_8
XFILLER_39_335 vssd1 vssd1 vccd1 vccd1 sky130_fd_sc_hd__fill_1
X_06891_ cell1.SB0.route_sel\[62\] cell1.SB0.route_sel\[63\] _01935_ _01958_ vssd1
+ vssd1 vccd1 vccd1 _01959_ sky130_fd_sc_hd__a211oi_1
X_08630_ _03653_ _03661_ _03665_ _03657_ _03622_ vssd1 vssd1 vccd1 vccd1 _03666_ sky130_fd_sc_hd__o32a_1
XFILLER_81_113 vssd1 vssd1 vccd1 vccd1 sky130_fd_sc_hd__fill_2
XANTENNA__08079__S _03087_ vssd1 vssd1 vccd1 vccd1 sky130_fd_sc_hd__diode_2
XANTENNA__13282__Q cell1.LE_1B.reset_val vssd1 vssd1 vccd1 vccd1 sky130_fd_sc_hd__diode_2
X_08561_ net491 _03509_ vssd1 vssd1 vccd1 vccd1 _03597_ sky130_fd_sc_hd__nand2_1
XFILLER_120_29 vccd1 vssd1 vccd1 vssd1 sky130_ef_sc_hd__decap_40_12
XANTENNA__10101__A2 cell2.SB0.config_data_out vssd1 vssd1 vccd1 vccd1 sky130_fd_sc_hd__diode_2
X_08492_ cell1.SB0.route_sel\[56\] _01521_ _01524_ cell1.SB0.route_sel\[63\] vssd1
+ vssd1 vccd1 vccd1 _03528_ sky130_fd_sc_hd__o22a_1
X_07512_ _02541_ _02561_ _02563_ vssd1 vssd1 vccd1 vccd1 _02564_ sky130_fd_sc_hd__o21ai_1
XANTENNA__08845__A3 bus3_1\[3\] vssd1 vssd1 vccd1 vccd1 sky130_fd_sc_hd__diode_2
X_07443_ cell1.SB0.route_sel\[117\] cell1.SB0.route_sel\[116\] vssd1 vssd1 vccd1 vccd1
+ _02497_ sky130_fd_sc_hd__nand2_1
XFILLER_50_555 vssd1 vssd1 vccd1 vccd1 sky130_fd_sc_hd__fill_1
XFILLER_10_408 vssd1 vssd1 vccd1 vccd1 sky130_fd_sc_hd__fill_1
X_09113_ _04141_ _04142_ cell1.CB_0.config_dataB\[17\] vssd1 vssd1 vccd1 vccd1 _04143_
+ sky130_fd_sc_hd__or3b_1
X_07374_ cell1.SB0.route_sel\[106\] cell1.SB0.route_sel\[107\] vssd1 vssd1 vccd1 vccd1
+ _02430_ sky130_fd_sc_hd__and2_1
XFILLER_13_27 vccd1 vssd1 vccd1 vssd1 sky130_ef_sc_hd__decap_40_12
XTAP_TAPCELL_ROW_33_797 vssd1 vccd1 sky130_fd_sc_hd__tapvpwrvgnd_1
XFILLER_129_27 vccd1 vssd1 vccd1 vssd1 sky130_ef_sc_hd__decap_40_12
XANTENNA__10925__X _05879_ vssd1 vssd1 vccd1 vccd1 sky130_fd_sc_hd__diode_2
X_09044_ net485 _03841_ vssd1 vssd1 vccd1 vccd1 _04074_ sky130_fd_sc_hd__or2_1
XFILLER_117_841 vssd1 vssd1 vccd1 vccd1 sky130_fd_sc_hd__fill_1
Xhold420 cell0.LE_0A.dff1_out vssd1 vssd1 vccd1 vccd1 net1379 sky130_fd_sc_hd__dlygate4sd3_1
XFILLER_132_811 vssd1 vssd1 vccd1 vccd1 sky130_fd_sc_hd__fill_1
Xhold442 cell3.LEI0.config_data\[18\] vssd1 vssd1 vccd1 vccd1 net1401 sky130_fd_sc_hd__dlygate4sd3_1
Xhold431 _01427_ vssd1 vssd1 vccd1 vccd1 net1390 sky130_fd_sc_hd__dlygate4sd3_1
Xhold453 cell0.LE_1A.config_data\[2\] vssd1 vssd1 vccd1 vccd1 net1412 sky130_fd_sc_hd__dlygate4sd3_1
Xhold475 _01420_ vssd1 vssd1 vccd1 vccd1 net1434 sky130_fd_sc_hd__dlygate4sd3_1
Xhold464 cell0.LEI0.config_data\[0\] vssd1 vssd1 vccd1 vccd1 net1423 sky130_fd_sc_hd__dlygate4sd3_1
Xfanout900 net907 vssd1 vssd1 vccd1 vccd1 net900 sky130_fd_sc_hd__clkbuf_2
Xhold486 cell0.LEI0.config_data\[35\] vssd1 vssd1 vccd1 vccd1 net1445 sky130_fd_sc_hd__dlygate4sd3_1
XANTENNA_fanout685_A net691 vssd1 vssd1 vccd1 vccd1 sky130_fd_sc_hd__diode_2
Xfanout933 net934 vssd1 vssd1 vccd1 vccd1 net933 sky130_fd_sc_hd__clkbuf_4
XANTENNA__11117__A1 _04354_ vssd1 vssd1 vccd1 vccd1 sky130_fd_sc_hd__diode_2
Xfanout922 net923 vssd1 vssd1 vccd1 vccd1 net922 sky130_fd_sc_hd__clkbuf_4
X_09946_ _04527_ _04923_ _04924_ _04555_ vssd1 vssd1 vccd1 vccd1 _04950_ sky130_fd_sc_hd__a2bb2o_1
Xfanout911 net912 vssd1 vssd1 vccd1 vccd1 net911 sky130_fd_sc_hd__clkbuf_2
Xhold497 cell0.LE_1A.dff1_out vssd1 vssd1 vccd1 vccd1 net1456 sky130_fd_sc_hd__dlygate4sd3_1
Xfanout955 net956 vssd1 vssd1 vccd1 vccd1 net955 sky130_fd_sc_hd__clkbuf_2
Xfanout944 net959 vssd1 vssd1 vccd1 vccd1 net944 sky130_fd_sc_hd__clkbuf_2
XANTENNA_fanout852_A net854 vssd1 vssd1 vccd1 vccd1 sky130_fd_sc_hd__diode_2
XANTENNA__07336__A3 _02391_ vssd1 vssd1 vccd1 vccd1 sky130_fd_sc_hd__diode_2
XANTENNA__06569__Y _01639_ vssd1 vssd1 vccd1 vccd1 sky130_fd_sc_hd__diode_2
XFILLER_97_290 vssd1 vssd1 vccd1 vccd1 sky130_fd_sc_hd__fill_1
X_09877_ net438 _04724_ vssd1 vssd1 vccd1 vccd1 _04883_ sky130_fd_sc_hd__nand2_1
XANTENNA__08533__A2 net2 vssd1 vssd1 vccd1 vccd1 sky130_fd_sc_hd__diode_2
XTAP_TAPCELL_ROW_107_1910 vssd1 vccd1 sky130_fd_sc_hd__tapvpwrvgnd_1
XFILLER_85_463 vssd1 vssd1 vccd1 vccd1 sky130_fd_sc_hd__fill_4
XPHY_EDGE_ROW_79_Right_79 vssd1 vssd1 vccd1 vccd1 sky130_fd_sc_hd__decap_3
X_08828_ cell1.SB0.route_sel\[26\] cell1.SB0.route_sel\[27\] cell1.SB0.route_sel\[29\]
+ _01510_ _03859_ vssd1 vssd1 vccd1 vccd1 _03860_ sky130_fd_sc_hd__o221a_1
XANTENNA_fanout640_X net640 vssd1 vssd1 vccd1 vccd1 sky130_fd_sc_hd__diode_2
X_08759_ net452 _03533_ _03792_ cell1.CB_1.config_dataB\[16\] vssd1 vssd1 vccd1 vccd1
+ _03793_ sky130_fd_sc_hd__o211a_1
XANTENNA__10628__A0 net15 vssd1 vssd1 vccd1 vccd1 sky130_fd_sc_hd__diode_2
XFILLER_72_157 vssd1 vssd1 vccd1 vccd1 sky130_fd_sc_hd__fill_4
XTAP_TAPCELL_ROW_49_1050 vssd1 vccd1 sky130_fd_sc_hd__tapvpwrvgnd_1
X_11770_ net990 net1286 net792 vssd1 vssd1 vccd1 vccd1 _00207_ sky130_fd_sc_hd__mux2_1
XFILLER_41_500 vssd1 vssd1 vccd1 vccd1 sky130_fd_sc_hd__fill_1
X_10721_ cell3.CB_1.config_dataA\[4\] _05596_ _05599_ cell3.LE_1A.config_data\[12\]
+ vssd1 vssd1 vccd1 vccd1 _05679_ sky130_fd_sc_hd__o211a_1
XANTENNA_fanout905_X net905 vssd1 vssd1 vccd1 vccd1 sky130_fd_sc_hd__diode_2
X_13440_ clknet_leaf_130_clk _00412_ net578 vssd1 vssd1 vccd1 vccd1 cell0.SB0.route_sel\[81\]
+ sky130_fd_sc_hd__dfstp_2
X_10652_ cell3.CB_1.config_dataA\[11\] _05606_ _05609_ vssd1 vssd1 vccd1 vccd1 _05610_
+ sky130_fd_sc_hd__a21o_1
X_10583_ _01734_ cell3.SB0.route_sel\[94\] vssd1 vssd1 vccd1 vccd1 _05541_ sky130_fd_sc_hd__nand2_1
X_13371_ clknet_leaf_127_clk _00343_ net576 vssd1 vssd1 vccd1 vccd1 cell0.SB0.route_sel\[12\]
+ sky130_fd_sc_hd__dfstp_1
XPHY_EDGE_ROW_88_Right_88 vssd1 vssd1 vccd1 vccd1 sky130_fd_sc_hd__decap_3
XANTENNA__06761__A net327 vssd1 vssd1 vccd1 vccd1 sky130_fd_sc_hd__diode_2
X_12322_ cell1.SB0.route_sel\[60\] cell1.SB0.route_sel\[59\] net856 vssd1 vssd1 vccd1
+ vccd1 _00755_ sky130_fd_sc_hd__mux2_1
XTAP_TAPCELL_ROW_11_469 vssd1 vccd1 sky130_fd_sc_hd__tapvpwrvgnd_1
X_12253_ net411 net413 net823 vssd1 vssd1 vccd1 vccd1 _00686_ sky130_fd_sc_hd__mux2_1
XANTENNA_input79_A SBsouth_in[22] vssd1 vssd1 vccd1 vccd1 sky130_fd_sc_hd__diode_2
X_11204_ net42 net43 cell3.CB_0.config_dataB\[15\] vssd1 vssd1 vccd1 vccd1 _06156_
+ sky130_fd_sc_hd__mux2_1
X_12184_ cell2.LE_1B.edge_mode cell2.LE_1B.config_data\[16\] net851 vssd1 vssd1 vccd1
+ vccd1 _00617_ sky130_fd_sc_hd__mux2_1
XPHY_EDGE_ROW_79_Left_222 vssd1 vssd1 vccd1 vccd1 sky130_fd_sc_hd__decap_3
XANTENNA__08221__A1 net346 vssd1 vssd1 vccd1 vccd1 sky130_fd_sc_hd__diode_2
X_11135_ _05874_ _05871_ net387 vssd1 vssd1 vccd1 vccd1 _06087_ sky130_fd_sc_hd__mux2_1
XFILLER_122_343 vssd1 vssd1 vccd1 vccd1 sky130_fd_sc_hd__fill_1
XFILLER_110_516 vssd1 vssd1 vccd1 vccd1 sky130_fd_sc_hd__fill_1
XANTENNA_input34_X net34 vssd1 vssd1 vccd1 vccd1 sky130_fd_sc_hd__diode_2
XFILLER_135_81 vssd1 vssd1 vccd1 vccd1 sky130_fd_sc_hd__fill_8
X_11066_ _05924_ _05998_ vssd1 vssd1 vccd1 vccd1 _06020_ sky130_fd_sc_hd__nor2_1
XFILLER_1_673 vccd1 vssd1 vccd1 vssd1 sky130_ef_sc_hd__decap_40_12
XANTENNA__06783__A1 net339 vssd1 vssd1 vccd1 vccd1 sky130_fd_sc_hd__diode_2
X_10017_ _04399_ _04998_ cell2.CB_1.config_dataB\[12\] vssd1 vssd1 vccd1 vccd1 _05021_
+ sky130_fd_sc_hd__o21ai_1
XANTENNA_output235_A net235 vssd1 vssd1 vccd1 vccd1 sky130_fd_sc_hd__diode_2
XPHY_EDGE_ROW_97_Right_97 vssd1 vssd1 vccd1 vccd1 sky130_fd_sc_hd__decap_3
XANTENNA__08524__A2 _03533_ vssd1 vssd1 vccd1 vccd1 sky130_fd_sc_hd__diode_2
XANTENNA__07732__B1 _02778_ vssd1 vssd1 vccd1 vccd1 sky130_fd_sc_hd__diode_2
XANTENNA__10619__B1 _05576_ vssd1 vssd1 vccd1 vccd1 sky130_fd_sc_hd__diode_2
XANTENNA__08627__S _03546_ vssd1 vssd1 vccd1 vccd1 sky130_fd_sc_hd__diode_2
XFILLER_32_500 vssd1 vssd1 vccd1 vccd1 sky130_fd_sc_hd__fill_1
X_13707_ clknet_leaf_28_clk _00679_ net617 vssd1 vssd1 vccd1 vccd1 cell2.CB_0.config_dataA\[9\]
+ sky130_fd_sc_hd__dfstp_1
XANTENNA__09792__A1_N _04671_ vssd1 vssd1 vccd1 vccd1 sky130_fd_sc_hd__diode_2
XPHY_EDGE_ROW_88_Left_231 vssd1 vssd1 vccd1 vccd1 sky130_fd_sc_hd__decap_3
X_11968_ cell0.SB0.route_sel\[74\] cell0.SB0.route_sel\[73\] net766 vssd1 vssd1 vccd1
+ vccd1 _00405_ sky130_fd_sc_hd__mux2_1
X_10919_ cell3.SB0.route_sel\[83\] cell3.SB0.route_sel\[82\] _01730_ cell3.SB0.route_sel\[86\]
+ _05872_ vssd1 vssd1 vccd1 vccd1 _05873_ sky130_fd_sc_hd__o221a_1
X_11899_ cell0.SB0.route_sel\[5\] cell0.SB0.route_sel\[4\] net781 vssd1 vssd1 vccd1
+ vccd1 _00336_ sky130_fd_sc_hd__mux2_1
X_13638_ clknet_leaf_38_clk _00610_ net648 vssd1 vssd1 vccd1 vccd1 cell2.LE_1B.config_data\[10\]
+ sky130_fd_sc_hd__dfrtp_1
X_13569_ clknet_leaf_118_clk _00541_ net668 vssd1 vssd1 vccd1 vccd1 cell1.LE_0A.config_data\[12\]
+ sky130_fd_sc_hd__dfrtp_1
XTAP_TAPCELL_ROW_30_756 vssd1 vccd1 sky130_fd_sc_hd__tapvpwrvgnd_1
XANTENNA__10398__A2 _05128_ vssd1 vssd1 vccd1 vccd1 sky130_fd_sc_hd__diode_2
X_07090_ _02063_ _02153_ vssd1 vssd1 vccd1 vccd1 _02154_ sky130_fd_sc_hd__or2_1
XTAP_TAPCELL_ROW_93_1700 vssd1 vccd1 sky130_fd_sc_hd__tapvpwrvgnd_1
XFILLER_114_811 vssd1 vssd1 vccd1 vccd1 sky130_fd_sc_hd__fill_1
XPHY_EDGE_ROW_97_Left_240 vssd1 vssd1 vccd1 vccd1 sky130_fd_sc_hd__decap_3
XANTENNA__13277__Q cell1.LE_1B.config_data\[13\] vssd1 vssd1 vccd1 vccd1 sky130_fd_sc_hd__diode_2
XANTENNA__08212__A1 _02846_ vssd1 vssd1 vccd1 vccd1 sky130_fd_sc_hd__diode_2
XANTENNA__08212__B2 _02807_ vssd1 vssd1 vccd1 vccd1 sky130_fd_sc_hd__diode_2
XANTENNA__09960__A1 bus3_2\[4\] vssd1 vssd1 vccd1 vccd1 sky130_fd_sc_hd__diode_2
XANTENNA__09960__B2 bus3_2\[5\] vssd1 vssd1 vccd1 vccd1 sky130_fd_sc_hd__diode_2
X_09800_ _04804_ _04795_ cell2.CB_1.config_dataA\[2\] vssd1 vssd1 vccd1 vccd1 _04806_
+ sky130_fd_sc_hd__mux2_1
XFILLER_87_717 vssd1 vssd1 vccd1 vccd1 sky130_fd_sc_hd__fill_2
XANTENNA__08869__Y _03901_ vssd1 vssd1 vccd1 vccd1 sky130_fd_sc_hd__diode_2
X_07992_ _02074_ _03029_ _03030_ _02172_ cell0.CB_0.config_dataB\[7\] vssd1 vssd1
+ vccd1 vccd1 _03034_ sky130_fd_sc_hd__a221o_1
XFILLER_101_549 vssd1 vssd1 vccd1 vccd1 sky130_fd_sc_hd__fill_1
X_06943_ _01616_ cell2.SB0.route_sel\[58\] cell2.SB0.route_sel\[62\] cell2.SB0.route_sel\[63\]
+ _02009_ vssd1 vssd1 vccd1 vccd1 _02010_ sky130_fd_sc_hd__o221a_1
X_09731_ cell2.SB0.route_sel\[3\] _01565_ vssd1 vssd1 vccd1 vccd1 _04743_ sky130_fd_sc_hd__nand2_1
XANTENNA__11228__S _06076_ vssd1 vssd1 vccd1 vccd1 sky130_fd_sc_hd__diode_2
XANTENNA__10858__A0 net15 vssd1 vssd1 vccd1 vccd1 sky130_fd_sc_hd__diode_2
X_09662_ cell3.SB0.route_sel\[104\] cell3.SB0.route_sel\[105\] vssd1 vssd1 vccd1 vccd1
+ _04677_ sky130_fd_sc_hd__and2_1
XFILLER_39_176 vssd1 vssd1 vccd1 vccd1 sky130_fd_sc_hd__fill_1
X_06874_ _01941_ _01937_ _01938_ vssd1 vssd1 vccd1 vccd1 _01942_ sky130_fd_sc_hd__mux2_1
XFILLER_27_305 vssd1 vssd1 vccd1 vccd1 sky130_fd_sc_hd__fill_1
XFILLER_131_39 vccd1 vssd1 vccd1 vssd1 sky130_ef_sc_hd__decap_40_12
X_09593_ cell3.SB0.route_sel\[95\] cell3.SB0.route_sel\[94\] vssd1 vssd1 vccd1 vccd1
+ _04610_ sky130_fd_sc_hd__nand2_1
X_08613_ cell1.CB_1.config_dataA\[19\] _03636_ vssd1 vssd1 vccd1 vccd1 _03649_ sky130_fd_sc_hd__nor2_1
XTAP_TAPCELL_ROW_120_2107 vssd1 vccd1 sky130_fd_sc_hd__tapvpwrvgnd_1
X_08544_ cell1.LEI0.config_data\[18\] _01821_ _03579_ cell1.LEI0.config_data\[19\]
+ vssd1 vssd1 vccd1 vccd1 _03580_ sky130_fd_sc_hd__o211a_1
XTAP_TAPCELL_ROW_38_878 vssd1 vccd1 sky130_fd_sc_hd__tapvpwrvgnd_1
XANTENNA__11283__B1 _05103_ vssd1 vssd1 vccd1 vccd1 sky130_fd_sc_hd__diode_2
XANTENNA__09222__A net317 vssd1 vssd1 vccd1 vccd1 sky130_fd_sc_hd__diode_2
XTAP_TAPCELL_ROW_18_580 vssd1 vccd1 sky130_fd_sc_hd__tapvpwrvgnd_1
XTAP_TAPCELL_ROW_102_1840 vssd1 vccd1 sky130_fd_sc_hd__tapvpwrvgnd_1
XFILLER_11_706 vccd1 vssd1 vccd1 vssd1 sky130_ef_sc_hd__decap_40_12
XFILLER_23_566 vssd1 vssd1 vccd1 vccd1 sky130_fd_sc_hd__fill_4
X_08475_ net497 _03509_ vssd1 vssd1 vccd1 vccd1 _03511_ sky130_fd_sc_hd__nand2_1
X_07426_ cell0.SB0.route_sel\[117\] cell0.SB0.route_sel\[116\] vssd1 vssd1 vccd1 vccd1
+ _02480_ sky130_fd_sc_hd__nand2_1
XANTENNA_fanout600_A net601 vssd1 vssd1 vccd1 vccd1 sky130_fd_sc_hd__diode_2
X_07357_ cell0.SB0.route_sel\[109\] cell0.SB0.route_sel\[108\] net101 _02411_ _02410_
+ vssd1 vssd1 vccd1 vccd1 _02413_ sky130_fd_sc_hd__a41o_1
XANTENNA__07254__A2 _02311_ vssd1 vssd1 vccd1 vccd1 sky130_fd_sc_hd__diode_2
X_09027_ bus3_1\[0\] bus3_1\[1\] bus3_1\[2\] bus3_1\[3\] net486 net484 vssd1 vssd1
+ vccd1 vccd1 _04057_ sky130_fd_sc_hd__mux4_1
X_07288_ cell0.SB0.route_sel\[96\] cell0.SB0.route_sel\[97\] _02335_ _02345_ net785
+ vssd1 vssd1 vccd1 vccd1 _02346_ sky130_fd_sc_hd__a311oi_4
XFILLER_136_479 vssd1 vssd1 vccd1 vccd1 sky130_fd_sc_hd__fill_1
XTAP_TAPCELL_ROW_131_2269 vssd1 vccd1 sky130_fd_sc_hd__tapvpwrvgnd_1
Xhold261 _01356_ vssd1 vssd1 vccd1 vccd1 net1220 sky130_fd_sc_hd__dlygate4sd3_1
Xhold250 _00144_ vssd1 vssd1 vccd1 vccd1 net1209 sky130_fd_sc_hd__dlygate4sd3_1
Xhold272 cell2.LE_0B.config_data\[12\] vssd1 vssd1 vccd1 vccd1 net1231 sky130_fd_sc_hd__dlygate4sd3_1
XANTENNA__10010__B2 bus3_2\[4\] vssd1 vssd1 vccd1 vccd1 sky130_fd_sc_hd__diode_2
XANTENNA__10010__A1 bus3_2\[5\] vssd1 vssd1 vccd1 vccd1 sky130_fd_sc_hd__diode_2
Xhold283 cell0.LE_0B.config_data\[4\] vssd1 vssd1 vccd1 vccd1 net1242 sky130_fd_sc_hd__dlygate4sd3_1
Xhold294 cell0.LE_1B.config_data\[4\] vssd1 vssd1 vccd1 vccd1 net1253 sky130_fd_sc_hd__dlygate4sd3_1
XANTENNA__11486__X net222 vssd1 vssd1 vccd1 vccd1 sky130_fd_sc_hd__diode_2
Xfanout741 net742 vssd1 vssd1 vccd1 vccd1 net741 sky130_fd_sc_hd__clkbuf_2
Xfanout730 net732 vssd1 vssd1 vccd1 vccd1 net730 sky130_fd_sc_hd__clkbuf_4
XANTENNA_fanout855_X net855 vssd1 vssd1 vccd1 vccd1 sky130_fd_sc_hd__diode_2
XPHY_EDGE_ROW_130_Right_130 vssd1 vssd1 vccd1 vccd1 sky130_fd_sc_hd__decap_3
Xfanout752 net754 vssd1 vssd1 vccd1 vccd1 net752 sky130_fd_sc_hd__buf_4
X_09929_ cell2.CB_1.config_dataB\[3\] cell2.CB_1.config_dataB\[2\] _04931_ _04932_
+ vssd1 vssd1 vccd1 vccd1 _04933_ sky130_fd_sc_hd__o22a_1
Xfanout774 net780 vssd1 vssd1 vccd1 vccd1 net774 sky130_fd_sc_hd__clkbuf_4
Xfanout763 net768 vssd1 vssd1 vccd1 vccd1 net763 sky130_fd_sc_hd__clkbuf_2
Xfanout785 net786 vssd1 vssd1 vccd1 vccd1 net785 sky130_fd_sc_hd__clkbuf_4
XANTENNA_input133_A nrst vssd1 vssd1 vccd1 vccd1 sky130_fd_sc_hd__diode_2
X_12940_ net1017 net1013 net933 vssd1 vssd1 vccd1 vccd1 _01368_ sky130_fd_sc_hd__mux2_1
Xfanout796 net798 vssd1 vssd1 vccd1 vccd1 net796 sky130_fd_sc_hd__clkbuf_4
XFILLER_18_305 vssd1 vssd1 vccd1 vccd1 sky130_fd_sc_hd__fill_1
XFILLER_105_95 vssd1 vssd1 vccd1 vccd1 sky130_fd_sc_hd__fill_1
X_12871_ cell2.SB0.route_sel\[113\] cell2.SB0.route_sel\[112\] net812 vssd1 vssd1
+ vccd1 vccd1 _01300_ sky130_fd_sc_hd__mux2_1
XFILLER_73_444 vssd1 vssd1 vccd1 vccd1 sky130_fd_sc_hd__fill_1
XFILLER_65_66 vssd1 vssd1 vccd1 vccd1 sky130_fd_sc_hd__fill_4
XANTENNA__07190__A1 net313 vssd1 vssd1 vccd1 vccd1 sky130_fd_sc_hd__diode_2
XTAP_TAPCELL_ROW_47_1009 vssd1 vccd1 sky130_fd_sc_hd__tapvpwrvgnd_1
X_11822_ cell1.CB_1.config_dataA\[3\] cell1.CB_1.config_dataA\[2\] net894 vssd1 vssd1
+ vccd1 vccd1 _00259_ sky130_fd_sc_hd__mux2_1
XFILLER_81_32 vssd1 vssd1 vccd1 vccd1 sky130_fd_sc_hd__fill_2
X_11753_ cell0.LEI0.config_data\[3\] net1099 net796 vssd1 vssd1 vccd1 vccd1 _00190_
+ sky130_fd_sc_hd__mux2_1
X_14472_ clknet_leaf_60_clk net1478 net738 vssd1 vssd1 vccd1 vccd1 cell3.LEI0.config_data\[37\]
+ sky130_fd_sc_hd__dfrtp_1
X_10704_ net8 net9 net10 net11 cell3.CB_1.config_dataA\[15\] cell3.CB_1.config_dataA\[16\]
+ vssd1 vssd1 vccd1 vccd1 _05662_ sky130_fd_sc_hd__mux4_1
XTAP_TAPCELL_ROW_60_1209 vssd1 vccd1 sky130_fd_sc_hd__tapvpwrvgnd_1
X_11684_ net1311 cell0.LE_1A.config_data\[2\] net801 vssd1 vssd1 vccd1 vccd1 _00124_
+ sky130_fd_sc_hd__mux2_1
XANTENNA__08690__B2 net27 vssd1 vssd1 vccd1 vccd1 sky130_fd_sc_hd__diode_2
XANTENNA__08690__A1 net28 vssd1 vssd1 vccd1 vccd1 sky130_fd_sc_hd__diode_2
XFILLER_14_577 vssd1 vssd1 vccd1 vccd1 sky130_fd_sc_hd__fill_8
XANTENNA__11026__A0 net40 vssd1 vssd1 vccd1 vccd1 sky130_fd_sc_hd__diode_2
X_10635_ net276 _05509_ _05569_ vssd1 vssd1 vccd1 vccd1 _05593_ sky130_fd_sc_hd__a21oi_1
XANTENNA__07858__Y _02902_ vssd1 vssd1 vccd1 vccd1 sky130_fd_sc_hd__diode_2
XFILLER_14_81 vssd1 vssd1 vccd1 vccd1 sky130_fd_sc_hd__fill_2
X_13423_ clknet_leaf_131_clk _00395_ net560 vssd1 vssd1 vccd1 vccd1 cell0.SB0.route_sel\[64\]
+ sky130_fd_sc_hd__dfstp_1
Xclkload109 clknet_leaf_51_clk vssd1 vssd1 vccd1 vccd1 clkload109/Y sky130_fd_sc_hd__clkinv_8
X_13354_ clknet_leaf_117_clk _00326_ net666 vssd1 vssd1 vccd1 vccd1 cell1.CB_0.config_dataA\[20\]
+ sky130_fd_sc_hd__dfstp_1
XANTENNA_output185_A net185 vssd1 vssd1 vccd1 vccd1 sky130_fd_sc_hd__diode_2
X_10566_ _01788_ net272 _05521_ net394 vssd1 vssd1 vccd1 vccd1 _05524_ sky130_fd_sc_hd__o31a_1
X_12305_ cell1.SB0.route_sel\[43\] cell1.SB0.route_sel\[42\] net856 vssd1 vssd1 vccd1
+ vccd1 _00738_ sky130_fd_sc_hd__mux2_1
X_13285_ clknet_leaf_95_clk _00257_ net687 vssd1 vssd1 vccd1 vccd1 cell1.CB_1.config_dataA\[1\]
+ sky130_fd_sc_hd__dfstp_1
X_10497_ net321 _03529_ _01963_ vssd1 vssd1 vccd1 vccd1 _05464_ sky130_fd_sc_hd__mux2_1
X_12236_ cell2.CB_0.config_dataB\[24\] cell2.CB_0.config_dataB\[23\] net826 vssd1
+ vssd1 vccd1 vccd1 _00669_ sky130_fd_sc_hd__mux2_1
XTAP_TAPCELL_ROW_75_1430 vssd1 vccd1 sky130_fd_sc_hd__tapvpwrvgnd_1
XANTENNA__13097__Q cell0.CB_0.config_dataB\[24\] vssd1 vssd1 vccd1 vccd1 sky130_fd_sc_hd__diode_2
X_12167_ net1207 cell2.LE_0A.reset_mode net850 vssd1 vssd1 vccd1 vccd1 _00600_ sky130_fd_sc_hd__mux2_1
XANTENNA__11396__X net260 vssd1 vssd1 vccd1 vccd1 sky130_fd_sc_hd__diode_2
XANTENNA__08745__A2 _03486_ vssd1 vssd1 vccd1 vccd1 sky130_fd_sc_hd__diode_2
X_11118_ cell3.CB_0.config_dataB\[0\] _05912_ _06069_ cell3.CB_0.config_dataB\[1\]
+ vssd1 vssd1 vccd1 vccd1 _06070_ sky130_fd_sc_hd__o211a_1
X_12098_ net964 net1038 net877 vssd1 vssd1 vccd1 vccd1 _00532_ sky130_fd_sc_hd__mux2_1
X_11049_ net49 net50 net51 net52 net373 net372 vssd1 vssd1 vccd1 vccd1 _06003_ sky130_fd_sc_hd__mux4_1
Xinput7 CBeast_in[15] vssd1 vssd1 vccd1 vccd1 net7 sky130_fd_sc_hd__clkbuf_4
XANTENNA__07705__B1 _02747_ vssd1 vssd1 vccd1 vccd1 sky130_fd_sc_hd__diode_2
XANTENNA__10887__S _05831_ vssd1 vssd1 vccd1 vccd1 sky130_fd_sc_hd__diode_2
XFILLER_64_477 vssd1 vssd1 vccd1 vccd1 sky130_fd_sc_hd__fill_2
XFILLER_64_455 vssd1 vssd1 vccd1 vccd1 sky130_fd_sc_hd__fill_1
XFILLER_36_157 vssd1 vssd1 vccd1 vccd1 sky130_fd_sc_hd__fill_1
XANTENNA__11265__A0 net305 vssd1 vssd1 vccd1 vccd1 sky130_fd_sc_hd__diode_2
XTAP_TAPCELL_ROW_86_1592 vssd1 vccd1 sky130_fd_sc_hd__tapvpwrvgnd_1
XTAP_TAPCELL_ROW_35_826 vssd1 vccd1 sky130_fd_sc_hd__tapvpwrvgnd_1
XTAP_TAPCELL_ROW_35_837 vssd1 vccd1 sky130_fd_sc_hd__tapvpwrvgnd_1
X_06590_ cell1.CB_1.config_dataB\[17\] vssd1 vssd1 vccd1 vccd1 _01660_ sky130_fd_sc_hd__inv_2
XFILLER_17_393 vssd1 vssd1 vccd1 vccd1 sky130_fd_sc_hd__fill_2
X_08260_ cell0.LE_1A.config_data\[3\] cell0.LE_1A.config_data\[2\] _03198_ vssd1 vssd1
+ vccd1 vccd1 _03300_ sky130_fd_sc_hd__mux2_1
XANTENNA__11017__A0 _05874_ vssd1 vssd1 vccd1 vccd1 sky130_fd_sc_hd__diode_2
X_07211_ net346 _01947_ _02032_ vssd1 vssd1 vccd1 vccd1 _02271_ sky130_fd_sc_hd__or3_1
X_08191_ cell0.CB_1.config_dataA\[9\] _03203_ _03207_ _03228_ _03230_ vssd1 vssd1
+ vccd1 vccd1 _03231_ sky130_fd_sc_hd__a311o_2
X_07142_ _01867_ _02032_ vssd1 vssd1 vccd1 vccd1 _02204_ sky130_fd_sc_hd__or2_1
XFILLER_105_107 vssd1 vssd1 vccd1 vccd1 sky130_fd_sc_hd__fill_1
X_07073_ _02133_ _02134_ _02135_ _02132_ _02111_ vssd1 vssd1 vccd1 vccd1 _02137_ sky130_fd_sc_hd__a311o_1
XANTENNA__10791__A2 _04362_ vssd1 vssd1 vccd1 vccd1 sky130_fd_sc_hd__diode_2
XFILLER_87_503 vssd1 vssd1 vccd1 vccd1 sky130_fd_sc_hd__fill_1
XFILLER_102_847 vssd1 vssd1 vccd1 vccd1 sky130_fd_sc_hd__fill_1
XFILLER_101_335 vssd1 vssd1 vccd1 vccd1 sky130_fd_sc_hd__fill_1
X_07975_ _03018_ _03017_ _02917_ vssd1 vssd1 vccd1 vccd1 _03019_ sky130_fd_sc_hd__mux2_1
XFILLER_19_15 vccd1 vssd1 vccd1 vssd1 sky130_ef_sc_hd__decap_40_12
XFILLER_142_27 vssd1 vssd1 vccd1 vccd1 sky130_fd_sc_hd__fill_1
XANTENNA__11099__A3 net57 vssd1 vssd1 vccd1 vccd1 sky130_fd_sc_hd__diode_2
X_09714_ _02592_ _04725_ _04726_ vssd1 vssd1 vccd1 vccd1 _04727_ sky130_fd_sc_hd__o21ba_1
X_06926_ cell2.CB_1.config_dataB\[24\] cell2.CB_1.config_dataB\[21\] cell2.CB_1.config_dataB\[20\]
+ vssd1 vssd1 vccd1 vccd1 _01993_ sky130_fd_sc_hd__nand3b_4
XFILLER_28_603 vssd1 vssd1 vccd1 vccd1 sky130_fd_sc_hd__fill_1
X_06857_ _01925_ net309 _01924_ vssd1 vssd1 vccd1 vccd1 _01926_ sky130_fd_sc_hd__mux2_1
X_09645_ cell3.SB0.route_sel\[96\] cell3.SB0.route_sel\[97\] _04659_ _04660_ vssd1
+ vssd1 vccd1 vccd1 _04661_ sky130_fd_sc_hd__a211o_1
XFILLER_67_271 vssd1 vssd1 vccd1 vccd1 sky130_fd_sc_hd__fill_1
XFILLER_27_113 vssd1 vssd1 vccd1 vccd1 sky130_fd_sc_hd__fill_1
XANTENNA_fanout648_A net649 vssd1 vssd1 vccd1 vccd1 sky130_fd_sc_hd__diode_2
XANTENNA_fanout550_A _01820_ vssd1 vssd1 vccd1 vccd1 sky130_fd_sc_hd__diode_2
X_09576_ net295 _04593_ _04591_ vssd1 vssd1 vccd1 vccd1 _04594_ sky130_fd_sc_hd__mux2_1
XANTENNA__12048__A2 net550 vssd1 vssd1 vccd1 vccd1 sky130_fd_sc_hd__diode_2
X_06788_ cell0.SB0.route_sel\[53\] cell0.SB0.route_sel\[52\] vssd1 vssd1 vccd1 vccd1
+ _01858_ sky130_fd_sc_hd__nand2_1
X_08527_ _03548_ _03551_ _03558_ _03562_ vssd1 vssd1 vccd1 vccd1 _03563_ sky130_fd_sc_hd__o211a_1
XFILLER_35_69 vssd1 vssd1 vccd1 vccd1 sky130_fd_sc_hd__fill_8
XFILLER_35_190 vssd1 vssd1 vccd1 vccd1 sky130_fd_sc_hd__fill_1
XANTENNA__08672__A1 net32 vssd1 vssd1 vccd1 vccd1 sky130_fd_sc_hd__diode_2
XTAP_TAPCELL_ROW_13_509 vssd1 vccd1 sky130_fd_sc_hd__tapvpwrvgnd_1
X_08458_ _02444_ _03493_ vssd1 vssd1 vccd1 vccd1 _03494_ sky130_fd_sc_hd__nor2_1
XANTENNA__06863__X _01931_ vssd1 vssd1 vccd1 vccd1 sky130_fd_sc_hd__diode_2
XANTENNA__11008__A0 _05847_ vssd1 vssd1 vccd1 vccd1 sky130_fd_sc_hd__diode_2
X_07409_ _02180_ _02397_ vssd1 vssd1 vccd1 vccd1 _02464_ sky130_fd_sc_hd__nor2_1
X_10420_ cell2.LE_0B.config_data\[15\] cell2.LE_0B.config_data\[14\] _05344_ vssd1
+ vssd1 vccd1 vccd1 _05419_ sky130_fd_sc_hd__mux2_1
XTAP_TAPCELL_ROW_133_2309 vssd1 vccd1 sky130_fd_sc_hd__tapvpwrvgnd_1
X_08389_ _03425_ _03426_ cell0.CB_1.config_dataB\[17\] vssd1 vssd1 vccd1 vccd1 _03427_
+ sky130_fd_sc_hd__mux2_1
XFILLER_109_446 vssd1 vssd1 vccd1 vccd1 sky130_fd_sc_hd__fill_2
X_10351_ net428 net426 vssd1 vssd1 vccd1 vccd1 _05350_ sky130_fd_sc_hd__nor2_1
XANTENNA__07200__A net349 vssd1 vssd1 vccd1 vccd1 sky130_fd_sc_hd__diode_2
X_10282_ net431 net430 vssd1 vssd1 vccd1 vccd1 _05281_ sky130_fd_sc_hd__or2_1
X_13070_ clknet_leaf_111_clk _00042_ net654 vssd1 vssd1 vccd1 vccd1 cell0.CB_1.config_dataA\[22\]
+ sky130_fd_sc_hd__dfstp_2
XANTENNA__09924__A1 _04197_ vssd1 vssd1 vccd1 vccd1 sky130_fd_sc_hd__diode_2
XTAP_TAPCELL_ROW_57_1160 vssd1 vccd1 sky130_fd_sc_hd__tapvpwrvgnd_1
X_12021_ cell0.SB0.config_data_out cell0.SB0.route_sel\[126\] net794 vssd1 vssd1 vccd1
+ vccd1 _00458_ sky130_fd_sc_hd__mux2_1
XFILLER_4_3 vccd1 vssd1 vccd1 vssd1 sky130_ef_sc_hd__decap_40_12
XFILLER_2_245 vssd1 vssd1 vccd1 vccd1 sky130_fd_sc_hd__fill_4
XANTENNA__09924__B2 _04260_ vssd1 vssd1 vccd1 vccd1 sky130_fd_sc_hd__diode_2
XANTENNA__07854__B _02897_ vssd1 vssd1 vccd1 vccd1 sky130_fd_sc_hd__diode_2
XFILLER_2_289 vccd1 vssd1 vccd1 vssd1 sky130_ef_sc_hd__decap_40_12
XFILLER_116_94 vssd1 vssd1 vccd1 vccd1 sky130_fd_sc_hd__fill_1
XFILLER_59_750 vssd1 vssd1 vccd1 vccd1 sky130_fd_sc_hd__fill_1
Xfanout560 net563 vssd1 vssd1 vccd1 vccd1 net560 sky130_fd_sc_hd__clkbuf_4
X_13972_ clknet_leaf_36_clk _00944_ net638 vssd1 vssd1 vccd1 vccd1 cell2.LEI0.config_data\[29\]
+ sky130_fd_sc_hd__dfrtp_1
XTAP_TAPCELL_ROW_70_1360 vssd1 vccd1 sky130_fd_sc_hd__tapvpwrvgnd_1
Xfanout593 net601 vssd1 vssd1 vccd1 vccd1 net593 sky130_fd_sc_hd__clkbuf_4
Xfanout571 net575 vssd1 vssd1 vccd1 vccd1 net571 sky130_fd_sc_hd__buf_2
Xfanout582 net584 vssd1 vssd1 vccd1 vccd1 net582 sky130_fd_sc_hd__clkbuf_4
X_12923_ net1079 net1081 net942 vssd1 vssd1 vccd1 vccd1 _01352_ sky130_fd_sc_hd__mux2_1
XFILLER_76_87 vssd1 vssd1 vccd1 vccd1 sky130_fd_sc_hd__fill_1
XFILLER_74_753 vssd1 vssd1 vccd1 vccd1 sky130_fd_sc_hd__fill_1
X_12854_ cell2.SB0.route_sel\[96\] cell2.SB0.route_sel\[95\] net833 vssd1 vssd1 vccd1
+ vccd1 _01283_ sky130_fd_sc_hd__mux2_1
XFILLER_92_53 vssd1 vssd1 vccd1 vccd1 sky130_fd_sc_hd__fill_8
X_12785_ cell2.SB0.route_sel\[27\] cell2.SB0.route_sel\[26\] net817 vssd1 vssd1 vccd1
+ vccd1 _01214_ sky130_fd_sc_hd__mux2_1
X_11805_ cell1.LE_1B.config_data\[6\] net1507 net901 vssd1 vssd1 vccd1 vccd1 _00242_
+ sky130_fd_sc_hd__mux2_1
X_11736_ net988 cell0.LE_0A.config_data\[8\] net808 vssd1 vssd1 vccd1 vccd1 _00174_
+ sky130_fd_sc_hd__mux2_1
X_14455_ clknet_leaf_59_clk net1390 net736 vssd1 vssd1 vccd1 vccd1 cell3.LEI0.config_data\[20\]
+ sky130_fd_sc_hd__dfrtp_1
X_11667_ cell0.CB_1.config_dataB\[13\] cell0.CB_1.config_dataB\[12\] net783 vssd1
+ vssd1 vccd1 vccd1 _00108_ sky130_fd_sc_hd__mux2_1
XANTENNA__11014__A3 net52 vssd1 vssd1 vccd1 vccd1 sky130_fd_sc_hd__diode_2
X_14386_ clknet_leaf_67_clk _01358_ net743 vssd1 vssd1 vccd1 vccd1 cell3.LE_1A.edge_mode
+ sky130_fd_sc_hd__dfstp_1
XANTENNA__10758__C1 _05503_ vssd1 vssd1 vccd1 vccd1 sky130_fd_sc_hd__diode_2
X_10618_ _04589_ _04595_ _04601_ _05539_ net398 vssd1 vssd1 vccd1 vccd1 _05576_ sky130_fd_sc_hd__a2111o_1
XFILLER_10_580 vssd1 vssd1 vccd1 vccd1 sky130_fd_sc_hd__fill_2
X_13406_ clknet_leaf_134_clk _00378_ net555 vssd1 vssd1 vccd1 vccd1 cell0.SB0.route_sel\[47\]
+ sky130_fd_sc_hd__dfstp_1
X_11598_ cell0.CB_1.config_dataA\[19\] cell0.CB_1.config_dataA\[18\] net789 vssd1
+ vssd1 vccd1 vccd1 _00039_ sky130_fd_sc_hd__mux2_1
X_10549_ net395 _05501_ _05506_ net394 vssd1 vssd1 vccd1 vccd1 _05507_ sky130_fd_sc_hd__o211a_1
X_13337_ clknet_leaf_83_clk _00309_ net674 vssd1 vssd1 vccd1 vccd1 cell1.CB_0.config_dataA\[3\]
+ sky130_fd_sc_hd__dfstp_1
XFILLER_6_562 vssd1 vssd1 vccd1 vccd1 sky130_fd_sc_hd__fill_2
XFILLER_142_235 vssd1 vssd1 vccd1 vccd1 sky130_fd_sc_hd__fill_1
X_13268_ clknet_leaf_93_clk net1028 net694 vssd1 vssd1 vccd1 vccd1 cell1.LE_1B.config_data\[4\]
+ sky130_fd_sc_hd__dfrtp_1
XANTENNA__08718__A2 _03465_ vssd1 vssd1 vccd1 vccd1 sky130_fd_sc_hd__diode_2
X_12219_ cell2.CB_0.config_dataB\[7\] cell2.CB_0.config_dataB\[6\] net825 vssd1 vssd1
+ vccd1 vccd1 _00652_ sky130_fd_sc_hd__mux2_1
X_13199_ clknet_leaf_6_clk _00171_ net567 vssd1 vssd1 vccd1 vccd1 cell0.LE_0A.config_data\[6\]
+ sky130_fd_sc_hd__dfrtp_1
XFILLER_69_503 vssd1 vssd1 vccd1 vccd1 sky130_fd_sc_hd__fill_1
XFILLER_37_3 vccd1 vssd1 vccd1 vssd1 sky130_ef_sc_hd__decap_40_12
XFILLER_96_388 vssd1 vssd1 vccd1 vccd1 sky130_fd_sc_hd__fill_1
X_07760_ _01605_ cell0.SB0.route_sel\[38\] cell0.SB0.route_sel\[33\] _01814_ _02805_
+ vssd1 vssd1 vccd1 vccd1 _02806_ sky130_fd_sc_hd__a221o_2
X_06711_ cell3.CB_1.config_dataB\[9\] vssd1 vssd1 vccd1 vccd1 _01781_ sky130_fd_sc_hd__inv_2
XTAP_TAPCELL_ROW_88_1632 vssd1 vccd1 sky130_fd_sc_hd__tapvpwrvgnd_1
XTAP_TAPCELL_ROW_88_1621 vssd1 vccd1 sky130_fd_sc_hd__tapvpwrvgnd_1
XFILLER_49_293 vssd1 vssd1 vccd1 vccd1 sky130_fd_sc_hd__fill_1
XPHY_EDGE_ROW_16_Left_159 vssd1 vssd1 vccd1 vccd1 sky130_fd_sc_hd__decap_3
X_09430_ _01826_ _04450_ _04452_ vssd1 vssd1 vccd1 vccd1 _04453_ sky130_fd_sc_hd__a21oi_1
X_07691_ cell1.SB0.route_sel\[21\] _01507_ vssd1 vssd1 vccd1 vccd1 _02739_ sky130_fd_sc_hd__nand2_1
XANTENNA__08351__A0 bus1_0\[12\] vssd1 vssd1 vccd1 vccd1 sky130_fd_sc_hd__diode_2
X_06642_ cell3.SB0.route_sel\[53\] vssd1 vssd1 vccd1 vccd1 _01712_ sky130_fd_sc_hd__inv_2
XFILLER_92_594 vccd1 vssd1 vccd1 vssd1 sky130_ef_sc_hd__decap_40_12
X_09361_ _04381_ _04384_ cell2.SB0.route_sel\[35\] cell2.SB0.route_sel\[34\] vssd1
+ vssd1 vccd1 vccd1 _04385_ sky130_fd_sc_hd__o211ai_1
X_06573_ cell2.SB0.route_sel\[111\] vssd1 vssd1 vccd1 vccd1 _01643_ sky130_fd_sc_hd__inv_2
X_09292_ _04317_ net282 _04316_ vssd1 vssd1 vccd1 vccd1 _04318_ sky130_fd_sc_hd__mux2_1
XANTENNA__08654__A1 net5 vssd1 vssd1 vccd1 vccd1 sky130_fd_sc_hd__diode_2
XFILLER_21_812 vssd1 vssd1 vccd1 vccd1 sky130_fd_sc_hd__fill_1
X_08312_ net508 net510 vssd1 vssd1 vccd1 vccd1 _03350_ sky130_fd_sc_hd__and2b_2
XANTENNA_23 net146 vssd1 vssd1 vccd1 vccd1 sky130_fd_sc_hd__diode_2
XANTENNA_12 cell1.LE_1A.config_data\[16\] vssd1 vssd1 vccd1 vccd1 sky130_fd_sc_hd__diode_2
X_08243_ _02846_ _03266_ _03267_ _02807_ vssd1 vssd1 vccd1 vccd1 _03283_ sky130_fd_sc_hd__a22o_1
XFILLER_32_171 vssd1 vssd1 vccd1 vccd1 sky130_fd_sc_hd__fill_1
XANTENNA_34 _00848_ vssd1 vssd1 vccd1 vccd1 sky130_fd_sc_hd__diode_2
XANTENNA_45 net1508 vssd1 vssd1 vccd1 vccd1 sky130_fd_sc_hd__diode_2
XPHY_EDGE_ROW_25_Left_168 vssd1 vssd1 vccd1 vccd1 sky130_fd_sc_hd__decap_3
XTAP_TAPCELL_ROW_115_2028 vssd1 vccd1 sky130_fd_sc_hd__tapvpwrvgnd_1
XANTENNA__13339__SET_B net674 vssd1 vssd1 vccd1 vccd1 sky130_fd_sc_hd__diode_2
X_08174_ cell0.CB_1.config_dataA\[6\] _03211_ _03212_ _03213_ vssd1 vssd1 vccd1 vccd1
+ _03214_ sky130_fd_sc_hd__a31o_1
XFILLER_21_27 vccd1 vssd1 vccd1 vssd1 sky130_ef_sc_hd__decap_40_12
XANTENNA__08406__B2 _02846_ vssd1 vssd1 vccd1 vccd1 sky130_fd_sc_hd__diode_2
XANTENNA__08406__A1 _02807_ vssd1 vssd1 vccd1 vccd1 sky130_fd_sc_hd__diode_2
XFILLER_137_27 vccd1 vssd1 vccd1 vssd1 sky130_ef_sc_hd__decap_40_12
XTAP_TAPCELL_ROW_115_2039 vssd1 vccd1 sky130_fd_sc_hd__tapvpwrvgnd_1
XTAP_TAPCELL_ROW_99_1794 vssd1 vccd1 sky130_fd_sc_hd__tapvpwrvgnd_1
X_07125_ cell2.SB0.route_sel\[72\] _01624_ cell2.SB0.route_sel\[75\] _01626_ _02187_
+ vssd1 vssd1 vccd1 vccd1 _02188_ sky130_fd_sc_hd__a221o_1
XFILLER_108_9 vccd1 vssd1 vccd1 vssd1 sky130_ef_sc_hd__decap_40_12
X_07056_ _02118_ _02119_ _02115_ _02116_ vssd1 vssd1 vccd1 vccd1 _02120_ sky130_fd_sc_hd__a2bb2o_1
Xoutput152 net152 vssd1 vssd1 vccd1 vccd1 CBeast_out[26] sky130_fd_sc_hd__buf_2
Xoutput141 net141 vssd1 vssd1 vccd1 vccd1 CBeast_out[16] sky130_fd_sc_hd__buf_2
Xoutput185 net185 vssd1 vssd1 vccd1 vccd1 CBnorth_out[27] sky130_fd_sc_hd__buf_2
Xoutput174 net174 vssd1 vssd1 vccd1 vccd1 CBnorth_out[17] sky130_fd_sc_hd__buf_2
XANTENNA__12072__S net905 vssd1 vssd1 vccd1 vccd1 sky130_fd_sc_hd__diode_2
Xoutput163 net163 vssd1 vssd1 vccd1 vccd1 CBeast_out[7] sky130_fd_sc_hd__buf_2
Xoutput196 net196 vssd1 vssd1 vccd1 vccd1 CBnorth_out[8] sky130_fd_sc_hd__buf_2
XFILLER_101_121 vssd1 vssd1 vccd1 vccd1 sky130_fd_sc_hd__fill_1
XFILLER_0_749 vssd1 vssd1 vccd1 vccd1 sky130_fd_sc_hd__fill_4
XPHY_EDGE_ROW_34_Left_177 vssd1 vssd1 vccd1 vccd1 sky130_fd_sc_hd__decap_3
XTAP_TAPCELL_ROW_110_1961 vssd1 vccd1 sky130_fd_sc_hd__tapvpwrvgnd_1
XANTENNA__07932__A3 net338 vssd1 vssd1 vccd1 vccd1 sky130_fd_sc_hd__diode_2
XANTENNA__08590__A0 _03517_ vssd1 vssd1 vccd1 vccd1 sky130_fd_sc_hd__diode_2
XFILLER_87_399 vssd1 vssd1 vccd1 vccd1 sky130_fd_sc_hd__fill_1
XFILLER_75_539 vssd1 vssd1 vccd1 vccd1 sky130_fd_sc_hd__fill_2
XTAP_TAPCELL_ROW_52_1090 vssd1 vccd1 sky130_fd_sc_hd__tapvpwrvgnd_1
X_07958_ _02388_ _02983_ _02984_ _02456_ _01575_ vssd1 vssd1 vccd1 vccd1 _03002_ sky130_fd_sc_hd__a221o_1
XANTENNA__11483__Y net221 vssd1 vssd1 vccd1 vccd1 sky130_fd_sc_hd__diode_2
XANTENNA_fanout932_A net933 vssd1 vssd1 vccd1 vccd1 sky130_fd_sc_hd__diode_2
X_07889_ net521 _02585_ vssd1 vssd1 vccd1 vccd1 _02933_ sky130_fd_sc_hd__nand2_1
X_06909_ net328 _01971_ _01975_ _01976_ vssd1 vssd1 vccd1 vccd1 _01977_ sky130_fd_sc_hd__o22a_1
X_09628_ net318 _02377_ _04643_ cell3.SB0.route_sel\[100\] cell3.SB0.route_sel\[101\]
+ vssd1 vssd1 vccd1 vccd1 _04644_ sky130_fd_sc_hd__o2111a_1
XANTENNA__08893__A1 bus3_1\[5\] vssd1 vssd1 vccd1 vccd1 sky130_fd_sc_hd__diode_2
XANTENNA__08893__B2 bus3_1\[4\] vssd1 vssd1 vccd1 vccd1 sky130_fd_sc_hd__diode_2
XFILLER_15_116 vssd1 vssd1 vccd1 vccd1 sky130_fd_sc_hd__fill_1
X_09559_ cell3.SB0.route_sel\[72\] _01723_ cell3.SB0.route_sel\[75\] _01725_ _04577_
+ vssd1 vssd1 vccd1 vccd1 _04578_ sky130_fd_sc_hd__a221o_1
XFILLER_102_85 vssd1 vssd1 vccd1 vccd1 sky130_fd_sc_hd__fill_2
X_12570_ cell3.SB0.route_sel\[35\] cell3.SB0.route_sel\[34\] net911 vssd1 vssd1 vccd1
+ vccd1 _00999_ sky130_fd_sc_hd__mux2_1
XFILLER_141_3 vccd1 vssd1 vccd1 vssd1 sky130_ef_sc_hd__decap_40_12
XANTENNA__13627__SET_B net751 vssd1 vssd1 vccd1 vccd1 sky130_fd_sc_hd__diode_2
XPHY_EDGE_ROW_43_Left_186 vssd1 vssd1 vccd1 vccd1 sky130_fd_sc_hd__decap_3
XFILLER_12_834 vssd1 vssd1 vccd1 vccd1 sky130_fd_sc_hd__fill_1
XFILLER_12_845 vssd1 vssd1 vccd1 vccd1 sky130_fd_sc_hd__fill_1
XFILLER_23_182 vssd1 vssd1 vccd1 vccd1 sky130_fd_sc_hd__fill_2
X_11521_ cell2.SB0.route_sel\[88\] cell2.SB0.route_sel\[89\] cell2.SB0.route_sel\[92\]
+ _01636_ _06347_ vssd1 vssd1 vccd1 vccd1 _06348_ sky130_fd_sc_hd__o221a_1
X_14240_ clknet_leaf_19_clk _01212_ net611 vssd1 vssd1 vccd1 vccd1 cell2.SB0.route_sel\[25\]
+ sky130_fd_sc_hd__dfstp_1
X_11452_ cell1.SB0.route_sel\[34\] _01513_ cell1.SB0.route_sel\[38\] cell1.SB0.route_sel\[39\]
+ _06301_ vssd1 vssd1 vccd1 vccd1 _06302_ sky130_fd_sc_hd__o221a_1
X_14171_ clknet_leaf_56_clk _01143_ net721 vssd1 vssd1 vccd1 vccd1 cell3.CB_0.config_dataB\[6\]
+ sky130_fd_sc_hd__dfstp_1
X_10403_ _05152_ _05385_ _05386_ _05156_ cell2.CB_0.config_dataB\[17\] vssd1 vssd1
+ vccd1 vccd1 _05402_ sky130_fd_sc_hd__a221o_1
XTAP_TAPCELL_ROW_59_1200 vssd1 vccd1 sky130_fd_sc_hd__tapvpwrvgnd_1
XANTENNA__08948__A2 _03858_ vssd1 vssd1 vccd1 vccd1 sky130_fd_sc_hd__diode_2
X_11383_ cell0.SB0.route_sel\[48\] cell0.SB0.route_sel\[49\] _01457_ cell0.SB0.route_sel\[52\]
+ _06255_ vssd1 vssd1 vccd1 vccd1 _06256_ sky130_fd_sc_hd__o221a_1
XANTENNA_input61_A CBnorth_in[6] vssd1 vssd1 vccd1 vccd1 sky130_fd_sc_hd__diode_2
X_10334_ net435 net433 _05097_ vssd1 vssd1 vccd1 vccd1 _05333_ sky130_fd_sc_hd__or3_1
XFILLER_109_287 vssd1 vssd1 vccd1 vccd1 sky130_fd_sc_hd__fill_1
XANTENNA__10755__A2 net10 vssd1 vssd1 vccd1 vccd1 sky130_fd_sc_hd__diode_2
X_13122_ clknet_leaf_8_clk _00094_ net572 vssd1 vssd1 vccd1 vccd1 cell0.CB_0.config_dataA\[24\]
+ sky130_fd_sc_hd__dfstp_1
Xclkbuf_0_cell0.LE_1B.sel_clk cell0.LE_1B.sel_clk vssd1 vssd1 vccd1 vccd1 clknet_0_cell0.LE_1B.sel_clk
+ sky130_fd_sc_hd__clkbuf_16
XANTENNA__09409__X _04432_ vssd1 vssd1 vccd1 vccd1 sky130_fd_sc_hd__diode_2
XFILLER_112_408 vssd1 vssd1 vccd1 vccd1 sky130_fd_sc_hd__fill_2
XFILLER_3_554 vssd1 vssd1 vccd1 vccd1 sky130_fd_sc_hd__fill_4
XFILLER_133_780 vssd1 vssd1 vccd1 vccd1 sky130_fd_sc_hd__fill_1
X_10265_ cell2.LE_0A.config_data\[1\] cell2.LE_0A.config_data\[0\] _05196_ vssd1 vssd1
+ vccd1 vccd1 _05266_ sky130_fd_sc_hd__mux2_1
XPHY_EDGE_ROW_52_Left_195 vssd1 vssd1 vccd1 vccd1 sky130_fd_sc_hd__decap_3
X_13053_ clknet_leaf_126_clk _00025_ net582 vssd1 vssd1 vccd1 vccd1 cell0.CB_1.config_dataA\[5\]
+ sky130_fd_sc_hd__dfstp_1
XANTENNA__10507__A2 _03498_ vssd1 vssd1 vccd1 vccd1 sky130_fd_sc_hd__diode_2
X_10196_ cell2.LE_0A.config_data\[5\] cell2.LE_0A.config_data\[4\] _05196_ vssd1 vssd1
+ vccd1 vccd1 _05197_ sky130_fd_sc_hd__mux2_1
X_12004_ cell0.SB0.route_sel\[110\] cell0.SB0.route_sel\[109\] net758 vssd1 vssd1
+ vccd1 vccd1 _00441_ sky130_fd_sc_hd__mux2_1
XANTENNA_output148_A net148 vssd1 vssd1 vccd1 vccd1 sky130_fd_sc_hd__diode_2
Xfanout390 cell3.CB_1.config_dataA\[16\] vssd1 vssd1 vccd1 vccd1 net390 sky130_fd_sc_hd__clkbuf_2
XTAP_TAPCELL_ROW_6_392 vssd1 vccd1 sky130_fd_sc_hd__tapvpwrvgnd_1
X_13955_ clknet_leaf_42_clk net1550 net633 vssd1 vssd1 vccd1 vccd1 cell2.LEI0.config_data\[12\]
+ sky130_fd_sc_hd__dfrtp_1
XANTENNA__08333__A0 bus1_0\[12\] vssd1 vssd1 vccd1 vccd1 sky130_fd_sc_hd__diode_2
XANTENNA_clkload7_A clknet_4_7_0_clk vssd1 vssd1 vccd1 vccd1 sky130_fd_sc_hd__diode_2
X_13886_ clknet_leaf_53_clk _00858_ net714 vssd1 vssd1 vccd1 vccd1 cell2.LE_1A.config_data\[9\]
+ sky130_fd_sc_hd__dfrtp_1
X_12906_ cell3.CB_1.config_dataB\[20\] cell3.CB_1.config_dataB\[19\] net938 vssd1
+ vssd1 vccd1 vccd1 _01335_ sky130_fd_sc_hd__mux2_1
XANTENNA__10691__A1 net22 vssd1 vssd1 vccd1 vccd1 sky130_fd_sc_hd__diode_2
X_12837_ cell2.SB0.route_sel\[79\] cell2.SB0.route_sel\[78\] net795 vssd1 vssd1 vccd1
+ vccd1 _01266_ sky130_fd_sc_hd__mux2_1
XTAP_TAPCELL_ROW_83_1551 vssd1 vccd1 sky130_fd_sc_hd__tapvpwrvgnd_1
XTAP_TAPCELL_ROW_45_987 vssd1 vccd1 sky130_fd_sc_hd__tapvpwrvgnd_1
XTAP_TAPCELL_ROW_45_976 vssd1 vccd1 sky130_fd_sc_hd__tapvpwrvgnd_1
X_12768_ cell2.SB0.route_sel\[10\] cell2.SB0.route_sel\[9\] net831 vssd1 vssd1 vccd1
+ vccd1 _01197_ sky130_fd_sc_hd__mux2_1
XFILLER_14_171 vssd1 vssd1 vccd1 vccd1 sky130_fd_sc_hd__fill_4
XANTENNA__10443__B2 cell3.SB0.route_sel\[45\] vssd1 vssd1 vccd1 vccd1 sky130_fd_sc_hd__diode_2
X_12699_ cell3.CB_1.config_dataA\[16\] net391 net938 vssd1 vssd1 vccd1 vccd1 _01128_
+ sky130_fd_sc_hd__mux2_1
X_11719_ net1366 net1413 net796 vssd1 vssd1 vccd1 vccd1 _00158_ sky130_fd_sc_hd__mux2_1
Xinput21 CBeast_in[28] vssd1 vssd1 vccd1 vccd1 net21 sky130_fd_sc_hd__buf_2
X_14438_ clknet_leaf_60_clk net1500 net734 vssd1 vssd1 vccd1 vccd1 cell3.LEI0.config_data\[3\]
+ sky130_fd_sc_hd__dfrtp_1
Xinput10 CBeast_in[18] vssd1 vssd1 vccd1 vccd1 net10 sky130_fd_sc_hd__buf_2
Xinput43 CBnorth_in[19] vssd1 vssd1 vccd1 vccd1 net43 sky130_fd_sc_hd__clkbuf_4
Xinput54 CBnorth_in[29] vssd1 vssd1 vccd1 vccd1 net54 sky130_fd_sc_hd__buf_2
XANTENNA__10185__B _05084_ vssd1 vssd1 vccd1 vccd1 sky130_fd_sc_hd__diode_2
Xinput32 CBeast_in[9] vssd1 vssd1 vccd1 vccd1 net32 sky130_fd_sc_hd__clkbuf_4
X_14369_ clknet_leaf_66_clk _01341_ net746 vssd1 vssd1 vccd1 vccd1 cell3.LE_1A.config_data\[0\]
+ sky130_fd_sc_hd__dfrtp_1
Xinput65 SBsouth_in[0] vssd1 vssd1 vccd1 vccd1 net65 sky130_fd_sc_hd__buf_1
Xinput76 SBsouth_in[1] vssd1 vssd1 vccd1 vccd1 net76 sky130_fd_sc_hd__buf_1
Xinput87 SBsouth_in[2] vssd1 vssd1 vccd1 vccd1 net87 sky130_fd_sc_hd__dlymetal6s2s_1
XANTENNA__07072__B1 _02132_ vssd1 vssd1 vccd1 vccd1 sky130_fd_sc_hd__diode_2
Xinput98 SBwest_in[10] vssd1 vssd1 vccd1 vccd1 net98 sky130_fd_sc_hd__buf_1
XANTENNA__08223__X _03263_ vssd1 vssd1 vccd1 vccd1 sky130_fd_sc_hd__diode_2
X_08930_ net468 _03841_ _03961_ cell1.CB_0.config_dataA\[11\] vssd1 vssd1 vccd1 vccd1
+ _03962_ sky130_fd_sc_hd__o211a_1
XANTENNA__07494__B cell0.SB0.config_data_out vssd1 vssd1 vccd1 vccd1 sky130_fd_sc_hd__diode_2
XFILLER_123_290 vssd1 vssd1 vccd1 vccd1 sky130_fd_sc_hd__fill_1
XFILLER_96_130 vssd1 vssd1 vccd1 vccd1 sky130_fd_sc_hd__fill_1
X_08861_ cell1.SB0.route_sel\[37\] cell1.SB0.route_sel\[36\] vssd1 vssd1 vccd1 vccd1
+ _03893_ sky130_fd_sc_hd__nand2b_1
X_07812_ net333 _02855_ _02856_ _02854_ vssd1 vssd1 vccd1 vccd1 _02857_ sky130_fd_sc_hd__a22oi_2
XFILLER_96_174 vssd1 vssd1 vccd1 vccd1 sky130_fd_sc_hd__fill_1
XFILLER_69_388 vssd1 vssd1 vccd1 vccd1 sky130_fd_sc_hd__fill_4
XANTENNA__09116__A2 _03817_ vssd1 vssd1 vccd1 vccd1 sky130_fd_sc_hd__diode_2
X_08792_ cell1.SB0.route_sel\[106\] cell1.SB0.route_sel\[107\] cell1.SB0.route_sel\[109\]
+ _01545_ _03823_ vssd1 vssd1 vccd1 vccd1 _03824_ sky130_fd_sc_hd__o221a_1
X_07743_ net339 net360 _02014_ _02011_ _01849_ vssd1 vssd1 vccd1 vccd1 _02789_ sky130_fd_sc_hd__o32a_1
XANTENNA__08875__A1 _03849_ vssd1 vssd1 vccd1 vccd1 sky130_fd_sc_hd__diode_2
X_07674_ cell1.SB0.route_sel\[22\] cell1.SB0.route_sel\[23\] _02702_ _02721_ vssd1
+ vssd1 vccd1 vccd1 _02722_ sky130_fd_sc_hd__a211o_1
XTAP_TAPCELL_ROW_125_2190 vssd1 vccd1 sky130_fd_sc_hd__tapvpwrvgnd_1
X_09413_ cell2.SB0.route_sel\[43\] cell2.SB0.route_sel\[42\] _04433_ _04435_ _04431_
+ vssd1 vssd1 vccd1 vccd1 _04436_ sky130_fd_sc_hd__a41o_1
X_06625_ cell3.SB0.route_sel\[27\] vssd1 vssd1 vccd1 vccd1 _01695_ sky130_fd_sc_hd__inv_2
XFILLER_80_531 vssd1 vssd1 vccd1 vccd1 sky130_fd_sc_hd__fill_1
XANTENNA__08875__B2 _03853_ vssd1 vssd1 vccd1 vccd1 sky130_fd_sc_hd__diode_2
X_09344_ net283 _04367_ vssd1 vssd1 vccd1 vccd1 _04369_ sky130_fd_sc_hd__nand2_1
X_06556_ cell2.SB0.route_sel\[74\] vssd1 vssd1 vccd1 vccd1 _01626_ sky130_fd_sc_hd__inv_2
XTAP_TAPCELL_ROW_23_648 vssd1 vccd1 sky130_fd_sc_hd__tapvpwrvgnd_1
XFILLER_139_839 vssd1 vssd1 vccd1 vccd1 sky130_fd_sc_hd__fill_1
X_09275_ _04279_ _04299_ _04300_ vssd1 vssd1 vccd1 vccd1 _04301_ sky130_fd_sc_hd__o21ai_1
X_06487_ cell0.CB_0.config_dataB\[4\] vssd1 vssd1 vccd1 vccd1 _01557_ sky130_fd_sc_hd__inv_2
XTAP_TAPCELL_ROW_23_659 vssd1 vccd1 sky130_fd_sc_hd__tapvpwrvgnd_1
XFILLER_32_26 vssd1 vssd1 vccd1 vccd1 sky130_fd_sc_hd__fill_2
X_08226_ net535 net537 vssd1 vssd1 vccd1 vccd1 _03266_ sky130_fd_sc_hd__and2b_1
X_08157_ _03196_ vssd1 vssd1 vccd1 vccd1 _03197_ sky130_fd_sc_hd__inv_2
XANTENNA_fanout301_X net301 vssd1 vssd1 vccd1 vccd1 sky130_fd_sc_hd__diode_2
X_07108_ cell0.SB0.route_sel\[77\] _01469_ cell0.SB0.route_sel\[74\] cell0.SB0.route_sel\[75\]
+ _02170_ vssd1 vssd1 vccd1 vccd1 _02171_ sky130_fd_sc_hd__o221a_2
XANTENNA__07063__B1 bus2_0\[9\] vssd1 vssd1 vccd1 vccd1 sky130_fd_sc_hd__diode_2
XANTENNA_fanout882_A net883 vssd1 vssd1 vccd1 vccd1 sky130_fd_sc_hd__diode_2
X_08088_ _02902_ _03125_ _03126_ _02905_ cell0.CB_0.config_dataB\[17\] vssd1 vssd1
+ vccd1 vccd1 _03130_ sky130_fd_sc_hd__a221o_1
X_07039_ net310 _02101_ vssd1 vssd1 vccd1 vccd1 _02104_ sky130_fd_sc_hd__nand2_1
XFILLER_0_502 vssd1 vssd1 vccd1 vccd1 sky130_fd_sc_hd__fill_2
XFILLER_0_513 vssd1 vssd1 vccd1 vccd1 sky130_fd_sc_hd__fill_1
X_10050_ net401 _04498_ vssd1 vssd1 vccd1 vccd1 _05054_ sky130_fd_sc_hd__nand2_1
XFILLER_0_535 vssd1 vssd1 vccd1 vccd1 sky130_fd_sc_hd__fill_1
XFILLER_48_517 vssd1 vssd1 vccd1 vccd1 sky130_fd_sc_hd__fill_1
XANTENNA_fanout768_X net768 vssd1 vssd1 vccd1 vccd1 sky130_fd_sc_hd__diode_2
XTAP_TAPCELL_ROW_141_2419 vssd1 vccd1 sky130_fd_sc_hd__tapvpwrvgnd_1
XFILLER_63_509 vssd1 vssd1 vccd1 vccd1 sky130_fd_sc_hd__fill_2
XTAP_TAPCELL_ROW_3_351 vssd1 vccd1 sky130_fd_sc_hd__tapvpwrvgnd_1
XANTENNA__08315__A0 bus1_0\[0\] vssd1 vssd1 vccd1 vccd1 sky130_fd_sc_hd__diode_2
X_10952_ net45 _05857_ _05862_ net46 cell3.CB_0.config_dataA\[3\] vssd1 vssd1 vccd1
+ vccd1 _05906_ sky130_fd_sc_hd__a221o_1
XANTENNA__10122__A0 net61 vssd1 vssd1 vccd1 vccd1 sky130_fd_sc_hd__diode_2
XFILLER_113_51 vssd1 vssd1 vccd1 vccd1 sky130_fd_sc_hd__fill_4
X_13740_ clknet_leaf_105_clk _00712_ net658 vssd1 vssd1 vccd1 vccd1 cell1.SB0.route_sel\[17\]
+ sky130_fd_sc_hd__dfstp_1
XFILLER_73_55 vssd1 vssd1 vccd1 vccd1 sky130_fd_sc_hd__fill_1
X_10883_ cell3.LE_1B.config_data\[10\] cell3.LE_1B.config_data\[11\] net292 vssd1
+ vssd1 vccd1 vccd1 _05839_ sky130_fd_sc_hd__mux2_1
X_13671_ clknet_leaf_14_clk _00643_ net631 vssd1 vssd1 vccd1 vccd1 cell2.CB_1.config_dataA\[23\]
+ sky130_fd_sc_hd__dfstp_1
X_12622_ cell3.SB0.route_sel\[87\] cell3.SB0.route_sel\[86\] net910 vssd1 vssd1 vccd1
+ vccd1 _01051_ sky130_fd_sc_hd__mux2_1
XTAP_TAPCELL_ROW_65_1281 vssd1 vccd1 sky130_fd_sc_hd__tapvpwrvgnd_1
XANTENNA__06764__A bus2_0\[11\] vssd1 vssd1 vccd1 vccd1 sky130_fd_sc_hd__diode_2
XTAP_TAPCELL_ROW_42_935 vssd1 vccd1 sky130_fd_sc_hd__tapvpwrvgnd_1
XANTENNA__09291__A1 net42 vssd1 vssd1 vccd1 vccd1 sky130_fd_sc_hd__diode_2
X_12553_ cell3.SB0.route_sel\[18\] cell3.SB0.route_sel\[17\] net919 vssd1 vssd1 vccd1
+ vccd1 _00982_ sky130_fd_sc_hd__mux2_1
XANTENNA__08094__A2 bus2_0\[2\] vssd1 vssd1 vccd1 vccd1 sky130_fd_sc_hd__diode_2
XFILLER_24_491 vssd1 vssd1 vccd1 vccd1 sky130_fd_sc_hd__fill_1
X_11504_ _06336_ _04442_ vssd1 vssd1 vccd1 vccd1 net243 sky130_fd_sc_hd__and2b_1
XFILLER_12_686 vssd1 vssd1 vccd1 vccd1 sky130_fd_sc_hd__fill_2
X_12484_ net755 _05276_ vssd1 vssd1 vccd1 vccd1 _06384_ sky130_fd_sc_hd__nand2_1
X_14223_ clknet_leaf_15_clk _01195_ net624 vssd1 vssd1 vccd1 vccd1 cell2.SB0.route_sel\[8\]
+ sky130_fd_sc_hd__dfstp_1
XFILLER_8_657 vccd1 vssd1 vccd1 vssd1 sky130_ef_sc_hd__decap_40_12
XANTENNA__10189__A0 net36 vssd1 vssd1 vccd1 vccd1 sky130_fd_sc_hd__diode_2
XANTENNA__09794__B _04608_ vssd1 vssd1 vccd1 vccd1 sky130_fd_sc_hd__diode_2
XANTENNA__10573__X _05531_ vssd1 vssd1 vccd1 vccd1 sky130_fd_sc_hd__diode_2
XANTENNA__12705__S net940 vssd1 vssd1 vccd1 vccd1 sky130_fd_sc_hd__diode_2
X_11435_ _02557_ _06290_ vssd1 vssd1 vccd1 vccd1 net204 sky130_fd_sc_hd__and2b_1
XANTENNA_input64_X net64 vssd1 vssd1 vccd1 vccd1 sky130_fd_sc_hd__diode_2
XFILLER_138_81 vssd1 vssd1 vccd1 vccd1 sky130_fd_sc_hd__fill_2
XFILLER_137_393 vssd1 vssd1 vccd1 vccd1 sky130_fd_sc_hd__fill_1
X_11366_ net748 cell3.LE_0A.reset_mode vssd1 vssd1 vccd1 vccd1 _11366_/X sky130_fd_sc_hd__xor2_2
X_14154_ clknet_leaf_70_clk _01126_ net730 vssd1 vssd1 vccd1 vccd1 cell3.CB_1.config_dataA\[14\]
+ sky130_fd_sc_hd__dfstp_1
XFILLER_98_41 vccd1 vssd1 vccd1 vssd1 sky130_ef_sc_hd__decap_40_12
XANTENNA__09594__A2 _02311_ vssd1 vssd1 vccd1 vccd1 sky130_fd_sc_hd__diode_2
XPHY_EDGE_ROW_60_Left_203 vssd1 vssd1 vccd1 vccd1 sky130_fd_sc_hd__decap_3
XFILLER_4_830 vssd1 vssd1 vccd1 vccd1 sky130_fd_sc_hd__fill_1
X_10317_ net435 _05144_ vssd1 vssd1 vccd1 vccd1 _05316_ sky130_fd_sc_hd__nand2_1
XFILLER_125_577 vssd1 vssd1 vccd1 vccd1 sky130_fd_sc_hd__fill_1
XFILLER_98_85 vssd1 vssd1 vccd1 vccd1 sky130_fd_sc_hd__fill_2
X_11297_ _01826_ _05501_ _04308_ vssd1 vssd1 vccd1 vccd1 _06213_ sky130_fd_sc_hd__mux2_1
X_14085_ clknet_leaf_84_clk _01057_ net675 vssd1 vssd1 vccd1 vccd1 cell3.SB0.route_sel\[93\]
+ sky130_fd_sc_hd__dfstp_1
X_13105_ clknet_leaf_5_clk _00077_ net566 vssd1 vssd1 vccd1 vccd1 cell0.CB_0.config_dataA\[7\]
+ sky130_fd_sc_hd__dfstp_1
XFILLER_3_362 vccd1 vssd1 vccd1 vssd1 sky130_ef_sc_hd__decap_40_12
X_10248_ _05238_ _05242_ _05248_ _01773_ _05247_ vssd1 vssd1 vccd1 vccd1 _05249_ sky130_fd_sc_hd__a221o_1
XANTENNA__09346__A2 _04362_ vssd1 vssd1 vccd1 vccd1 sky130_fd_sc_hd__diode_2
X_13036_ clknet_leaf_120_clk net1257 net596 vssd1 vssd1 vccd1 vccd1 cell0.LE_1B.config_data\[8\]
+ sky130_fd_sc_hd__dfrtp_1
XANTENNA__10361__A0 net33 vssd1 vssd1 vccd1 vccd1 sky130_fd_sc_hd__diode_2
XFILLER_121_783 vssd1 vssd1 vccd1 vccd1 sky130_fd_sc_hd__fill_1
X_10179_ net33 net44 net55 net58 net422 net420 vssd1 vssd1 vccd1 vccd1 _05180_ sky130_fd_sc_hd__mux4_1
XFILLER_94_645 vssd1 vssd1 vccd1 vccd1 sky130_fd_sc_hd__fill_1
XFILLER_93_122 vssd1 vssd1 vccd1 vccd1 sky130_fd_sc_hd__fill_2
X_13938_ clknet_leaf_43_clk _00910_ net627 vssd1 vssd1 vccd1 vccd1 cell2.LE_0A.edge_mode
+ sky130_fd_sc_hd__dfstp_1
XFILLER_62_520 vssd1 vssd1 vccd1 vccd1 sky130_fd_sc_hd__fill_1
X_13869_ clknet_leaf_17_clk _00841_ net628 vssd1 vssd1 vccd1 vccd1 cell2.CB_1.config_dataB\[18\]
+ sky130_fd_sc_hd__dfstp_1
X_06410_ cell0.SB0.route_sel\[108\] vssd1 vssd1 vccd1 vccd1 _01480_ sky130_fd_sc_hd__inv_2
X_07390_ cell1.SB0.route_sel\[106\] _01544_ cell1.SB0.route_sel\[109\] _01545_ _02445_
+ vssd1 vssd1 vccd1 vccd1 _02446_ sky130_fd_sc_hd__a221o_1
XANTENNA__08609__B2 _03473_ vssd1 vssd1 vccd1 vccd1 sky130_fd_sc_hd__diode_2
XANTENNA__08609__A1 _03477_ vssd1 vssd1 vccd1 vccd1 sky130_fd_sc_hd__diode_2
X_09060_ cell1.CB_0.config_dataB\[11\] net480 vssd1 vssd1 vccd1 vccd1 _04090_ sky130_fd_sc_hd__nor2_1
XTAP_TAPCELL_ROW_20_607 vssd1 vccd1 sky130_fd_sc_hd__tapvpwrvgnd_1
XANTENNA__07293__B1 _02346_ vssd1 vssd1 vccd1 vccd1 sky130_fd_sc_hd__diode_2
XFILLER_30_472 vssd1 vssd1 vccd1 vccd1 sky130_fd_sc_hd__fill_1
XFILLER_136_809 vssd1 vssd1 vccd1 vccd1 sky130_fd_sc_hd__fill_2
X_08011_ cell0.CB_0.config_dataB\[9\] _03039_ _03052_ vssd1 vssd1 vccd1 vccd1 _03053_
+ sky130_fd_sc_hd__nand3b_1
XANTENNA__07832__A2 _02235_ vssd1 vssd1 vccd1 vccd1 sky130_fd_sc_hd__diode_2
XFILLER_8_83 vssd1 vssd1 vccd1 vccd1 sky130_fd_sc_hd__fill_1
XFILLER_118_29 vccd1 vssd1 vccd1 vssd1 sky130_ef_sc_hd__decap_40_12
XTAP_TAPCELL_ROW_96_1753 vssd1 vccd1 sky130_fd_sc_hd__tapvpwrvgnd_1
XTAP_TAPCELL_ROW_96_1742 vssd1 vccd1 sky130_fd_sc_hd__tapvpwrvgnd_1
XFILLER_116_533 vssd1 vssd1 vccd1 vccd1 sky130_fd_sc_hd__fill_1
XANTENNA__11298__Y net143 vssd1 vssd1 vccd1 vccd1 sky130_fd_sc_hd__diode_2
XANTENNA__08388__A3 bus1_0\[15\] vssd1 vssd1 vccd1 vccd1 sky130_fd_sc_hd__diode_2
X_09962_ net406 _04498_ vssd1 vssd1 vccd1 vccd1 _04966_ sky130_fd_sc_hd__nand2_1
X_08913_ cell1.CB_0.config_dataA\[13\] cell1.CB_0.config_dataA\[12\] vssd1 vssd1 vccd1
+ vccd1 _03945_ sky130_fd_sc_hd__nor2_1
X_09893_ net438 _04498_ _04898_ vssd1 vssd1 vccd1 vccd1 _04899_ sky130_fd_sc_hd__a21o_1
XANTENNA_fanout296_A cell3.CB_1.le_outA vssd1 vssd1 vccd1 vccd1 sky130_fd_sc_hd__diode_2
X_08844_ cell1.CB_0.config_dataA\[8\] cell1.CB_0.config_dataA\[7\] _03875_ vssd1 vssd1
+ vccd1 vccd1 _03876_ sky130_fd_sc_hd__o21ai_1
XANTENNA__07952__B _02301_ vssd1 vssd1 vccd1 vccd1 sky130_fd_sc_hd__diode_2
XPHY_EDGE_ROW_108_Left_251 vssd1 vssd1 vccd1 vccd1 sky130_fd_sc_hd__decap_3
X_08775_ cell1.LE_1B.config_data\[11\] cell1.LE_1B.config_data\[10\] _03735_ vssd1
+ vssd1 vccd1 vccd1 _03809_ sky130_fd_sc_hd__mux2_1
XFILLER_27_15 vccd1 vssd1 vccd1 vssd1 sky130_ef_sc_hd__decap_40_12
X_07726_ _01970_ _02646_ vssd1 vssd1 vccd1 vccd1 _02773_ sky130_fd_sc_hd__or2_1
XTAP_TAPCELL_ROW_0_310 vssd1 vccd1 sky130_fd_sc_hd__tapvpwrvgnd_1
XTAP_TAPCELL_ROW_28_729 vssd1 vccd1 sky130_fd_sc_hd__tapvpwrvgnd_1
XTAP_TAPCELL_ROW_123_2149 vssd1 vccd1 sky130_fd_sc_hd__tapvpwrvgnd_1
XANTENNA__09512__X _04532_ vssd1 vssd1 vccd1 vccd1 sky130_fd_sc_hd__diode_2
XFILLER_53_553 vssd1 vssd1 vccd1 vccd1 sky130_fd_sc_hd__fill_1
X_07657_ cell0.SB0.route_sel\[19\] cell0.SB0.route_sel\[18\] vssd1 vssd1 vccd1 vccd1
+ _02705_ sky130_fd_sc_hd__nand2_1
XANTENNA_fanout349_X net349 vssd1 vssd1 vccd1 vccd1 sky130_fd_sc_hd__diode_2
XTAP_TAPCELL_ROW_105_1882 vssd1 vccd1 sky130_fd_sc_hd__tapvpwrvgnd_1
X_06608_ cell1.CB_0.config_dataA\[2\] vssd1 vssd1 vccd1 vccd1 _01678_ sky130_fd_sc_hd__inv_2
XFILLER_43_36 vssd1 vssd1 vccd1 vccd1 sky130_fd_sc_hd__fill_1
XFILLER_41_737 vssd1 vssd1 vccd1 vccd1 sky130_fd_sc_hd__fill_1
X_07588_ net72 _02635_ vssd1 vssd1 vccd1 vccd1 _02638_ sky130_fd_sc_hd__nand2_1
XANTENNA__10407__B2 net59 vssd1 vssd1 vccd1 vccd1 sky130_fd_sc_hd__diode_2
XANTENNA__10407__A1 net60 vssd1 vssd1 vccd1 vccd1 sky130_fd_sc_hd__diode_2
X_09327_ _04329_ _04349_ _04351_ vssd1 vssd1 vccd1 vccd1 _04352_ sky130_fd_sc_hd__o21ai_1
XANTENNA__08076__A2 net350 vssd1 vssd1 vccd1 vccd1 sky130_fd_sc_hd__diode_2
X_06539_ cell0.SB0.route_sel\[43\] vssd1 vssd1 vccd1 vccd1 _01609_ sky130_fd_sc_hd__inv_2
XANTENNA__07284__B1 bus2_0\[12\] vssd1 vssd1 vccd1 vccd1 sky130_fd_sc_hd__diode_2
XTAP_TAPCELL_ROW_138_2381 vssd1 vccd1 sky130_fd_sc_hd__tapvpwrvgnd_1
XPHY_EDGE_ROW_117_Left_260 vssd1 vssd1 vccd1 vccd1 sky130_fd_sc_hd__decap_3
X_09258_ cell2.SB0.route_sel\[19\] cell2.SB0.route_sel\[18\] _04283_ vssd1 vssd1 vccd1
+ vccd1 _04284_ sky130_fd_sc_hd__a21oi_1
XANTENNA__11489__X net237 vssd1 vssd1 vccd1 vccd1 sky130_fd_sc_hd__diode_2
XFILLER_119_360 vssd1 vssd1 vccd1 vccd1 sky130_fd_sc_hd__fill_1
X_09189_ net381 cell3.CB_0.config_dataB\[23\] _04215_ vssd1 vssd1 vccd1 vccd1 _04217_
+ sky130_fd_sc_hd__or3_1
X_08209_ _03245_ _03248_ vssd1 vssd1 vccd1 vccd1 _03249_ sky130_fd_sc_hd__or2_1
X_11220_ net285 net280 net297 net290 cell3.LEI0.config_data\[39\] cell3.LEI0.config_data\[40\]
+ vssd1 vssd1 vccd1 vccd1 _06172_ sky130_fd_sc_hd__mux4_1
XFILLER_4_137 vssd1 vssd1 vccd1 vccd1 sky130_fd_sc_hd__fill_2
XFILLER_134_363 vssd1 vssd1 vccd1 vccd1 sky130_fd_sc_hd__fill_1
X_11151_ _05921_ _06080_ _06101_ net386 cell3.CB_0.config_dataB\[7\] vssd1 vssd1 vccd1
+ vccd1 _06103_ sky130_fd_sc_hd__a221o_1
XFILLER_107_588 vssd1 vssd1 vccd1 vccd1 sky130_fd_sc_hd__fill_2
XANTENNA__12580__A1 cell3.SB0.route_sel\[44\] vssd1 vssd1 vccd1 vccd1 sky130_fd_sc_hd__diode_2
XTAP_TAPCELL_ROW_8_421 vssd1 vccd1 sky130_fd_sc_hd__tapvpwrvgnd_1
X_10102_ _02603_ _05102_ vssd1 vssd1 vccd1 vccd1 _05103_ sky130_fd_sc_hd__nand2_4
XTAP_TAPCELL_ROW_8_432 vssd1 vccd1 sky130_fd_sc_hd__tapvpwrvgnd_1
X_11082_ _06035_ _06034_ _05961_ vssd1 vssd1 vccd1 vccd1 _06036_ sky130_fd_sc_hd__mux2_1
XFILLER_0_343 vssd1 vssd1 vccd1 vccd1 sky130_fd_sc_hd__fill_2
XANTENNA__10343__A0 net313 vssd1 vssd1 vccd1 vccd1 sky130_fd_sc_hd__diode_2
X_10033_ net400 _04608_ vssd1 vssd1 vccd1 vccd1 _05037_ sky130_fd_sc_hd__nand2_1
XFILLER_75_111 vssd1 vssd1 vccd1 vccd1 sky130_fd_sc_hd__fill_1
XANTENNA__06759__A cell0.CB_1.le_outA vssd1 vssd1 vccd1 vccd1 sky130_fd_sc_hd__diode_2
XFILLER_0_365 vssd1 vssd1 vccd1 vccd1 sky130_fd_sc_hd__fill_4
XFILLER_0_376 vssd1 vssd1 vccd1 vccd1 sky130_fd_sc_hd__fill_4
XANTENNA_input24_A CBeast_in[30] vssd1 vssd1 vccd1 vccd1 sky130_fd_sc_hd__diode_2
XFILLER_102_282 vssd1 vssd1 vccd1 vccd1 sky130_fd_sc_hd__fill_1
XFILLER_84_21 vssd1 vssd1 vccd1 vccd1 sky130_fd_sc_hd__fill_4
XANTENNA__11384__B _01874_ vssd1 vssd1 vccd1 vccd1 sky130_fd_sc_hd__diode_2
XFILLER_91_615 vssd1 vssd1 vccd1 vccd1 sky130_fd_sc_hd__fill_1
XFILLER_75_166 vssd1 vssd1 vccd1 vccd1 sky130_fd_sc_hd__fill_2
XTAP_TAPCELL_ROW_67_1310 vssd1 vccd1 sky130_fd_sc_hd__tapvpwrvgnd_1
XFILLER_29_561 vssd1 vssd1 vccd1 vccd1 sky130_fd_sc_hd__fill_2
X_11984_ cell0.SB0.route_sel\[90\] cell0.SB0.route_sel\[89\] net791 vssd1 vssd1 vccd1
+ vccd1 _00421_ sky130_fd_sc_hd__mux2_1
XANTENNA__10646__A1 net22 vssd1 vssd1 vccd1 vccd1 sky130_fd_sc_hd__diode_2
X_10935_ cell3.SB0.route_sel\[59\] cell3.SB0.route_sel\[58\] cell3.SB0.route_sel\[62\]
+ _01715_ _05888_ vssd1 vssd1 vccd1 vccd1 _05889_ sky130_fd_sc_hd__o221a_1
XANTENNA__08693__B _03509_ vssd1 vssd1 vccd1 vccd1 sky130_fd_sc_hd__diode_2
X_13723_ clknet_leaf_102_clk _00695_ net676 vssd1 vssd1 vccd1 vccd1 cell1.SB0.route_sel\[0\]
+ sky130_fd_sc_hd__dfstp_1
XFILLER_32_704 vssd1 vssd1 vccd1 vccd1 sky130_fd_sc_hd__fill_1
XANTENNA__07511__A1 cell1.SB0.config_data_out vssd1 vssd1 vccd1 vccd1 sky130_fd_sc_hd__diode_2
X_13654_ clknet_leaf_53_clk _00626_ net714 vssd1 vssd1 vccd1 vccd1 cell2.CB_1.config_dataA\[6\]
+ sky130_fd_sc_hd__dfstp_1
X_10866_ _05510_ _05798_ _05820_ net364 cell3.CB_1.config_dataB\[17\] vssd1 vssd1
+ vccd1 vccd1 _05822_ sky130_fd_sc_hd__a221o_1
XTAP_TAPCELL_ROW_80_1510 vssd1 vccd1 sky130_fd_sc_hd__tapvpwrvgnd_1
XFILLER_90_9 vccd1 vssd1 vccd1 vssd1 sky130_ef_sc_hd__decap_40_12
X_12605_ cell3.SB0.route_sel\[70\] cell3.SB0.route_sel\[69\] net909 vssd1 vssd1 vccd1
+ vccd1 _01034_ sky130_fd_sc_hd__mux2_1
XFILLER_129_113 vssd1 vssd1 vccd1 vccd1 sky130_fd_sc_hd__fill_1
X_10797_ net286 net279 cell3.LEI0.config_data\[21\] vssd1 vssd1 vccd1 vccd1 _05753_
+ sky130_fd_sc_hd__mux2_1
XANTENNA__09803__A3 bus3_2\[3\] vssd1 vssd1 vccd1 vccd1 sky130_fd_sc_hd__diode_2
X_13585_ clknet_leaf_88_clk _00557_ net697 vssd1 vssd1 vccd1 vccd1 cell1.LEI0.config_data\[6\]
+ sky130_fd_sc_hd__dfrtp_1
X_12536_ cell3.SB0.route_sel\[1\] cell3.SB0.route_sel\[0\] net935 vssd1 vssd1 vccd1
+ vccd1 _00965_ sky130_fd_sc_hd__mux2_1
XFILLER_8_432 vccd1 vssd1 vccd1 vssd1 sky130_ef_sc_hd__decap_40_12
X_12467_ net1055 cell2.LE_0A.config_data\[3\] net813 vssd1 vssd1 vccd1 vccd1 _00897_
+ sky130_fd_sc_hd__mux2_1
XFILLER_8_498 vssd1 vssd1 vccd1 vccd1 sky130_fd_sc_hd__fill_1
X_14206_ clknet_leaf_55_clk _01178_ net719 vssd1 vssd1 vccd1 vccd1 cell3.CB_0.config_dataA\[16\]
+ sky130_fd_sc_hd__dfstp_1
XTAP_TAPCELL_ROW_78_1472 vssd1 vccd1 sky130_fd_sc_hd__tapvpwrvgnd_1
X_11418_ cell0.SB0.route_sel\[96\] cell0.SB0.route_sel\[97\] vssd1 vssd1 vccd1 vccd1
+ _06279_ sky130_fd_sc_hd__nor2_1
X_14137_ clknet_leaf_66_clk _01109_ net743 vssd1 vssd1 vccd1 vccd1 cell3.LE_1B.edge_mode
+ sky130_fd_sc_hd__dfstp_1
X_12398_ cell2.CB_1.config_dataB\[8\] cell2.CB_1.config_dataB\[7\] net848 vssd1 vssd1
+ vccd1 vccd1 _00831_ sky130_fd_sc_hd__mux2_1
XTAP_TAPCELL_ROW_78_1483 vssd1 vccd1 sky130_fd_sc_hd__tapvpwrvgnd_1
XFILLER_141_845 vssd1 vssd1 vccd1 vccd1 sky130_fd_sc_hd__fill_2
X_11349_ _01825_ _05871_ _04624_ vssd1 vssd1 vccd1 vccd1 _06240_ sky130_fd_sc_hd__mux2_1
XFILLER_4_693 vssd1 vssd1 vccd1 vccd1 sky130_fd_sc_hd__fill_4
XFILLER_3_181 vccd1 vssd1 vccd1 vssd1 sky130_ef_sc_hd__decap_40_12
XTAP_TAPCELL_ROW_91_1672 vssd1 vccd1 sky130_fd_sc_hd__tapvpwrvgnd_1
X_14068_ clknet_leaf_14_clk _01040_ net599 vssd1 vssd1 vccd1 vccd1 cell3.SB0.route_sel\[76\]
+ sky130_fd_sc_hd__dfstp_1
XANTENNA__08501__X _03537_ vssd1 vssd1 vccd1 vccd1 sky130_fd_sc_hd__diode_2
X_13019_ net1424 net1426 net949 vssd1 vssd1 vccd1 vccd1 _01447_ sky130_fd_sc_hd__mux2_1
X_06890_ cell1.SB0.route_sel\[61\] cell1.SB0.route_sel\[60\] vssd1 vssd1 vccd1 vccd1
+ _01958_ sky130_fd_sc_hd__nand2_1
XFILLER_67_667 vssd1 vssd1 vccd1 vccd1 sky130_fd_sc_hd__fill_1
XFILLER_94_486 vssd1 vssd1 vccd1 vccd1 sky130_fd_sc_hd__fill_2
XFILLER_82_637 vssd1 vssd1 vccd1 vccd1 sky130_fd_sc_hd__fill_2
XFILLER_82_648 vssd1 vssd1 vccd1 vccd1 sky130_fd_sc_hd__fill_1
X_08560_ _03590_ _03593_ _03595_ cell1.CB_1.config_dataA\[12\] vssd1 vssd1 vccd1 vccd1
+ _03596_ sky130_fd_sc_hd__o22a_1
X_08491_ cell1.SB0.route_sel\[61\] cell1.SB0.route_sel\[60\] vssd1 vssd1 vccd1 vccd1
+ _03527_ sky130_fd_sc_hd__or2_1
X_07511_ cell1.SB0.config_data_out cell1.SB0.route_sel\[126\] _02542_ _02562_ vssd1
+ vssd1 vccd1 vccd1 _02563_ sky130_fd_sc_hd__a211oi_1
XFILLER_22_203 vssd1 vssd1 vccd1 vccd1 sky130_fd_sc_hd__fill_1
X_07442_ _02474_ net266 _02493_ _02475_ vssd1 vssd1 vccd1 vccd1 _02496_ sky130_fd_sc_hd__a31o_1
XFILLER_50_567 vssd1 vssd1 vccd1 vccd1 sky130_fd_sc_hd__fill_1
X_07373_ _02407_ _02426_ _02428_ vssd1 vssd1 vccd1 vccd1 _02429_ sky130_fd_sc_hd__a21bo_1
XANTENNA__11062__A1 net45 vssd1 vssd1 vccd1 vccd1 sky130_fd_sc_hd__diode_2
X_09112_ _03894_ _04128_ _04129_ _03890_ vssd1 vssd1 vccd1 vccd1 _04142_ sky130_fd_sc_hd__a22o_1
XFILLER_50_589 vssd1 vssd1 vccd1 vccd1 sky130_fd_sc_hd__fill_1
XFILLER_13_39 vccd1 vssd1 vccd1 vssd1 sky130_ef_sc_hd__decap_40_12
XTAP_TAPCELL_ROW_33_798 vssd1 vccd1 sky130_fd_sc_hd__tapvpwrvgnd_1
XANTENNA__11062__B2 net46 vssd1 vssd1 vccd1 vccd1 sky130_fd_sc_hd__diode_2
XFILLER_129_39 vccd1 vssd1 vccd1 vssd1 sky130_ef_sc_hd__decap_40_12
XANTENNA__07805__A2 _02847_ vssd1 vssd1 vccd1 vccd1 sky130_fd_sc_hd__diode_2
X_09043_ _01669_ _04070_ _04072_ vssd1 vssd1 vccd1 vccd1 _04073_ sky130_fd_sc_hd__a21oi_1
XPHY_EDGE_ROW_111_Right_111 vssd1 vssd1 vccd1 vccd1 sky130_fd_sc_hd__decap_3
Xhold410 cell0.LE_0B.config_data\[9\] vssd1 vssd1 vccd1 vccd1 net1369 sky130_fd_sc_hd__dlygate4sd3_1
Xhold443 _01426_ vssd1 vssd1 vccd1 vccd1 net1402 sky130_fd_sc_hd__dlygate4sd3_1
Xhold432 cell2.LE_1A.config_data\[15\] vssd1 vssd1 vccd1 vccd1 net1391 sky130_fd_sc_hd__dlygate4sd3_1
XANTENNA_clkbuf_4_6_0_clk_X clknet_4_6_0_clk vssd1 vssd1 vccd1 vccd1 sky130_fd_sc_hd__diode_2
XANTENNA__10168__A3 _05139_ vssd1 vssd1 vccd1 vccd1 sky130_fd_sc_hd__diode_2
Xhold454 cell0.LE_0B.config_data\[14\] vssd1 vssd1 vccd1 vccd1 net1413 sky130_fd_sc_hd__dlygate4sd3_1
Xhold421 cell1.LEI0.config_data\[29\] vssd1 vssd1 vccd1 vccd1 net1380 sky130_fd_sc_hd__dlygate4sd3_1
Xhold465 cell3.LEI0.config_data\[40\] vssd1 vssd1 vccd1 vccd1 net1424 sky130_fd_sc_hd__dlygate4sd3_1
XFILLER_116_385 vssd1 vssd1 vccd1 vccd1 sky130_fd_sc_hd__fill_1
XFILLER_89_225 vssd1 vssd1 vccd1 vccd1 sky130_fd_sc_hd__fill_2
Xhold476 cell0.LEI0.config_data\[13\] vssd1 vssd1 vccd1 vccd1 net1435 sky130_fd_sc_hd__dlygate4sd3_1
XANTENNA__08230__A2 _02494_ vssd1 vssd1 vccd1 vccd1 sky130_fd_sc_hd__diode_2
Xhold487 cell1.LEI0.config_data\[10\] vssd1 vssd1 vccd1 vccd1 net1446 sky130_fd_sc_hd__dlygate4sd3_1
Xfanout934 net959 vssd1 vssd1 vccd1 vccd1 net934 sky130_fd_sc_hd__buf_2
Xhold498 cell3.LEI0.config_data\[25\] vssd1 vssd1 vccd1 vccd1 net1457 sky130_fd_sc_hd__dlygate4sd3_1
XANTENNA__11117__A2 _04362_ vssd1 vssd1 vccd1 vccd1 sky130_fd_sc_hd__diode_2
Xfanout923 net934 vssd1 vssd1 vccd1 vccd1 net923 sky130_fd_sc_hd__clkbuf_2
X_09945_ net410 _04583_ _04948_ net408 vssd1 vssd1 vccd1 vccd1 _04949_ sky130_fd_sc_hd__o211a_1
Xfanout912 net916 vssd1 vssd1 vccd1 vccd1 net912 sky130_fd_sc_hd__clkbuf_2
XANTENNA__09507__X _04527_ vssd1 vssd1 vccd1 vccd1 sky130_fd_sc_hd__diode_2
Xfanout901 net907 vssd1 vssd1 vccd1 vccd1 net901 sky130_fd_sc_hd__clkbuf_4
XANTENNA_fanout580_A net581 vssd1 vssd1 vccd1 vccd1 sky130_fd_sc_hd__diode_2
XANTENNA__10325__A0 net33 vssd1 vssd1 vccd1 vccd1 sky130_fd_sc_hd__diode_2
Xfanout956 net958 vssd1 vssd1 vccd1 vccd1 net956 sky130_fd_sc_hd__clkbuf_2
Xfanout945 net952 vssd1 vssd1 vccd1 vccd1 net945 sky130_fd_sc_hd__clkbuf_4
XFILLER_98_770 vssd1 vssd1 vccd1 vccd1 sky130_fd_sc_hd__fill_1
X_09876_ _04881_ vssd1 vssd1 vccd1 vccd1 _04882_ sky130_fd_sc_hd__inv_2
XANTENNA_fanout678_A net684 vssd1 vssd1 vccd1 vccd1 sky130_fd_sc_hd__diode_2
XANTENNA__08533__A3 net3 vssd1 vssd1 vccd1 vccd1 sky130_fd_sc_hd__diode_2
X_08827_ _01511_ cell1.SB0.route_sel\[31\] vssd1 vssd1 vccd1 vccd1 _03859_ sky130_fd_sc_hd__nand2_1
XANTENNA_fanout845_A net855 vssd1 vssd1 vccd1 vccd1 sky130_fd_sc_hd__diode_2
XTAP_TAPCELL_ROW_107_1911 vssd1 vccd1 sky130_fd_sc_hd__tapvpwrvgnd_1
XFILLER_73_615 vssd1 vssd1 vccd1 vccd1 sky130_fd_sc_hd__fill_1
XFILLER_18_509 vssd1 vssd1 vccd1 vccd1 sky130_fd_sc_hd__fill_2
X_08758_ net452 _03529_ vssd1 vssd1 vccd1 vccd1 _03792_ sky130_fd_sc_hd__nand2_1
XANTENNA__10628__A1 net16 vssd1 vssd1 vccd1 vccd1 sky130_fd_sc_hd__diode_2
X_07709_ _02754_ _02755_ _02753_ vssd1 vssd1 vccd1 vccd1 _02756_ sky130_fd_sc_hd__a21oi_2
XTAP_TAPCELL_ROW_49_1040 vssd1 vccd1 sky130_fd_sc_hd__tapvpwrvgnd_1
X_08689_ net29 net30 net462 vssd1 vssd1 vccd1 vccd1 _03723_ sky130_fd_sc_hd__mux2_1
X_10720_ _05638_ _05640_ _05676_ _05677_ vssd1 vssd1 vccd1 vccd1 _05678_ sky130_fd_sc_hd__o2bb2a_1
XFILLER_110_41 vssd1 vssd1 vccd1 vccd1 sky130_fd_sc_hd__fill_4
XTAP_TAPCELL_ROW_62_1240 vssd1 vccd1 sky130_fd_sc_hd__tapvpwrvgnd_1
X_10651_ _05531_ _05602_ _05603_ _05528_ _01790_ vssd1 vssd1 vccd1 vccd1 _05609_ sky130_fd_sc_hd__a221o_1
X_10582_ _04589_ _04595_ _04601_ _05539_ vssd1 vssd1 vccd1 vccd1 _05540_ sky130_fd_sc_hd__a211o_2
X_13370_ clknet_leaf_132_clk _00342_ net558 vssd1 vssd1 vccd1 vccd1 cell0.SB0.route_sel\[11\]
+ sky130_fd_sc_hd__dfstp_1
XFILLER_139_499 vssd1 vssd1 vccd1 vccd1 sky130_fd_sc_hd__fill_1
XFILLER_127_617 vssd1 vssd1 vccd1 vccd1 sky130_fd_sc_hd__fill_1
XANTENNA__10564__A net272 vssd1 vssd1 vccd1 vccd1 sky130_fd_sc_hd__diode_2
X_12321_ cell1.SB0.route_sel\[59\] cell1.SB0.route_sel\[58\] net856 vssd1 vssd1 vccd1
+ vccd1 _00754_ sky130_fd_sc_hd__mux2_1
X_12252_ net413 cell2.CB_0.config_dataA\[14\] net823 vssd1 vssd1 vccd1 vccd1 _00685_
+ sky130_fd_sc_hd__mux2_1
X_11203_ _05921_ _06147_ _05924_ _06146_ vssd1 vssd1 vccd1 vccd1 _06155_ sky130_fd_sc_hd__o2bb2a_1
X_12183_ cell2.LE_1B.config_data\[16\] net1267 net851 vssd1 vssd1 vccd1 vccd1 _00616_
+ sky130_fd_sc_hd__mux2_1
XANTENNA_clkbuf_leaf_61_clk_A clknet_4_15_0_clk vssd1 vssd1 vccd1 vccd1 sky130_fd_sc_hd__diode_2
XANTENNA__08221__A2 net349 vssd1 vssd1 vccd1 vccd1 sky130_fd_sc_hd__diode_2
X_11134_ _06085_ vssd1 vssd1 vccd1 vccd1 _06086_ sky130_fd_sc_hd__inv_2
XFILLER_1_641 vccd1 vssd1 vccd1 vssd1 sky130_ef_sc_hd__decap_40_12
X_11065_ _05912_ _05916_ net373 vssd1 vssd1 vccd1 vccd1 _06019_ sky130_fd_sc_hd__mux2_1
XANTENNA__11108__A2 _05893_ vssd1 vssd1 vccd1 vccd1 sky130_fd_sc_hd__diode_2
XANTENNA__09706__C1 _04718_ vssd1 vssd1 vccd1 vccd1 sky130_fd_sc_hd__diode_2
XFILLER_1_685 vccd1 vssd1 vccd1 vssd1 sky130_ef_sc_hd__decap_40_12
XANTENNA__06783__A2 net361 vssd1 vssd1 vccd1 vccd1 sky130_fd_sc_hd__diode_2
X_10016_ net403 _04472_ _05019_ net402 vssd1 vssd1 vccd1 vccd1 _05020_ sky130_fd_sc_hd__o211a_1
XANTENNA_clkbuf_leaf_76_clk_A clknet_4_14_0_clk vssd1 vssd1 vccd1 vccd1 sky130_fd_sc_hd__diode_2
XANTENNA_input27_X net27 vssd1 vssd1 vccd1 vccd1 sky130_fd_sc_hd__diode_2
XFILLER_0_173 vssd1 vssd1 vccd1 vccd1 sky130_fd_sc_hd__fill_4
XFILLER_76_464 vssd1 vssd1 vccd1 vccd1 sky130_fd_sc_hd__fill_2
XFILLER_91_434 vssd1 vssd1 vccd1 vccd1 sky130_fd_sc_hd__fill_1
X_11967_ cell0.SB0.route_sel\[73\] cell0.SB0.route_sel\[72\] net766 vssd1 vssd1 vccd1
+ vccd1 _00404_ sky130_fd_sc_hd__mux2_1
X_13706_ clknet_leaf_28_clk _00678_ net617 vssd1 vssd1 vccd1 vccd1 cell2.CB_0.config_dataA\[8\]
+ sky130_fd_sc_hd__dfstp_1
X_10918_ _01731_ cell3.SB0.route_sel\[84\] vssd1 vssd1 vccd1 vccd1 _05872_ sky130_fd_sc_hd__nand2_1
XFILLER_17_586 vssd1 vssd1 vccd1 vccd1 sky130_fd_sc_hd__fill_1
XANTENNA__07391__A_N _02444_ vssd1 vssd1 vccd1 vccd1 sky130_fd_sc_hd__diode_2
X_11898_ cell0.SB0.route_sel\[4\] cell0.SB0.route_sel\[3\] net781 vssd1 vssd1 vccd1
+ vccd1 _00335_ sky130_fd_sc_hd__mux2_1
XANTENNA_clkbuf_leaf_134_clk_A clknet_4_0_0_clk vssd1 vssd1 vccd1 vccd1 sky130_fd_sc_hd__diode_2
XFILLER_32_545 vssd1 vssd1 vccd1 vccd1 sky130_fd_sc_hd__fill_1
X_13637_ clknet_leaf_38_clk _00609_ net647 vssd1 vssd1 vccd1 vccd1 cell2.LE_1B.config_data\[9\]
+ sky130_fd_sc_hd__dfrtp_1
X_10849_ _05549_ _05796_ _05799_ _05553_ vssd1 vssd1 vccd1 vccd1 _05805_ sky130_fd_sc_hd__o2bb2a_1
XFILLER_20_718 vssd1 vssd1 vccd1 vccd1 sky130_fd_sc_hd__fill_1
XANTENNA_clkbuf_leaf_14_clk_A clknet_4_3_0_clk vssd1 vssd1 vccd1 vccd1 sky130_fd_sc_hd__diode_2
X_13568_ clknet_leaf_118_clk net1142 net668 vssd1 vssd1 vccd1 vccd1 cell1.LE_0A.config_data\[11\]
+ sky130_fd_sc_hd__dfrtp_1
XFILLER_117_105 vssd1 vssd1 vccd1 vccd1 sky130_fd_sc_hd__fill_1
X_12519_ cell2.LEI0.config_data\[33\] net1095 net846 vssd1 vssd1 vccd1 vccd1 _00948_
+ sky130_fd_sc_hd__mux2_1
XANTENNA__08870__C _03901_ vssd1 vssd1 vccd1 vccd1 sky130_fd_sc_hd__diode_2
XFILLER_8_251 vssd1 vssd1 vccd1 vccd1 sky130_fd_sc_hd__fill_1
XTAP_TAPCELL_ROW_30_757 vssd1 vccd1 sky130_fd_sc_hd__tapvpwrvgnd_1
XFILLER_133_609 vssd1 vssd1 vccd1 vccd1 sky130_fd_sc_hd__fill_1
XTAP_TAPCELL_ROW_93_1701 vssd1 vccd1 sky130_fd_sc_hd__tapvpwrvgnd_1
XFILLER_8_295 vssd1 vssd1 vccd1 vccd1 sky130_fd_sc_hd__fill_2
XFILLER_8_284 vssd1 vssd1 vccd1 vccd1 sky130_fd_sc_hd__fill_2
X_13499_ clknet_leaf_98_clk _00471_ net683 vssd1 vssd1 vccd1 vccd1 cell1.CB_1.config_dataB\[12\]
+ sky130_fd_sc_hd__dfstp_2
XANTENNA_clkbuf_leaf_29_clk_A clknet_4_5_0_clk vssd1 vssd1 vccd1 vccd1 sky130_fd_sc_hd__diode_2
XFILLER_5_51 vssd1 vssd1 vccd1 vccd1 sky130_fd_sc_hd__fill_4
XFILLER_140_141 vssd1 vssd1 vccd1 vccd1 sky130_fd_sc_hd__fill_1
X_07991_ net530 _02235_ _03032_ net529 vssd1 vssd1 vccd1 vccd1 _03033_ sky130_fd_sc_hd__o211a_1
Xclkbuf_4_7_0_clk clknet_0_clk vssd1 vssd1 vccd1 vccd1 clknet_4_7_0_clk sky130_fd_sc_hd__clkbuf_8
XANTENNA__10921__B _05874_ vssd1 vssd1 vccd1 vccd1 sky130_fd_sc_hd__diode_2
X_09730_ net272 _04742_ vssd1 vssd1 vccd1 vccd1 bus3_1\[15\] sky130_fd_sc_hd__nor2_4
XFILLER_86_217 vssd1 vssd1 vccd1 vccd1 sky130_fd_sc_hd__fill_1
X_06942_ cell2.SB0.route_sel\[57\] cell2.SB0.route_sel\[56\] vssd1 vssd1 vccd1 vccd1
+ _02009_ sky130_fd_sc_hd__nand2b_1
XANTENNA__10858__A1 net16 vssd1 vssd1 vccd1 vccd1 sky130_fd_sc_hd__diode_2
X_09661_ _04668_ _04674_ _04675_ vssd1 vssd1 vccd1 vccd1 _04676_ sky130_fd_sc_hd__a21o_1
X_06873_ net94 _01939_ _01940_ vssd1 vssd1 vccd1 vccd1 _01941_ sky130_fd_sc_hd__a21oi_1
X_09592_ _01993_ _02084_ _02320_ _04607_ vssd1 vssd1 vccd1 vccd1 _04609_ sky130_fd_sc_hd__o211a_1
X_08612_ _03643_ _03646_ _03647_ cell1.CB_1.config_dataA\[18\] vssd1 vssd1 vccd1 vccd1
+ _03648_ sky130_fd_sc_hd__or4b_1
XTAP_TAPCELL_ROW_120_2108 vssd1 vccd1 sky130_fd_sc_hd__tapvpwrvgnd_1
XFILLER_82_456 vssd1 vssd1 vccd1 vccd1 sky130_fd_sc_hd__fill_1
X_08543_ cell1.LEI0.config_data\[18\] net323 vssd1 vssd1 vccd1 vccd1 _03579_ sky130_fd_sc_hd__nand2_1
XTAP_TAPCELL_ROW_38_879 vssd1 vccd1 sky130_fd_sc_hd__tapvpwrvgnd_1
XFILLER_35_383 vssd1 vssd1 vccd1 vccd1 sky130_fd_sc_hd__fill_1
XANTENNA__10368__B _05084_ vssd1 vssd1 vccd1 vccd1 sky130_fd_sc_hd__diode_2
XTAP_TAPCELL_ROW_102_1841 vssd1 vccd1 sky130_fd_sc_hd__tapvpwrvgnd_1
XTAP_TAPCELL_ROW_18_581 vssd1 vccd1 sky130_fd_sc_hd__tapvpwrvgnd_1
X_08474_ _03509_ vssd1 vssd1 vccd1 vccd1 _03510_ sky130_fd_sc_hd__inv_2
XFILLER_11_718 vssd1 vssd1 vccd1 vccd1 sky130_fd_sc_hd__fill_2
X_07425_ cell0.SB0.route_sel\[115\] cell0.SB0.route_sel\[114\] vssd1 vssd1 vccd1 vccd1
+ _02479_ sky130_fd_sc_hd__nand2_1
XFILLER_138_9 vccd1 vssd1 vccd1 vssd1 sky130_ef_sc_hd__decap_40_12
X_07356_ cell0.SB0.route_sel\[109\] cell0.SB0.route_sel\[108\] net69 vssd1 vssd1 vccd1
+ vccd1 _02412_ sky130_fd_sc_hd__a21boi_1
XTAP_TAPCELL_ROW_135_2340 vssd1 vccd1 sky130_fd_sc_hd__tapvpwrvgnd_1
X_07287_ cell0.SB0.route_sel\[96\] cell0.SB0.route_sel\[97\] _02344_ vssd1 vssd1 vccd1
+ vccd1 _02345_ sky130_fd_sc_hd__a21oi_1
X_09026_ _03890_ _04054_ _04055_ _03894_ _01669_ vssd1 vssd1 vccd1 vccd1 _04056_ sky130_fd_sc_hd__a221o_1
XFILLER_117_650 vssd1 vssd1 vccd1 vccd1 sky130_fd_sc_hd__fill_1
Xhold262 cell3.LE_1B.config_data\[2\] vssd1 vssd1 vccd1 vccd1 net1221 sky130_fd_sc_hd__dlygate4sd3_1
Xhold240 cell2.LE_1B.config_data\[7\] vssd1 vssd1 vccd1 vccd1 net1199 sky130_fd_sc_hd__dlygate4sd3_1
Xhold251 cell0.LE_0B.config_data\[7\] vssd1 vssd1 vccd1 vccd1 net1210 sky130_fd_sc_hd__dlygate4sd3_1
XANTENNA__09400__A1 cell3.SB0.route_sel\[44\] vssd1 vssd1 vccd1 vccd1 sky130_fd_sc_hd__diode_2
XANTENNA__09400__B2 _04422_ vssd1 vssd1 vccd1 vccd1 sky130_fd_sc_hd__diode_2
Xhold273 _00883_ vssd1 vssd1 vccd1 vccd1 net1232 sky130_fd_sc_hd__dlygate4sd3_1
Xhold295 cell0.LE_0B.config_data\[12\] vssd1 vssd1 vccd1 vccd1 net1254 sky130_fd_sc_hd__dlygate4sd3_1
Xhold284 _00147_ vssd1 vssd1 vccd1 vccd1 net1243 sky130_fd_sc_hd__dlygate4sd3_1
XFILLER_49_13 vssd1 vssd1 vccd1 vccd1 sky130_fd_sc_hd__fill_1
Xfanout742 net749 vssd1 vssd1 vccd1 vccd1 net742 sky130_fd_sc_hd__clkbuf_2
Xfanout720 net723 vssd1 vssd1 vccd1 vccd1 net720 sky130_fd_sc_hd__clkbuf_4
Xfanout731 net732 vssd1 vssd1 vccd1 vccd1 net731 sky130_fd_sc_hd__clkbuf_2
XFILLER_104_399 vssd1 vssd1 vccd1 vccd1 sky130_fd_sc_hd__fill_1
X_09928_ bus3_2\[4\] _04922_ _04924_ bus3_2\[5\] cell2.CB_1.config_dataB\[3\] vssd1
+ vssd1 vccd1 vccd1 _04932_ sky130_fd_sc_hd__a221o_1
XANTENNA__07980__X _03024_ vssd1 vssd1 vccd1 vccd1 sky130_fd_sc_hd__diode_2
Xfanout753 net754 vssd1 vssd1 vccd1 vccd1 net753 sky130_fd_sc_hd__buf_4
Xfanout775 net776 vssd1 vssd1 vccd1 vccd1 net775 sky130_fd_sc_hd__clkbuf_4
Xfanout764 net767 vssd1 vssd1 vccd1 vccd1 net764 sky130_fd_sc_hd__clkbuf_4
XANTENNA_fanout750_X net750 vssd1 vssd1 vccd1 vccd1 sky130_fd_sc_hd__diode_2
X_09859_ cell2.LEI0.config_data\[31\] _04864_ vssd1 vssd1 vccd1 vccd1 _04865_ sky130_fd_sc_hd__nor2_1
XFILLER_100_561 vssd1 vssd1 vccd1 vccd1 sky130_fd_sc_hd__fill_1
XANTENNA__10849__B2 _05553_ vssd1 vssd1 vccd1 vccd1 sky130_fd_sc_hd__diode_2
Xfanout797 net798 vssd1 vssd1 vccd1 vccd1 net797 sky130_fd_sc_hd__buf_2
Xfanout786 net787 vssd1 vssd1 vccd1 vccd1 net786 sky130_fd_sc_hd__clkbuf_4
XANTENNA__14312__SET_B net621 vssd1 vssd1 vccd1 vccd1 sky130_fd_sc_hd__diode_2
XFILLER_105_85 vssd1 vssd1 vccd1 vccd1 sky130_fd_sc_hd__fill_1
X_12870_ cell2.SB0.route_sel\[112\] cell2.SB0.route_sel\[111\] net812 vssd1 vssd1
+ vccd1 vccd1 _01299_ sky130_fd_sc_hd__mux2_1
XFILLER_85_283 vssd1 vssd1 vccd1 vccd1 sky130_fd_sc_hd__fill_2
XFILLER_65_45 vssd1 vssd1 vccd1 vccd1 sky130_fd_sc_hd__fill_1
XANTENNA_input126_A SBwest_in[7] vssd1 vssd1 vccd1 vccd1 sky130_fd_sc_hd__diode_2
XFILLER_45_158 vssd1 vssd1 vccd1 vccd1 sky130_fd_sc_hd__fill_1
X_11821_ cell1.CB_1.config_dataA\[2\] net496 net894 vssd1 vssd1 vccd1 vccd1 _00258_
+ sky130_fd_sc_hd__mux2_1
XFILLER_33_309 vssd1 vssd1 vccd1 vccd1 sky130_fd_sc_hd__fill_1
XFILLER_121_51 vssd1 vssd1 vccd1 vccd1 sky130_fd_sc_hd__fill_4
X_11752_ net1099 net1113 net796 vssd1 vssd1 vccd1 vccd1 _00189_ sky130_fd_sc_hd__mux2_1
X_14471_ clknet_leaf_63_clk _01443_ net740 vssd1 vssd1 vccd1 vccd1 cell3.LEI0.config_data\[36\]
+ sky130_fd_sc_hd__dfrtp_1
X_10703_ cell3.CB_1.config_dataA\[16\] _05659_ _05660_ vssd1 vssd1 vccd1 vccd1 _05661_
+ sky130_fd_sc_hd__a21oi_1
X_11683_ net1412 net1299 net801 vssd1 vssd1 vccd1 vccd1 _00123_ sky130_fd_sc_hd__mux2_1
XANTENNA__11026__A1 net41 vssd1 vssd1 vccd1 vccd1 sky130_fd_sc_hd__diode_2
X_10634_ net398 _05501_ _05591_ net396 vssd1 vssd1 vccd1 vccd1 _05592_ sky130_fd_sc_hd__o211a_1
XANTENNA_input91_A SBsouth_in[4] vssd1 vssd1 vccd1 vccd1 sky130_fd_sc_hd__diode_2
X_13422_ clknet_leaf_131_clk _00394_ net560 vssd1 vssd1 vccd1 vccd1 cell0.SB0.route_sel\[63\]
+ sky130_fd_sc_hd__dfstp_1
X_13353_ clknet_leaf_117_clk _00325_ net671 vssd1 vssd1 vccd1 vccd1 cell1.CB_0.config_dataA\[19\]
+ sky130_fd_sc_hd__dfstp_1
XFILLER_127_447 vssd1 vssd1 vccd1 vccd1 sky130_fd_sc_hd__fill_1
XANTENNA__10785__A0 net8 vssd1 vssd1 vccd1 vccd1 sky130_fd_sc_hd__diode_2
X_10565_ net272 _05521_ vssd1 vssd1 vccd1 vccd1 _05523_ sky130_fd_sc_hd__or2_2
XANTENNA__13192__RESET_B net751 vssd1 vssd1 vccd1 vccd1 sky130_fd_sc_hd__diode_2
X_12304_ cell1.SB0.route_sel\[42\] cell1.SB0.route_sel\[41\] net859 vssd1 vssd1 vccd1
+ vccd1 _00737_ sky130_fd_sc_hd__mux2_1
XANTENNA_output178_A net178 vssd1 vssd1 vccd1 vccd1 sky130_fd_sc_hd__diode_2
XANTENNA__11329__A2 _05921_ vssd1 vssd1 vccd1 vccd1 sky130_fd_sc_hd__diode_2
X_13284_ clknet_leaf_85_clk _00256_ net685 vssd1 vssd1 vccd1 vccd1 cell1.CB_1.config_dataA\[0\]
+ sky130_fd_sc_hd__dfstp_1
XFILLER_6_755 vssd1 vssd1 vccd1 vccd1 sky130_fd_sc_hd__fill_1
X_10496_ net334 _01843_ _01844_ _05463_ vssd1 vssd1 vccd1 vccd1 net162 sky130_fd_sc_hd__a22o_1
X_12235_ cell2.CB_0.config_dataB\[23\] cell2.CB_0.config_dataB\[22\] net826 vssd1
+ vssd1 vccd1 vccd1 _00668_ sky130_fd_sc_hd__mux2_1
XTAP_TAPCELL_ROW_75_1431 vssd1 vccd1 sky130_fd_sc_hd__tapvpwrvgnd_1
XFILLER_30_81 vssd1 vssd1 vccd1 vccd1 sky130_fd_sc_hd__fill_2
X_12166_ net1468 net548 _06380_ vssd1 vssd1 vccd1 vccd1 _00599_ sky130_fd_sc_hd__a21bo_1
X_11117_ _04354_ _04362_ _04370_ _05915_ _01796_ vssd1 vssd1 vccd1 vccd1 _06069_ sky130_fd_sc_hd__a2111o_1
XFILLER_69_729 vssd1 vssd1 vccd1 vccd1 sky130_fd_sc_hd__fill_1
XANTENNA__13577__SET_B net753 vssd1 vssd1 vccd1 vccd1 sky130_fd_sc_hd__diode_2
X_12097_ net1038 cell1.LE_0A.config_data\[1\] net877 vssd1 vssd1 vccd1 vccd1 _00531_
+ sky130_fd_sc_hd__mux2_1
X_11048_ cell3.CB_0.config_dataA\[17\] _06001_ vssd1 vssd1 vccd1 vccd1 _06002_ sky130_fd_sc_hd__nand2_1
Xinput8 CBeast_in[16] vssd1 vssd1 vccd1 vccd1 net8 sky130_fd_sc_hd__buf_2
XANTENNA__11265__A1 _05128_ vssd1 vssd1 vccd1 vccd1 sky130_fd_sc_hd__diode_2
X_12999_ cell3.LEI0.config_data\[20\] net1389 net947 vssd1 vssd1 vccd1 vccd1 _01427_
+ sky130_fd_sc_hd__mux2_1
XTAP_TAPCELL_ROW_35_827 vssd1 vccd1 sky130_fd_sc_hd__tapvpwrvgnd_1
XTAP_TAPCELL_ROW_35_838 vssd1 vccd1 sky130_fd_sc_hd__tapvpwrvgnd_1
XTAP_TAPCELL_ROW_86_1593 vssd1 vccd1 sky130_fd_sc_hd__tapvpwrvgnd_1
XANTENNA__08130__A1 _02136_ vssd1 vssd1 vccd1 vccd1 sky130_fd_sc_hd__diode_2
XFILLER_32_320 vssd1 vssd1 vccd1 vccd1 sky130_fd_sc_hd__fill_1
XANTENNA__09977__B _04608_ vssd1 vssd1 vccd1 vccd1 sky130_fd_sc_hd__diode_2
XTAP_TAPCELL_ROW_15_540 vssd1 vccd1 sky130_fd_sc_hd__tapvpwrvgnd_1
XANTENNA__11017__A1 _05871_ vssd1 vssd1 vccd1 vccd1 sky130_fd_sc_hd__diode_2
XANTENNA__08881__B _03820_ vssd1 vssd1 vccd1 vccd1 sky130_fd_sc_hd__diode_2
X_07210_ _01947_ _02032_ vssd1 vssd1 vccd1 vccd1 _02270_ sky130_fd_sc_hd__nor2_1
X_08190_ cell0.LEI0.config_data\[20\] _03229_ vssd1 vssd1 vccd1 vccd1 _03230_ sky130_fd_sc_hd__nor2_1
XANTENNA__07778__A net360 vssd1 vssd1 vccd1 vccd1 sky130_fd_sc_hd__diode_2
X_07141_ net344 _02202_ vssd1 vssd1 vccd1 vccd1 _02203_ sky130_fd_sc_hd__nor2_1
XFILLER_118_469 vssd1 vssd1 vccd1 vccd1 sky130_fd_sc_hd__fill_1
XTAP_TAPCELL_ROW_117_2070 vssd1 vccd1 sky130_fd_sc_hd__tapvpwrvgnd_1
X_07072_ _02133_ _02134_ _02135_ _02132_ vssd1 vssd1 vccd1 vccd1 _02136_ sky130_fd_sc_hd__a31o_2
XFILLER_10_29 vccd1 vssd1 vccd1 vssd1 sky130_ef_sc_hd__decap_40_12
XFILLER_126_29 vccd1 vssd1 vccd1 vssd1 sky130_ef_sc_hd__decap_40_12
X_07974_ cell0.LE_0A.config_data\[15\] cell0.LE_0A.config_data\[14\] _02947_ vssd1
+ vssd1 vccd1 vccd1 _03018_ sky130_fd_sc_hd__mux2_1
XFILLER_19_27 vccd1 vssd1 vccd1 vssd1 sky130_ef_sc_hd__decap_40_12
X_09713_ net262 cell3.SB0.route_sel\[126\] _02595_ _04718_ vssd1 vssd1 vccd1 vccd1
+ _04726_ sky130_fd_sc_hd__a211o_1
X_06925_ cell2.CB_1.config_dataB\[24\] cell2.CB_1.config_dataB\[21\] cell2.CB_1.config_dataB\[20\]
+ vssd1 vssd1 vccd1 vccd1 _01992_ sky130_fd_sc_hd__and3b_1
X_06856_ net61 net307 _01921_ vssd1 vssd1 vccd1 vccd1 _01925_ sky130_fd_sc_hd__mux2_1
X_09644_ _01824_ _04657_ vssd1 vssd1 vccd1 vccd1 _04660_ sky130_fd_sc_hd__nor2_1
XANTENNA__08548__S _03546_ vssd1 vssd1 vccd1 vccd1 sky130_fd_sc_hd__diode_2
XFILLER_27_125 vssd1 vssd1 vccd1 vccd1 sky130_fd_sc_hd__fill_4
XFILLER_35_15 vccd1 vssd1 vccd1 vssd1 sky130_ef_sc_hd__decap_40_12
X_09575_ net19 net289 _04592_ vssd1 vssd1 vccd1 vccd1 _04593_ sky130_fd_sc_hd__mux2_1
X_06787_ cell0.SB0.route_sel\[51\] cell0.SB0.route_sel\[50\] vssd1 vssd1 vccd1 vccd1
+ _01857_ sky130_fd_sc_hd__nand2_1
X_08526_ _03560_ _03561_ cell1.CB_1.config_dataA\[7\] vssd1 vssd1 vccd1 vccd1 _03562_
+ sky130_fd_sc_hd__or3b_1
X_08457_ cell1.SB0.route_sel\[109\] cell1.SB0.route_sel\[108\] cell1.SB0.route_sel\[111\]
+ _01546_ _03492_ vssd1 vssd1 vccd1 vccd1 _03493_ sky130_fd_sc_hd__o221a_2
XANTENNA__08672__A2 net2 vssd1 vssd1 vccd1 vccd1 sky130_fd_sc_hd__diode_2
X_07408_ _02178_ _02394_ vssd1 vssd1 vccd1 vccd1 _02463_ sky130_fd_sc_hd__nor2_1
XFILLER_11_559 vssd1 vssd1 vccd1 vccd1 sky130_fd_sc_hd__fill_1
X_08388_ bus1_0\[12\] bus1_0\[13\] bus1_0\[14\] bus1_0\[15\] net501 cell0.CB_1.config_dataB\[16\]
+ vssd1 vssd1 vccd1 vccd1 _03426_ sky130_fd_sc_hd__mux4_1
X_07339_ net36 _02395_ vssd1 vssd1 vccd1 vccd1 _02396_ sky130_fd_sc_hd__or2_1
XANTENNA__10767__A0 _05519_ vssd1 vssd1 vccd1 vccd1 sky130_fd_sc_hd__diode_2
X_10350_ _05136_ _05348_ vssd1 vssd1 vccd1 vccd1 _05349_ sky130_fd_sc_hd__nand2_1
Xclkbuf_1_0__f_cell1.LE_1A.sel_clk clknet_0_cell1.LE_1A.sel_clk vssd1 vssd1 vccd1
+ vccd1 clknet_1_0__leaf_cell1.LE_1A.sel_clk sky130_fd_sc_hd__clkbuf_16
XANTENNA__07632__B1 _02661_ vssd1 vssd1 vccd1 vccd1 sky130_fd_sc_hd__diode_2
XANTENNA__07200__B _01931_ vssd1 vssd1 vccd1 vccd1 sky130_fd_sc_hd__diode_2
X_10281_ net432 net430 vssd1 vssd1 vccd1 vccd1 _05280_ sky130_fd_sc_hd__nor2_1
X_09009_ bus3_1\[8\] bus3_1\[9\] bus3_1\[10\] bus3_1\[11\] net482 net481 vssd1 vssd1
+ vccd1 vccd1 _04039_ sky130_fd_sc_hd__mux4_1
XFILLER_3_725 vssd1 vssd1 vccd1 vccd1 sky130_fd_sc_hd__fill_2
XANTENNA__10614__S0 net398 vssd1 vssd1 vccd1 vccd1 sky130_fd_sc_hd__diode_2
XTAP_TAPCELL_ROW_57_1161 vssd1 vccd1 sky130_fd_sc_hd__tapvpwrvgnd_1
X_12020_ cell0.SB0.route_sel\[126\] cell0.SB0.route_sel\[125\] net791 vssd1 vssd1
+ vccd1 vccd1 _00457_ sky130_fd_sc_hd__mux2_1
XANTENNA_hold588_A cell1.LE_1B.reset_val vssd1 vssd1 vccd1 vccd1 sky130_fd_sc_hd__diode_2
XFILLER_120_623 vssd1 vssd1 vccd1 vccd1 sky130_fd_sc_hd__fill_1
Xfanout550 _01820_ vssd1 vssd1 vccd1 vccd1 net550 sky130_fd_sc_hd__clkbuf_8
XFILLER_59_740 vssd1 vssd1 vccd1 vccd1 sky130_fd_sc_hd__fill_1
X_13971_ clknet_leaf_36_clk _00943_ net638 vssd1 vssd1 vccd1 vccd1 cell2.LEI0.config_data\[28\]
+ sky130_fd_sc_hd__dfrtp_1
XTAP_TAPCELL_ROW_70_1361 vssd1 vccd1 sky130_fd_sc_hd__tapvpwrvgnd_1
Xfanout572 net573 vssd1 vssd1 vccd1 vccd1 net572 sky130_fd_sc_hd__clkbuf_4
Xfanout583 net584 vssd1 vssd1 vccd1 vccd1 net583 sky130_fd_sc_hd__clkbuf_4
Xfanout561 net563 vssd1 vssd1 vccd1 vccd1 net561 sky130_fd_sc_hd__clkbuf_2
XANTENNA__10298__A2 _05107_ vssd1 vssd1 vccd1 vccd1 sky130_fd_sc_hd__diode_2
X_12922_ net1081 net1228 net942 vssd1 vssd1 vccd1 vccd1 _01351_ sky130_fd_sc_hd__mux2_1
Xfanout594 net601 vssd1 vssd1 vccd1 vccd1 net594 sky130_fd_sc_hd__buf_2
XFILLER_46_423 vssd1 vssd1 vccd1 vccd1 sky130_fd_sc_hd__fill_1
XANTENNA__07699__B1 bus1_0\[3\] vssd1 vssd1 vccd1 vccd1 sky130_fd_sc_hd__diode_2
XANTENNA_input129_X net129 vssd1 vssd1 vccd1 vccd1 sky130_fd_sc_hd__diode_2
XFILLER_92_21 vssd1 vssd1 vccd1 vccd1 sky130_fd_sc_hd__fill_4
XFILLER_18_158 vssd1 vssd1 vccd1 vccd1 sky130_fd_sc_hd__fill_1
X_12853_ cell2.SB0.route_sel\[95\] cell2.SB0.route_sel\[94\] net831 vssd1 vssd1 vccd1
+ vccd1 _01282_ sky130_fd_sc_hd__mux2_1
X_12784_ cell2.SB0.route_sel\[26\] cell2.SB0.route_sel\[25\] net816 vssd1 vssd1 vccd1
+ vccd1 _01213_ sky130_fd_sc_hd__mux2_1
X_11804_ cell1.LE_1B.config_data\[5\] net1448 net901 vssd1 vssd1 vccd1 vccd1 _00241_
+ sky130_fd_sc_hd__mux2_1
XFILLER_14_331 vssd1 vssd1 vccd1 vccd1 sky130_fd_sc_hd__fill_2
XANTENNA__11798__A2 net548 vssd1 vssd1 vccd1 vccd1 sky130_fd_sc_hd__diode_2
X_11735_ net1128 net1059 net772 vssd1 vssd1 vccd1 vccd1 _00173_ sky130_fd_sc_hd__mux2_1
XFILLER_30_802 vssd1 vssd1 vccd1 vccd1 sky130_fd_sc_hd__fill_1
X_14454_ clknet_leaf_59_clk net1402 net735 vssd1 vssd1 vccd1 vccd1 cell3.LEI0.config_data\[19\]
+ sky130_fd_sc_hd__dfrtp_1
XANTENNA__11612__S net773 vssd1 vssd1 vccd1 vccd1 sky130_fd_sc_hd__diode_2
XANTENNA_input94_X net94 vssd1 vssd1 vccd1 vccd1 sky130_fd_sc_hd__diode_2
XANTENNA_clkbuf_4_14_0_clk_X clknet_4_14_0_clk vssd1 vssd1 vccd1 vccd1 sky130_fd_sc_hd__diode_2
X_11666_ cell0.CB_1.config_dataB\[12\] net502 net783 vssd1 vssd1 vccd1 vccd1 _00107_
+ sky130_fd_sc_hd__mux2_1
X_13405_ clknet_leaf_0_clk _00377_ net553 vssd1 vssd1 vccd1 vccd1 cell0.SB0.route_sel\[46\]
+ sky130_fd_sc_hd__dfstp_1
X_14385_ clknet_leaf_66_clk _01357_ net743 vssd1 vssd1 vccd1 vccd1 cell3.LE_1A.config_data\[16\]
+ sky130_fd_sc_hd__dfrtp_1
X_10617_ _01784_ _05572_ _05574_ vssd1 vssd1 vccd1 vccd1 _05575_ sky130_fd_sc_hd__a21oi_1
XANTENNA__10758__B1 _04370_ vssd1 vssd1 vccd1 vccd1 sky130_fd_sc_hd__diode_2
X_11597_ cell0.CB_1.config_dataA\[18\] cell0.CB_1.config_dataA\[17\] net789 vssd1
+ vssd1 vccd1 vccd1 _00038_ sky130_fd_sc_hd__mux2_1
X_10548_ _04354_ _04362_ _04370_ _05503_ _01788_ vssd1 vssd1 vccd1 vccd1 _05506_ sky130_fd_sc_hd__a2111o_1
X_13336_ clknet_leaf_83_clk _00308_ net674 vssd1 vssd1 vccd1 vccd1 cell1.CB_0.config_dataA\[2\]
+ sky130_fd_sc_hd__dfstp_2
XANTENNA__07110__B _02132_ vssd1 vssd1 vccd1 vccd1 sky130_fd_sc_hd__diode_2
XFILLER_142_225 vssd1 vssd1 vccd1 vccd1 sky130_fd_sc_hd__fill_1
X_13267_ clknet_leaf_92_clk _00239_ net694 vssd1 vssd1 vccd1 vccd1 cell1.LE_1B.config_data\[3\]
+ sky130_fd_sc_hd__dfrtp_1
XFILLER_6_585 vssd1 vssd1 vccd1 vccd1 sky130_fd_sc_hd__fill_2
XANTENNA_max_cap341_A _02208_ vssd1 vssd1 vccd1 vccd1 sky130_fd_sc_hd__diode_2
X_12218_ net430 net432 net825 vssd1 vssd1 vccd1 vccd1 _00651_ sky130_fd_sc_hd__mux2_1
X_10479_ clknet_leaf_13_clk cell0.LE_0B.edge_mode vssd1 vssd1 vccd1 vccd1 cell0.LE_0B.sel_clk
+ sky130_fd_sc_hd__xnor2_2
XANTENNA__08179__A1 _02350_ vssd1 vssd1 vccd1 vccd1 sky130_fd_sc_hd__diode_2
X_13198_ clknet_leaf_6_clk net994 net567 vssd1 vssd1 vccd1 vccd1 cell0.LE_0A.config_data\[5\]
+ sky130_fd_sc_hd__dfrtp_1
XANTENNA__07926__B2 _02172_ vssd1 vssd1 vccd1 vccd1 sky130_fd_sc_hd__diode_2
XANTENNA__07926__A1 _02074_ vssd1 vssd1 vccd1 vccd1 sky130_fd_sc_hd__diode_2
XANTENNA__09037__B _03820_ vssd1 vssd1 vccd1 vccd1 sky130_fd_sc_hd__diode_2
XANTENNA__07109__Y _02172_ vssd1 vssd1 vccd1 vccd1 sky130_fd_sc_hd__diode_2
X_12149_ net1323 cell1.LEI0.config_data\[30\] net900 vssd1 vssd1 vccd1 vccd1 _00582_
+ sky130_fd_sc_hd__mux2_1
XFILLER_2_41 vccd1 vssd1 vccd1 vssd1 sky130_ef_sc_hd__decap_40_12
X_06710_ net369 vssd1 vssd1 vccd1 vccd1 _01780_ sky130_fd_sc_hd__inv_2
XTAP_TAPCELL_ROW_88_1633 vssd1 vccd1 sky130_fd_sc_hd__tapvpwrvgnd_1
XTAP_TAPCELL_ROW_88_1622 vssd1 vccd1 sky130_fd_sc_hd__tapvpwrvgnd_1
XANTENNA__09679__B2 _04691_ vssd1 vssd1 vccd1 vccd1 sky130_fd_sc_hd__diode_2
XFILLER_2_85 vccd1 vssd1 vccd1 vssd1 sky130_ef_sc_hd__decap_40_12
XANTENNA__07780__B net349 vssd1 vssd1 vccd1 vccd1 sky130_fd_sc_hd__diode_2
XANTENNA__08351__A1 bus1_0\[13\] vssd1 vssd1 vccd1 vccd1 sky130_fd_sc_hd__diode_2
X_07690_ cell1.SB0.route_sel\[16\] cell1.SB0.route_sel\[17\] _02731_ _02737_ net865
+ vssd1 vssd1 vccd1 vccd1 _02738_ sky130_fd_sc_hd__a311o_2
X_06641_ cell3.SB0.route_sel\[55\] vssd1 vssd1 vccd1 vccd1 _01711_ sky130_fd_sc_hd__inv_2
XFILLER_92_562 vssd1 vssd1 vccd1 vccd1 sky130_fd_sc_hd__fill_2
X_06572_ cell2.SB0.route_sel\[106\] vssd1 vssd1 vccd1 vccd1 _01642_ sky130_fd_sc_hd__inv_2
X_09360_ _02801_ _04382_ _04383_ vssd1 vssd1 vccd1 vccd1 _04384_ sky130_fd_sc_hd__o21a_1
XANTENNA__08103__A1 _02074_ vssd1 vssd1 vccd1 vccd1 sky130_fd_sc_hd__diode_2
XFILLER_24_139 vssd1 vssd1 vccd1 vccd1 sky130_fd_sc_hd__fill_1
X_09291_ net278 net42 _04314_ vssd1 vssd1 vccd1 vccd1 _04317_ sky130_fd_sc_hd__mux2_1
XANTENNA__08103__B2 _02172_ vssd1 vssd1 vccd1 vccd1 sky130_fd_sc_hd__diode_2
X_08311_ net509 _02719_ _03348_ net508 vssd1 vssd1 vccd1 vccd1 _03349_ sky130_fd_sc_hd__o211a_1
XANTENNA__10997__A0 net47 vssd1 vssd1 vccd1 vccd1 sky130_fd_sc_hd__diode_2
XANTENNA_13 cell1.LE_1B.config_data\[0\] vssd1 vssd1 vccd1 vccd1 sky130_fd_sc_hd__diode_2
X_08242_ net536 _01877_ _03281_ net535 vssd1 vssd1 vccd1 vccd1 _03282_ sky130_fd_sc_hd__o211a_1
XFILLER_33_695 vssd1 vssd1 vccd1 vccd1 sky130_fd_sc_hd__fill_1
XANTENNA__08654__A2 net6 vssd1 vssd1 vccd1 vccd1 sky130_fd_sc_hd__diode_2
XANTENNA_24 net155 vssd1 vssd1 vccd1 vccd1 sky130_fd_sc_hd__diode_2
XANTENNA_35 _02977_ vssd1 vssd1 vccd1 vccd1 sky130_fd_sc_hd__diode_2
XANTENNA__07862__B1 _02905_ vssd1 vssd1 vccd1 vccd1 sky130_fd_sc_hd__diode_2
XANTENNA_46 net1508 vssd1 vssd1 vccd1 vccd1 sky130_fd_sc_hd__diode_2
X_08173_ _02633_ _03201_ _03203_ _02678_ cell0.CB_1.config_dataA\[7\] vssd1 vssd1
+ vccd1 vccd1 _03213_ sky130_fd_sc_hd__a221o_1
XTAP_TAPCELL_ROW_115_2029 vssd1 vccd1 sky130_fd_sc_hd__tapvpwrvgnd_1
XTAP_TAPCELL_ROW_99_1795 vssd1 vccd1 sky130_fd_sc_hd__tapvpwrvgnd_1
X_07124_ cell2.SB0.route_sel\[79\] cell2.SB0.route_sel\[78\] vssd1 vssd1 vccd1 vccd1
+ _02187_ sky130_fd_sc_hd__nor2_1
XANTENNA__07795__X _02840_ vssd1 vssd1 vccd1 vccd1 sky130_fd_sc_hd__diode_2
XANTENNA__07614__B1 _02661_ vssd1 vssd1 vccd1 vccd1 sky130_fd_sc_hd__diode_2
XFILLER_21_39 vccd1 vssd1 vccd1 vssd1 sky130_ef_sc_hd__decap_40_12
XFILLER_137_39 vccd1 vssd1 vccd1 vssd1 sky130_ef_sc_hd__decap_40_12
XFILLER_133_225 vssd1 vssd1 vccd1 vccd1 sky130_fd_sc_hd__fill_1
X_07055_ cell0.SB0.route_sel\[77\] cell0.SB0.route_sel\[76\] net128 _02117_ _02116_
+ vssd1 vssd1 vccd1 vccd1 _02119_ sky130_fd_sc_hd__a41o_1
Xoutput142 net142 vssd1 vssd1 vccd1 vccd1 CBeast_out[17] sky130_fd_sc_hd__buf_2
Xoutput186 net186 vssd1 vssd1 vccd1 vccd1 CBnorth_out[28] sky130_fd_sc_hd__buf_2
XFILLER_142_770 vssd1 vssd1 vccd1 vccd1 sky130_fd_sc_hd__fill_4
Xoutput175 net175 vssd1 vssd1 vccd1 vccd1 CBnorth_out[18] sky130_fd_sc_hd__buf_2
XANTENNA__11174__A0 net47 vssd1 vssd1 vccd1 vccd1 sky130_fd_sc_hd__diode_2
XFILLER_88_813 vssd1 vssd1 vccd1 vccd1 sky130_fd_sc_hd__fill_1
XANTENNA__07917__A1 bus2_0\[4\] vssd1 vssd1 vccd1 vccd1 sky130_fd_sc_hd__diode_2
Xoutput153 net153 vssd1 vssd1 vccd1 vccd1 CBeast_out[27] sky130_fd_sc_hd__buf_2
Xoutput164 net164 vssd1 vssd1 vccd1 vccd1 CBeast_out[8] sky130_fd_sc_hd__buf_2
Xoutput197 net197 vssd1 vssd1 vccd1 vccd1 CBnorth_out[9] sky130_fd_sc_hd__buf_2
XTAP_TAPCELL_ROW_110_1951 vssd1 vccd1 sky130_fd_sc_hd__tapvpwrvgnd_1
XFILLER_102_645 vssd1 vssd1 vccd1 vccd1 sky130_fd_sc_hd__fill_1
XFILLER_87_323 vssd1 vssd1 vccd1 vccd1 sky130_fd_sc_hd__fill_1
XANTENNA__07917__B2 bus2_0\[5\] vssd1 vssd1 vccd1 vccd1 sky130_fd_sc_hd__diode_2
XANTENNA__09119__A0 bus3_1\[12\] vssd1 vssd1 vccd1 vccd1 sky130_fd_sc_hd__diode_2
XTAP_TAPCELL_ROW_110_1962 vssd1 vccd1 sky130_fd_sc_hd__tapvpwrvgnd_1
X_07957_ net512 _02526_ _03000_ net511 vssd1 vssd1 vccd1 vccd1 _03001_ sky130_fd_sc_hd__o211a_1
XANTENNA__08590__A1 _03514_ vssd1 vssd1 vccd1 vccd1 sky130_fd_sc_hd__diode_2
XTAP_TAPCELL_ROW_52_1091 vssd1 vccd1 sky130_fd_sc_hd__tapvpwrvgnd_1
X_06908_ net325 _01974_ _01971_ vssd1 vssd1 vccd1 vccd1 _01976_ sky130_fd_sc_hd__o21ai_2
XFILLER_28_412 vssd1 vssd1 vccd1 vccd1 sky130_fd_sc_hd__fill_1
XANTENNA_fanout758_A net807 vssd1 vssd1 vccd1 vccd1 sky130_fd_sc_hd__diode_2
X_07888_ _02927_ _02930_ _02931_ _01569_ _02926_ vssd1 vssd1 vccd1 vccd1 _02932_ sky130_fd_sc_hd__a221o_1
X_09627_ cell3.SB0.route_sel\[102\] cell3.SB0.route_sel\[103\] vssd1 vssd1 vccd1 vccd1
+ _04643_ sky130_fd_sc_hd__nand2_1
X_06839_ net303 _01903_ _01905_ _01902_ vssd1 vssd1 vccd1 vccd1 _01908_ sky130_fd_sc_hd__a31o_1
X_09558_ cell3.SB0.route_sel\[78\] cell3.SB0.route_sel\[79\] vssd1 vssd1 vccd1 vccd1
+ _04577_ sky130_fd_sc_hd__nor2_1
XFILLER_70_223 vssd1 vssd1 vccd1 vccd1 sky130_fd_sc_hd__fill_4
X_08509_ cell1.CB_1.config_dataA\[4\] _03474_ _03523_ _03544_ _01663_ vssd1 vssd1
+ vccd1 vccd1 _03545_ sky130_fd_sc_hd__a32o_1
X_11520_ _01634_ cell2.SB0.route_sel\[90\] vssd1 vssd1 vccd1 vccd1 _06347_ sky130_fd_sc_hd__nand2_1
X_09489_ net287 _04509_ vssd1 vssd1 vccd1 vccd1 _04510_ sky130_fd_sc_hd__nor2_1
XFILLER_51_481 vssd1 vssd1 vccd1 vccd1 sky130_fd_sc_hd__fill_1
XANTENNA__07211__A net346 vssd1 vssd1 vccd1 vccd1 sky130_fd_sc_hd__diode_2
X_11451_ cell1.SB0.route_sel\[33\] cell1.SB0.route_sel\[32\] vssd1 vssd1 vccd1 vccd1
+ _06301_ sky130_fd_sc_hd__nand2b_1
XFILLER_125_715 vssd1 vssd1 vccd1 vccd1 sky130_fd_sc_hd__fill_1
X_10402_ net424 _05148_ _05400_ net423 vssd1 vssd1 vccd1 vccd1 _05401_ sky130_fd_sc_hd__o211a_1
X_14170_ clknet_leaf_58_clk _01142_ net720 vssd1 vssd1 vccd1 vccd1 cell3.CB_0.config_dataB\[5\]
+ sky130_fd_sc_hd__dfstp_1
Xclkbuf_1_0__f_cell3.LE_1B.sel_clk clknet_0_cell3.LE_1B.sel_clk vssd1 vssd1 vccd1
+ vccd1 clknet_1_0__leaf_cell3.LE_1B.sel_clk sky130_fd_sc_hd__clkbuf_16
XANTENNA__10204__A2 _05088_ vssd1 vssd1 vccd1 vccd1 sky130_fd_sc_hd__diode_2
X_11382_ _01460_ cell0.SB0.route_sel\[50\] vssd1 vssd1 vccd1 vccd1 _06255_ sky130_fd_sc_hd__nand2_1
X_10333_ net436 _05088_ _05331_ net433 vssd1 vssd1 vccd1 vccd1 _05332_ sky130_fd_sc_hd__o211a_1
XANTENNA__10755__A3 net11 vssd1 vssd1 vccd1 vccd1 sky130_fd_sc_hd__diode_2
X_13121_ clknet_leaf_8_clk _00093_ net572 vssd1 vssd1 vccd1 vccd1 cell0.CB_0.config_dataA\[23\]
+ sky130_fd_sc_hd__dfstp_1
XANTENNA__09358__B1 _02804_ vssd1 vssd1 vccd1 vccd1 sky130_fd_sc_hd__diode_2
XANTENNA_input54_A CBnorth_in[29] vssd1 vssd1 vccd1 vccd1 sky130_fd_sc_hd__diode_2
XANTENNA__11165__A0 net53 vssd1 vssd1 vccd1 vccd1 sky130_fd_sc_hd__diode_2
X_10264_ cell2.LE_0A.config_data\[3\] cell2.LE_0A.config_data\[2\] _05196_ vssd1 vssd1
+ vccd1 vccd1 _05265_ sky130_fd_sc_hd__mux2_1
X_13052_ clknet_leaf_126_clk _00024_ net582 vssd1 vssd1 vccd1 vccd1 cell0.CB_1.config_dataA\[4\]
+ sky130_fd_sc_hd__dfstp_1
XANTENNA__10912__A0 net49 vssd1 vssd1 vccd1 vccd1 sky130_fd_sc_hd__diode_2
X_10195_ _05193_ _05195_ vssd1 vssd1 vccd1 vccd1 _05196_ sky130_fd_sc_hd__nor2_4
X_12003_ cell0.SB0.route_sel\[109\] cell0.SB0.route_sel\[108\] net758 vssd1 vssd1
+ vccd1 vccd1 _00440_ sky130_fd_sc_hd__mux2_1
Xfanout380 cell3.CB_0.config_dataB\[23\] vssd1 vssd1 vccd1 vccd1 net380 sky130_fd_sc_hd__clkbuf_2
Xfanout391 cell3.CB_1.config_dataA\[15\] vssd1 vssd1 vccd1 vccd1 net391 sky130_fd_sc_hd__buf_2
XTAP_TAPCELL_ROW_6_393 vssd1 vccd1 sky130_fd_sc_hd__tapvpwrvgnd_1
X_13954_ clknet_leaf_41_clk net1322 net641 vssd1 vssd1 vccd1 vccd1 cell2.LEI0.config_data\[11\]
+ sky130_fd_sc_hd__dfrtp_1
XFILLER_46_231 vssd1 vssd1 vccd1 vccd1 sky130_fd_sc_hd__fill_1
XANTENNA__08333__A1 bus1_0\[13\] vssd1 vssd1 vccd1 vccd1 sky130_fd_sc_hd__diode_2
X_13885_ clknet_leaf_53_clk _00857_ net714 vssd1 vssd1 vccd1 vccd1 cell2.LE_1A.config_data\[8\]
+ sky130_fd_sc_hd__dfrtp_1
X_12905_ cell3.CB_1.config_dataB\[19\] cell3.CB_1.config_dataB\[18\] net938 vssd1
+ vssd1 vccd1 vccd1 _01334_ sky130_fd_sc_hd__mux2_1
XFILLER_74_584 vssd1 vssd1 vccd1 vccd1 sky130_fd_sc_hd__fill_4
XANTENNA_output210_A net210 vssd1 vssd1 vccd1 vccd1 sky130_fd_sc_hd__diode_2
XANTENNA__10691__A2 net24 vssd1 vssd1 vccd1 vccd1 sky130_fd_sc_hd__diode_2
X_12836_ cell2.SB0.route_sel\[78\] cell2.SB0.route_sel\[77\] net778 vssd1 vssd1 vccd1
+ vccd1 _01265_ sky130_fd_sc_hd__mux2_1
XTAP_TAPCELL_ROW_83_1552 vssd1 vccd1 sky130_fd_sc_hd__tapvpwrvgnd_1
XTAP_TAPCELL_ROW_45_988 vssd1 vccd1 sky130_fd_sc_hd__tapvpwrvgnd_1
XTAP_TAPCELL_ROW_45_977 vssd1 vccd1 sky130_fd_sc_hd__tapvpwrvgnd_1
XANTENNA__09833__A1 _04671_ vssd1 vssd1 vccd1 vccd1 sky130_fd_sc_hd__diode_2
XANTENNA__06944__B _02008_ vssd1 vssd1 vccd1 vccd1 sky130_fd_sc_hd__diode_2
X_12767_ cell2.SB0.route_sel\[9\] cell2.SB0.route_sel\[8\] net829 vssd1 vssd1 vccd1
+ vccd1 _01196_ sky130_fd_sc_hd__mux2_1
X_12698_ net391 cell3.CB_1.config_dataA\[14\] net941 vssd1 vssd1 vccd1 vccd1 _01127_
+ sky130_fd_sc_hd__mux2_1
X_11718_ cell0.LE_0B.config_data\[14\] net1268 net796 vssd1 vssd1 vccd1 vccd1 _00157_
+ sky130_fd_sc_hd__mux2_1
XTAP_TAPCELL_ROW_25_690 vssd1 vccd1 sky130_fd_sc_hd__tapvpwrvgnd_1
XFILLER_30_643 vssd1 vssd1 vccd1 vccd1 sky130_fd_sc_hd__fill_1
Xinput22 CBeast_in[29] vssd1 vssd1 vccd1 vccd1 net22 sky130_fd_sc_hd__buf_2
X_14437_ clknet_leaf_59_clk net1395 net734 vssd1 vssd1 vccd1 vccd1 cell3.LEI0.config_data\[2\]
+ sky130_fd_sc_hd__dfrtp_1
Xinput11 CBeast_in[19] vssd1 vssd1 vccd1 vccd1 net11 sky130_fd_sc_hd__buf_2
X_11649_ cell0.CB_0.config_dataA\[20\] cell0.CB_0.config_dataA\[19\] net773 vssd1
+ vssd1 vccd1 vccd1 _00090_ sky130_fd_sc_hd__mux2_1
Xinput55 CBnorth_in[2] vssd1 vssd1 vccd1 vccd1 net55 sky130_fd_sc_hd__buf_2
Xinput44 CBnorth_in[1] vssd1 vssd1 vccd1 vccd1 net44 sky130_fd_sc_hd__buf_2
Xinput33 CBnorth_in[0] vssd1 vssd1 vccd1 vccd1 net33 sky130_fd_sc_hd__buf_2
X_14368_ clknet_1_0__leaf_cell3.LE_1B.sel_clk _01340_ net753 vssd1 vssd1 vccd1 vccd1
+ cell3.LE_1B.dff0_out sky130_fd_sc_hd__dfrtp_1
XFILLER_128_597 vssd1 vssd1 vccd1 vccd1 sky130_fd_sc_hd__fill_1
X_13319_ clknet_leaf_88_clk _00291_ net690 vssd1 vssd1 vccd1 vccd1 cell1.CB_0.config_dataB\[10\]
+ sky130_fd_sc_hd__dfstp_1
Xinput88 SBsouth_in[30] vssd1 vssd1 vccd1 vccd1 net88 sky130_fd_sc_hd__clkbuf_2
Xinput66 SBsouth_in[10] vssd1 vssd1 vccd1 vccd1 net66 sky130_fd_sc_hd__clkbuf_2
Xinput77 SBsouth_in[20] vssd1 vssd1 vccd1 vccd1 net77 sky130_fd_sc_hd__dlymetal6s2s_1
XANTENNA__08504__X _03540_ vssd1 vssd1 vccd1 vccd1 sky130_fd_sc_hd__diode_2
X_14299_ clknet_leaf_12_clk _01271_ net590 vssd1 vssd1 vccd1 vccd1 cell2.SB0.route_sel\[84\]
+ sky130_fd_sc_hd__dfstp_1
Xinput99 SBwest_in[11] vssd1 vssd1 vccd1 vccd1 net99 sky130_fd_sc_hd__buf_1
XANTENNA__09990__B _04724_ vssd1 vssd1 vccd1 vccd1 sky130_fd_sc_hd__diode_2
X_08860_ cell1.SB0.route_sel\[34\] cell1.SB0.route_sel\[35\] vssd1 vssd1 vccd1 vccd1
+ _03892_ sky130_fd_sc_hd__or2_1
XFILLER_69_378 vssd1 vssd1 vccd1 vccd1 sky130_fd_sc_hd__fill_1
X_07811_ net320 _01838_ _02143_ _02146_ _01842_ vssd1 vssd1 vccd1 vccd1 _02856_ sky130_fd_sc_hd__o32a_1
XFILLER_96_197 vssd1 vssd1 vccd1 vccd1 sky130_fd_sc_hd__fill_8
X_08791_ cell1.SB0.route_sel\[111\] _01546_ vssd1 vssd1 vccd1 vccd1 _03823_ sky130_fd_sc_hd__nand2_1
XANTENNA__08324__A1 _02846_ vssd1 vssd1 vccd1 vccd1 sky130_fd_sc_hd__diode_2
X_07742_ _02784_ _02786_ _02787_ vssd1 vssd1 vccd1 vccd1 _02788_ sky130_fd_sc_hd__a21oi_1
XANTENNA__13696__SET_B net621 vssd1 vssd1 vccd1 vccd1 sky130_fd_sc_hd__diode_2
XANTENNA__10667__C1 _05503_ vssd1 vssd1 vccd1 vccd1 sky130_fd_sc_hd__diode_2
X_07673_ cell1.SB0.route_sel\[21\] cell1.SB0.route_sel\[20\] vssd1 vssd1 vccd1 vccd1
+ _02721_ sky130_fd_sc_hd__nand2_1
XANTENNA__08324__B2 _02807_ vssd1 vssd1 vccd1 vccd1 sky130_fd_sc_hd__diode_2
XTAP_TAPCELL_ROW_125_2180 vssd1 vccd1 sky130_fd_sc_hd__tapvpwrvgnd_1
X_09412_ cell2.SB0.route_sel\[46\] cell2.SB0.route_sel\[47\] _04434_ vssd1 vssd1 vccd1
+ vccd1 _04435_ sky130_fd_sc_hd__a21bo_1
X_06624_ cell3.SB0.route_sel\[25\] vssd1 vssd1 vccd1 vccd1 _01694_ sky130_fd_sc_hd__inv_2
X_09343_ _01825_ _04216_ _04363_ _04365_ _04367_ vssd1 vssd1 vccd1 vccd1 _04368_ sky130_fd_sc_hd__a311o_1
XFILLER_80_587 vssd1 vssd1 vccd1 vccd1 sky130_fd_sc_hd__fill_1
X_06555_ cell2.SB0.route_sel\[75\] vssd1 vssd1 vccd1 vccd1 _01625_ sky130_fd_sc_hd__inv_2
XANTENNA_fanout339_A net340 vssd1 vssd1 vccd1 vccd1 sky130_fd_sc_hd__diode_2
X_09274_ cell3.SB0.route_sel\[22\] cell3.SB0.route_sel\[23\] net314 _04279_ _04277_
+ vssd1 vssd1 vccd1 vccd1 _04300_ sky130_fd_sc_hd__a221oi_1
X_06486_ cell0.CB_0.config_dataB\[2\] vssd1 vssd1 vccd1 vccd1 _01556_ sky130_fd_sc_hd__inv_2
XTAP_TAPCELL_ROW_23_649 vssd1 vccd1 sky130_fd_sc_hd__tapvpwrvgnd_1
X_08225_ _03264_ _03232_ _03231_ vssd1 vssd1 vccd1 vccd1 _03265_ sky130_fd_sc_hd__mux2_1
XFILLER_120_9 vccd1 vssd1 vccd1 vssd1 sky130_ef_sc_hd__decap_40_12
X_08156_ net344 net347 cell0.CB_1.le_outA cell0.CB_1.le_outB cell0.LEI0.config_data\[6\]
+ cell0.LEI0.config_data\[7\] vssd1 vssd1 vccd1 vccd1 _03196_ sky130_fd_sc_hd__mux4_1
XFILLER_5_809 vssd1 vssd1 vccd1 vccd1 sky130_fd_sc_hd__fill_1
XANTENNA__07063__A1 _02032_ vssd1 vssd1 vccd1 vccd1 sky130_fd_sc_hd__diode_2
X_07107_ cell0.SB0.route_sel\[78\] cell0.SB0.route_sel\[79\] vssd1 vssd1 vccd1 vccd1
+ _02170_ sky130_fd_sc_hd__nand2b_1
X_08087_ net524 _02894_ _03128_ net523 vssd1 vssd1 vccd1 vccd1 _03129_ sky130_fd_sc_hd__o211a_1
XFILLER_121_217 vssd1 vssd1 vccd1 vccd1 sky130_fd_sc_hd__fill_1
X_07038_ _02098_ _02101_ _02102_ vssd1 vssd1 vccd1 vccd1 _02103_ sky130_fd_sc_hd__or3b_1
XTAP_TAPCELL_ROW_54_1120 vssd1 vccd1 sky130_fd_sc_hd__tapvpwrvgnd_1
XANTENNA_fanout875_A net884 vssd1 vssd1 vccd1 vccd1 sky130_fd_sc_hd__diode_2
XFILLER_88_676 vssd1 vssd1 vccd1 vccd1 sky130_fd_sc_hd__fill_2
XFILLER_88_654 vssd1 vssd1 vccd1 vccd1 sky130_fd_sc_hd__fill_1
XANTENNA_input1_X net1 vssd1 vssd1 vccd1 vccd1 sky130_fd_sc_hd__diode_2
XANTENNA__08563__B2 _03514_ vssd1 vssd1 vccd1 vccd1 sky130_fd_sc_hd__diode_2
XANTENNA__08563__A1 _03517_ vssd1 vssd1 vccd1 vccd1 sky130_fd_sc_hd__diode_2
X_08989_ cell1.LE_0A.config_data\[16\] _04018_ _04019_ net351 vssd1 vssd1 vccd1 vccd1
+ cell1.CB_0.le_outA sky130_fd_sc_hd__o211a_2
XTAP_TAPCELL_ROW_3_352 vssd1 vccd1 sky130_fd_sc_hd__tapvpwrvgnd_1
XANTENNA__08315__A1 bus1_0\[1\] vssd1 vssd1 vccd1 vccd1 sky130_fd_sc_hd__diode_2
X_10951_ net47 net48 net379 vssd1 vssd1 vccd1 vccd1 _05905_ sky130_fd_sc_hd__mux2_1
XANTENNA__10122__A1 net62 vssd1 vssd1 vccd1 vccd1 sky130_fd_sc_hd__diode_2
X_13670_ clknet_leaf_14_clk _00642_ net631 vssd1 vssd1 vccd1 vccd1 cell2.CB_1.config_dataA\[22\]
+ sky130_fd_sc_hd__dfstp_1
XFILLER_44_746 vssd1 vssd1 vccd1 vccd1 sky130_fd_sc_hd__fill_1
XFILLER_43_223 vssd1 vssd1 vccd1 vccd1 sky130_fd_sc_hd__fill_1
XFILLER_16_426 vssd1 vssd1 vccd1 vccd1 sky130_fd_sc_hd__fill_1
X_10882_ _05836_ _05837_ _05758_ vssd1 vssd1 vccd1 vccd1 _05838_ sky130_fd_sc_hd__mux2_1
X_12621_ cell3.SB0.route_sel\[86\] cell3.SB0.route_sel\[85\] net878 vssd1 vssd1 vccd1
+ vccd1 _01050_ sky130_fd_sc_hd__mux2_1
XPHY_EDGE_ROW_125_Right_125 vssd1 vssd1 vccd1 vccd1 sky130_fd_sc_hd__decap_3
XANTENNA__09815__A1 _04399_ vssd1 vssd1 vccd1 vccd1 sky130_fd_sc_hd__diode_2
XTAP_TAPCELL_ROW_65_1282 vssd1 vccd1 sky130_fd_sc_hd__tapvpwrvgnd_1
XTAP_TAPCELL_ROW_42_936 vssd1 vccd1 sky130_fd_sc_hd__tapvpwrvgnd_1
XANTENNA__10286__B _05144_ vssd1 vssd1 vccd1 vccd1 sky130_fd_sc_hd__diode_2
X_12552_ cell3.SB0.route_sel\[17\] cell3.SB0.route_sel\[16\] net919 vssd1 vssd1 vccd1
+ vccd1 _00981_ sky130_fd_sc_hd__mux2_1
XANTENNA__08094__A3 bus2_0\[3\] vssd1 vssd1 vccd1 vccd1 sky130_fd_sc_hd__diode_2
X_12483_ net1485 net549 _06383_ vssd1 vssd1 vccd1 vccd1 _00913_ sky130_fd_sc_hd__a21bo_1
X_11503_ cell2.SB0.route_sel\[40\] cell2.SB0.route_sel\[41\] cell2.SB0.route_sel\[43\]
+ _01607_ _06335_ vssd1 vssd1 vccd1 vccd1 _06336_ sky130_fd_sc_hd__o221a_1
XFILLER_7_113 vccd1 vssd1 vccd1 vssd1 sky130_ef_sc_hd__decap_40_12
X_14222_ clknet_leaf_16_clk _01194_ net624 vssd1 vssd1 vccd1 vccd1 cell2.SB0.route_sel\[7\]
+ sky130_fd_sc_hd__dfstp_1
X_11434_ cell0.SB0.route_sel\[120\] _01487_ cell0.SB0.route_sel\[123\] _01489_ _06289_
+ vssd1 vssd1 vccd1 vccd1 _06290_ sky130_fd_sc_hd__a221o_1
XFILLER_8_669 vccd1 vssd1 vccd1 vssd1 sky130_ef_sc_hd__decap_40_12
XANTENNA__10189__A1 net37 vssd1 vssd1 vccd1 vccd1 sky130_fd_sc_hd__diode_2
X_11365_ clknet_leaf_55_clk cell3.LE_0A.edge_mode vssd1 vssd1 vccd1 vccd1 cell3.LE_0A.sel_clk
+ sky130_fd_sc_hd__xnor2_2
X_14153_ clknet_leaf_70_clk _01125_ net730 vssd1 vssd1 vccd1 vccd1 cell3.CB_1.config_dataA\[13\]
+ sky130_fd_sc_hd__dfstp_1
XFILLER_98_53 vssd1 vssd1 vccd1 vccd1 sky130_fd_sc_hd__fill_2
Xclkbuf_leaf_100_clk clknet_4_10_0_clk vssd1 vssd1 vccd1 vccd1 clknet_leaf_100_clk
+ sky130_fd_sc_hd__clkbuf_8
XANTENNA_input57_X net57 vssd1 vssd1 vccd1 vccd1 sky130_fd_sc_hd__diode_2
X_10316_ net435 net433 _05139_ _05311_ cell2.CB_0.config_dataB\[2\] vssd1 vssd1 vccd1
+ vccd1 _05315_ sky130_fd_sc_hd__o311a_1
XANTENNA__10733__C _05521_ vssd1 vssd1 vccd1 vccd1 sky130_fd_sc_hd__diode_2
XANTENNA__09719__A_N _04731_ vssd1 vssd1 vccd1 vccd1 sky130_fd_sc_hd__diode_2
X_14084_ clknet_leaf_80_clk _01056_ net710 vssd1 vssd1 vccd1 vccd1 cell3.SB0.route_sel\[92\]
+ sky130_fd_sc_hd__dfstp_1
X_11296_ _04231_ _06212_ _04234_ vssd1 vssd1 vccd1 vccd1 net142 sky130_fd_sc_hd__o21ai_2
X_13104_ clknet_leaf_5_clk _00076_ net566 vssd1 vssd1 vccd1 vccd1 cell0.CB_0.config_dataA\[6\]
+ sky130_fd_sc_hd__dfstp_1
XANTENNA_output160_A net160 vssd1 vssd1 vccd1 vccd1 sky130_fd_sc_hd__diode_2
XANTENNA__07424__A1_N cell0.CB_1.le_outA vssd1 vssd1 vccd1 vccd1 sky130_fd_sc_hd__diode_2
XANTENNA__12721__S net932 vssd1 vssd1 vccd1 vccd1 sky130_fd_sc_hd__diode_2
X_10247_ net33 net44 net55 net58 net413 net411 vssd1 vssd1 vccd1 vccd1 _05248_ sky130_fd_sc_hd__mux4_1
XANTENNA_output258_A net258 vssd1 vssd1 vccd1 vccd1 sky130_fd_sc_hd__diode_2
X_13035_ clknet_leaf_120_clk _00007_ net596 vssd1 vssd1 vccd1 vccd1 cell0.LE_1B.config_data\[7\]
+ sky130_fd_sc_hd__dfrtp_1
XFILLER_3_374 vccd1 vssd1 vccd1 vssd1 sky130_ef_sc_hd__decap_40_12
XANTENNA__10361__A1 net44 vssd1 vssd1 vccd1 vccd1 sky130_fd_sc_hd__diode_2
X_10178_ _05175_ _05178_ vssd1 vssd1 vccd1 vccd1 _05179_ sky130_fd_sc_hd__nor2_1
X_13937_ clknet_leaf_25_clk _00909_ net617 vssd1 vssd1 vccd1 vccd1 cell2.LE_0A.config_data\[16\]
+ sky130_fd_sc_hd__dfrtp_2
XFILLER_19_242 vssd1 vssd1 vccd1 vccd1 sky130_fd_sc_hd__fill_1
XANTENNA__06868__A1 net360 vssd1 vssd1 vccd1 vccd1 sky130_fd_sc_hd__diode_2
X_13868_ clknet_leaf_18_clk _00840_ net628 vssd1 vssd1 vccd1 vccd1 cell2.CB_1.config_dataB\[17\]
+ sky130_fd_sc_hd__dfstp_2
XANTENNA__09806__B2 _04197_ vssd1 vssd1 vccd1 vccd1 sky130_fd_sc_hd__diode_2
XANTENNA__09806__A1 _04260_ vssd1 vssd1 vccd1 vccd1 sky130_fd_sc_hd__diode_2
XFILLER_97_3 vccd1 vssd1 vccd1 vssd1 sky130_ef_sc_hd__decap_40_12
X_12819_ cell2.SB0.route_sel\[61\] cell2.SB0.route_sel\[60\] net809 vssd1 vssd1 vccd1
+ vccd1 _01248_ sky130_fd_sc_hd__mux2_1
X_13799_ clknet_leaf_105_clk _00771_ net659 vssd1 vssd1 vccd1 vccd1 cell1.SB0.route_sel\[76\]
+ sky130_fd_sc_hd__dfstp_1
XANTENNA__07817__B1 bus3_1\[5\] vssd1 vssd1 vccd1 vccd1 sky130_fd_sc_hd__diode_2
XTAP_TAPCELL_ROW_20_608 vssd1 vccd1 sky130_fd_sc_hd__tapvpwrvgnd_1
XANTENNA__07293__A1 net358 vssd1 vssd1 vccd1 vccd1 sky130_fd_sc_hd__diode_2
X_08010_ _03047_ _03050_ _03051_ _01558_ _03046_ vssd1 vssd1 vccd1 vccd1 _03052_ sky130_fd_sc_hd__a221o_1
XTAP_TAPCELL_ROW_96_1754 vssd1 vccd1 sky130_fd_sc_hd__tapvpwrvgnd_1
XTAP_TAPCELL_ROW_96_1743 vssd1 vccd1 sky130_fd_sc_hd__tapvpwrvgnd_1
Xmax_cap300 _01928_ vssd1 vssd1 vccd1 vccd1 net300 sky130_fd_sc_hd__clkbuf_2
XANTENNA__09034__A2 _03858_ vssd1 vssd1 vccd1 vccd1 sky130_fd_sc_hd__diode_2
X_09961_ net405 _04963_ _04964_ vssd1 vssd1 vccd1 vccd1 _04965_ sky130_fd_sc_hd__a21oi_1
X_08912_ bus3_1\[0\] bus3_1\[1\] bus3_1\[2\] bus3_1\[3\] net468 net466 vssd1 vssd1
+ vccd1 vccd1 _03944_ sky130_fd_sc_hd__mux4_1
XFILLER_134_29 vccd1 vssd1 vccd1 vssd1 sky130_ef_sc_hd__decap_40_12
X_09892_ net438 _04472_ cell2.CB_1.config_dataA\[16\] vssd1 vssd1 vccd1 vccd1 _04898_
+ sky130_fd_sc_hd__o21ai_1
XTAP_TAPCELL_ROW_127_2220 vssd1 vccd1 sky130_fd_sc_hd__tapvpwrvgnd_1
XFILLER_85_613 vssd1 vssd1 vccd1 vccd1 sky130_fd_sc_hd__fill_1
X_08843_ net469 _03873_ _03874_ vssd1 vssd1 vccd1 vccd1 _03875_ sky130_fd_sc_hd__a21o_1
XANTENNA_fanout289_A cell3.CB_1.le_outB vssd1 vssd1 vccd1 vccd1 sky130_fd_sc_hd__diode_2
X_08774_ cell1.LE_1B.config_data\[9\] cell1.LE_1B.config_data\[8\] _03735_ vssd1 vssd1
+ vccd1 vccd1 _03808_ sky130_fd_sc_hd__mux2_1
XFILLER_27_27 vccd1 vssd1 vccd1 vssd1 sky130_ef_sc_hd__decap_40_12
XANTENNA__11301__A0 _05489_ vssd1 vssd1 vccd1 vccd1 sky130_fd_sc_hd__diode_2
XFILLER_72_307 vssd1 vssd1 vccd1 vccd1 sky130_fd_sc_hd__fill_1
X_07725_ cell1.SB0.route_sel\[26\] cell1.SB0.route_sel\[27\] _02765_ _02766_ _02771_
+ vssd1 vssd1 vccd1 vccd1 _02772_ sky130_fd_sc_hd__a41o_1
XTAP_TAPCELL_ROW_0_300 vssd1 vccd1 sky130_fd_sc_hd__tapvpwrvgnd_1
XTAP_TAPCELL_ROW_0_311 vssd1 vccd1 sky130_fd_sc_hd__tapvpwrvgnd_1
XANTENNA__10939__X _05893_ vssd1 vssd1 vccd1 vccd1 sky130_fd_sc_hd__diode_2
XFILLER_81_841 vssd1 vssd1 vccd1 vccd1 sky130_fd_sc_hd__fill_1
XANTENNA_clkbuf_4_2_0_clk_X clknet_4_2_0_clk vssd1 vssd1 vccd1 vccd1 sky130_fd_sc_hd__diode_2
XFILLER_26_757 vssd1 vssd1 vccd1 vccd1 sky130_fd_sc_hd__fill_1
X_07656_ _02701_ _02703_ _02702_ vssd1 vssd1 vccd1 vccd1 _02704_ sky130_fd_sc_hd__a21o_1
XFILLER_25_256 vssd1 vssd1 vccd1 vccd1 sky130_fd_sc_hd__fill_1
XANTENNA_fanout623_A net650 vssd1 vssd1 vccd1 vccd1 sky130_fd_sc_hd__diode_2
XTAP_TAPCELL_ROW_105_1883 vssd1 vccd1 sky130_fd_sc_hd__tapvpwrvgnd_1
X_06607_ cell3.SB0.route_sel\[5\] vssd1 vssd1 vccd1 vccd1 _01677_ sky130_fd_sc_hd__inv_2
X_07587_ _02608_ _02634_ _02636_ vssd1 vssd1 vccd1 vccd1 _02637_ sky130_fd_sc_hd__a21o_1
X_06538_ cell2.SB0.route_sel\[47\] vssd1 vssd1 vccd1 vccd1 _01608_ sky130_fd_sc_hd__inv_2
X_09326_ net318 _04327_ _04350_ cell3.SB0.route_sel\[28\] cell3.SB0.route_sel\[29\]
+ vssd1 vssd1 vccd1 vccd1 _04351_ sky130_fd_sc_hd__o2111a_1
X_09257_ _04282_ net317 _04279_ vssd1 vssd1 vccd1 vccd1 _04283_ sky130_fd_sc_hd__mux2_1
XANTENNA__08076__A3 net340 vssd1 vssd1 vccd1 vccd1 sky130_fd_sc_hd__diode_2
XANTENNA__07967__Y _03011_ vssd1 vssd1 vccd1 vccd1 sky130_fd_sc_hd__diode_2
XFILLER_21_451 vssd1 vssd1 vccd1 vccd1 sky130_fd_sc_hd__fill_1
XTAP_TAPCELL_ROW_138_2382 vssd1 vccd1 sky130_fd_sc_hd__tapvpwrvgnd_1
XTAP_TAPCELL_ROW_138_2371 vssd1 vccd1 sky130_fd_sc_hd__tapvpwrvgnd_1
X_08208_ net538 _03246_ _03247_ vssd1 vssd1 vccd1 vccd1 _03248_ sky130_fd_sc_hd__a21oi_1
X_06469_ cell1.SB0.route_sel\[97\] vssd1 vssd1 vccd1 vccd1 _01539_ sky130_fd_sc_hd__inv_2
XFILLER_135_821 vssd1 vssd1 vccd1 vccd1 sky130_fd_sc_hd__fill_4
X_09188_ cell3.CB_0.config_dataB\[22\] cell3.CB_0.config_dataB\[23\] vssd1 vssd1 vccd1
+ vccd1 _04216_ sky130_fd_sc_hd__nor2_1
XFILLER_5_617 vccd1 vssd1 vccd1 vssd1 sky130_ef_sc_hd__decap_40_12
X_08139_ _03171_ _03174_ _03178_ cell0.CB_1.config_dataA\[3\] vssd1 vssd1 vccd1 vccd1
+ _03179_ sky130_fd_sc_hd__and4bb_1
X_11150_ _05924_ _06079_ vssd1 vssd1 vccd1 vccd1 _06102_ sky130_fd_sc_hd__nor2_1
XANTENNA__10040__A0 bus3_2\[12\] vssd1 vssd1 vccd1 vccd1 sky130_fd_sc_hd__diode_2
XANTENNA_fanout780_X net780 vssd1 vssd1 vccd1 vccd1 sky130_fd_sc_hd__diode_2
X_10101_ _01651_ cell2.SB0.config_data_out _01653_ cell2.SB0.route_sel\[124\] _05101_
+ vssd1 vssd1 vccd1 vccd1 _05102_ sky130_fd_sc_hd__a221o_1
XTAP_TAPCELL_ROW_8_433 vssd1 vccd1 sky130_fd_sc_hd__tapvpwrvgnd_1
XTAP_TAPCELL_ROW_8_422 vssd1 vccd1 sky130_fd_sc_hd__tapvpwrvgnd_1
XFILLER_1_845 vssd1 vssd1 vccd1 vccd1 sky130_fd_sc_hd__fill_1
XANTENNA__08798__Y _03830_ vssd1 vssd1 vccd1 vccd1 sky130_fd_sc_hd__diode_2
X_11081_ cell3.LE_0A.config_data\[2\] cell3.LE_0A.config_data\[3\] _05930_ vssd1 vssd1
+ vccd1 vccd1 _06035_ sky130_fd_sc_hd__mux2_1
XANTENNA__10343__A1 net308 vssd1 vssd1 vccd1 vccd1 sky130_fd_sc_hd__diode_2
X_10032_ bus3_2\[8\] bus3_2\[9\] bus3_2\[10\] bus3_2\[11\] net400 net399 vssd1 vssd1
+ vccd1 vccd1 _05036_ sky130_fd_sc_hd__mux4_1
XFILLER_76_635 vssd1 vssd1 vccd1 vccd1 sky130_fd_sc_hd__fill_1
XFILLER_0_388 vssd1 vssd1 vccd1 vccd1 sky130_fd_sc_hd__fill_4
XFILLER_48_359 vssd1 vssd1 vccd1 vccd1 sky130_fd_sc_hd__fill_4
XANTENNA_input17_A CBeast_in[24] vssd1 vssd1 vccd1 vccd1 sky130_fd_sc_hd__diode_2
XANTENNA__09703__X bus3_1\[14\] vssd1 vssd1 vccd1 vccd1 sky130_fd_sc_hd__diode_2
XFILLER_75_178 vssd1 vssd1 vccd1 vccd1 sky130_fd_sc_hd__fill_2
XFILLER_29_551 vssd1 vssd1 vccd1 vccd1 sky130_fd_sc_hd__fill_8
X_13722_ clknet_leaf_35_clk _00694_ net636 vssd1 vssd1 vccd1 vccd1 cell2.CB_0.config_dataA\[24\]
+ sky130_fd_sc_hd__dfstp_1
XFILLER_90_137 vssd1 vssd1 vccd1 vccd1 sky130_fd_sc_hd__fill_2
XFILLER_84_690 vssd1 vssd1 vccd1 vccd1 sky130_fd_sc_hd__fill_2
XTAP_TAPCELL_ROW_67_1311 vssd1 vccd1 sky130_fd_sc_hd__tapvpwrvgnd_1
X_11983_ cell0.SB0.route_sel\[89\] cell0.SB0.route_sel\[88\] net791 vssd1 vssd1 vccd1
+ vccd1 _00420_ sky130_fd_sc_hd__mux2_1
XANTENNA__10646__A2 net24 vssd1 vssd1 vccd1 vccd1 sky130_fd_sc_hd__diode_2
X_10934_ cell3.SB0.route_sel\[60\] _01716_ vssd1 vssd1 vccd1 vccd1 _05888_ sky130_fd_sc_hd__nand2_1
XFILLER_17_768 vssd1 vssd1 vccd1 vccd1 sky130_fd_sc_hd__fill_1
XFILLER_140_83 vssd1 vssd1 vccd1 vccd1 sky130_fd_sc_hd__fill_1
X_13653_ clknet_leaf_40_clk _00625_ net643 vssd1 vssd1 vccd1 vccd1 cell2.CB_1.config_dataA\[5\]
+ sky130_fd_sc_hd__dfstp_1
X_10865_ _05513_ _05797_ vssd1 vssd1 vccd1 vccd1 _05821_ sky130_fd_sc_hd__nor2_1
XTAP_TAPCELL_ROW_80_1511 vssd1 vccd1 sky130_fd_sc_hd__tapvpwrvgnd_1
XFILLER_71_373 vssd1 vssd1 vccd1 vccd1 sky130_fd_sc_hd__fill_1
XFILLER_44_587 vssd1 vssd1 vccd1 vccd1 sky130_fd_sc_hd__fill_1
X_13584_ clknet_leaf_88_clk _00556_ net688 vssd1 vssd1 vccd1 vccd1 cell1.LEI0.config_data\[5\]
+ sky130_fd_sc_hd__dfrtp_1
X_12604_ cell3.SB0.route_sel\[69\] cell3.SB0.route_sel\[68\] net878 vssd1 vssd1 vccd1
+ vccd1 _01033_ sky130_fd_sc_hd__mux2_1
X_10796_ _05729_ _05737_ _05751_ cell3.CB_1.config_dataB\[9\] vssd1 vssd1 vccd1 vccd1
+ _05752_ sky130_fd_sc_hd__a211o_1
X_12535_ cell3.SB0.route_sel\[0\] cell3.CB_1.config_dataB\[24\] net936 vssd1 vssd1
+ vccd1 vccd1 _00964_ sky130_fd_sc_hd__mux2_1
XFILLER_12_440 vssd1 vssd1 vccd1 vccd1 sky130_fd_sc_hd__fill_2
XFILLER_8_444 vssd1 vssd1 vccd1 vccd1 sky130_fd_sc_hd__fill_2
XFILLER_33_81 vssd1 vssd1 vccd1 vccd1 sky130_fd_sc_hd__fill_8
X_12466_ net1057 cell2.LE_0A.config_data\[2\] net813 vssd1 vssd1 vccd1 vccd1 _00896_
+ sky130_fd_sc_hd__mux2_1
X_14205_ clknet_leaf_56_clk _01177_ net719 vssd1 vssd1 vccd1 vccd1 cell3.CB_0.config_dataA\[15\]
+ sky130_fd_sc_hd__dfstp_1
XFILLER_125_320 vssd1 vssd1 vccd1 vccd1 sky130_fd_sc_hd__fill_1
X_12397_ cell2.CB_1.config_dataB\[7\] net405 net848 vssd1 vssd1 vccd1 vccd1 _00830_
+ sky130_fd_sc_hd__mux2_1
XTAP_TAPCELL_ROW_78_1473 vssd1 vccd1 sky130_fd_sc_hd__tapvpwrvgnd_1
X_11417_ _06278_ _02346_ vssd1 vssd1 vccd1 vccd1 net201 sky130_fd_sc_hd__and2b_1
X_14136_ clknet_leaf_66_clk _01108_ net743 vssd1 vssd1 vccd1 vccd1 cell3.LE_1B.config_data\[16\]
+ sky130_fd_sc_hd__dfrtp_1
X_11348_ net281 _04598_ _04599_ _06239_ vssd1 vssd1 vccd1 vccd1 net184 sky130_fd_sc_hd__a22o_1
XTAP_TAPCELL_ROW_78_1484 vssd1 vccd1 sky130_fd_sc_hd__tapvpwrvgnd_1
XANTENNA__08989__X cell1.CB_0.le_outA vssd1 vssd1 vccd1 vccd1 sky130_fd_sc_hd__diode_2
X_11279_ _05111_ net307 _02463_ vssd1 vssd1 vccd1 vccd1 _06208_ sky130_fd_sc_hd__mux2_1
XFILLER_113_559 vssd1 vssd1 vccd1 vccd1 sky130_fd_sc_hd__fill_1
XTAP_TAPCELL_ROW_91_1673 vssd1 vccd1 sky130_fd_sc_hd__tapvpwrvgnd_1
X_14067_ clknet_leaf_14_clk _01039_ net668 vssd1 vssd1 vccd1 vccd1 cell3.SB0.route_sel\[75\]
+ sky130_fd_sc_hd__dfstp_1
XFILLER_3_193 vccd1 vssd1 vccd1 vssd1 sky130_ef_sc_hd__decap_40_12
X_13018_ net1426 cell3.LEI0.config_data\[38\] net949 vssd1 vssd1 vccd1 vccd1 _01446_
+ sky130_fd_sc_hd__mux2_1
XFILLER_94_410 vssd1 vssd1 vccd1 vccd1 sky130_fd_sc_hd__fill_8
XFILLER_94_421 vssd1 vssd1 vccd1 vccd1 sky130_fd_sc_hd__fill_8
XFILLER_39_337 vssd1 vssd1 vccd1 vccd1 sky130_fd_sc_hd__fill_1
XFILLER_54_307 vssd1 vssd1 vccd1 vccd1 sky130_fd_sc_hd__fill_1
XFILLER_81_115 vssd1 vssd1 vccd1 vccd1 sky130_fd_sc_hd__fill_1
XFILLER_75_690 vssd1 vssd1 vccd1 vccd1 sky130_fd_sc_hd__fill_1
X_07510_ cell1.SB0.route_sel\[125\] cell1.SB0.route_sel\[124\] vssd1 vssd1 vccd1 vccd1
+ _02562_ sky130_fd_sc_hd__nand2_1
X_08490_ cell1.CB_1.config_dataA\[1\] _03524_ _03525_ vssd1 vssd1 vccd1 vccd1 _03526_
+ sky130_fd_sc_hd__a21oi_1
X_07441_ _02494_ vssd1 vssd1 vccd1 vccd1 _02495_ sky130_fd_sc_hd__inv_2
X_07372_ cell0.CB_1.le_outA _02405_ _02427_ cell1.SB0.route_sel\[108\] cell1.SB0.route_sel\[109\]
+ vssd1 vssd1 vccd1 vccd1 _02428_ sky130_fd_sc_hd__o2111a_1
X_09111_ net476 _03885_ _04140_ net475 vssd1 vssd1 vccd1 vccd1 _04141_ sky130_fd_sc_hd__o211a_1
XTAP_TAPCELL_ROW_33_799 vssd1 vccd1 sky130_fd_sc_hd__tapvpwrvgnd_1
X_09042_ cell1.CB_0.config_dataB\[2\] _04071_ cell1.CB_0.config_dataB\[3\] vssd1 vssd1
+ vccd1 vccd1 _04072_ sky130_fd_sc_hd__a21bo_1
XANTENNA__09007__A2 _03817_ vssd1 vssd1 vccd1 vccd1 sky130_fd_sc_hd__diode_2
Xhold411 cell2.LEI0.config_data\[13\] vssd1 vssd1 vccd1 vccd1 net1370 sky130_fd_sc_hd__dlygate4sd3_1
Xhold400 _00564_ vssd1 vssd1 vccd1 vccd1 net1359 sky130_fd_sc_hd__dlygate4sd3_1
Xhold422 cell3.LEI0.config_data\[42\] vssd1 vssd1 vccd1 vccd1 net1381 sky130_fd_sc_hd__dlygate4sd3_1
Xhold444 cell3.LEI0.config_data\[0\] vssd1 vssd1 vccd1 vccd1 net1403 sky130_fd_sc_hd__dlygate4sd3_1
Xhold433 cell3.LE_1A.config_data\[8\] vssd1 vssd1 vccd1 vccd1 net1392 sky130_fd_sc_hd__dlygate4sd3_1
Xhold455 cell3.LEI0.config_data\[35\] vssd1 vssd1 vccd1 vccd1 net1414 sky130_fd_sc_hd__dlygate4sd3_1
Xhold466 _01448_ vssd1 vssd1 vccd1 vccd1 net1425 sky130_fd_sc_hd__dlygate4sd3_1
XFILLER_89_237 vssd1 vssd1 vccd1 vccd1 sky130_fd_sc_hd__fill_1
Xhold477 _00200_ vssd1 vssd1 vccd1 vccd1 net1436 sky130_fd_sc_hd__dlygate4sd3_1
Xhold499 cell3.LEI0.config_data\[4\] vssd1 vssd1 vccd1 vccd1 net1458 sky130_fd_sc_hd__dlygate4sd3_1
Xfanout924 net925 vssd1 vssd1 vccd1 vccd1 net924 sky130_fd_sc_hd__clkbuf_4
Xfanout913 net916 vssd1 vssd1 vccd1 vccd1 net913 sky130_fd_sc_hd__clkbuf_4
X_09944_ net409 _04608_ vssd1 vssd1 vccd1 vccd1 _04948_ sky130_fd_sc_hd__nand2_1
Xfanout902 net907 vssd1 vssd1 vccd1 vccd1 net902 sky130_fd_sc_hd__buf_2
Xhold488 _00561_ vssd1 vssd1 vccd1 vccd1 net1447 sky130_fd_sc_hd__dlygate4sd3_1
XANTENNA__10325__A1 net44 vssd1 vssd1 vccd1 vccd1 sky130_fd_sc_hd__diode_2
Xfanout957 net958 vssd1 vssd1 vccd1 vccd1 net957 sky130_fd_sc_hd__clkbuf_4
XANTENNA_input9_A CBeast_in[17] vssd1 vssd1 vccd1 vccd1 sky130_fd_sc_hd__diode_2
Xfanout946 net952 vssd1 vssd1 vccd1 vccd1 net946 sky130_fd_sc_hd__clkbuf_2
X_09875_ _04880_ _04879_ cell2.CB_1.config_dataA\[17\] vssd1 vssd1 vccd1 vccd1 _04881_
+ sky130_fd_sc_hd__mux2_1
Xfanout935 net936 vssd1 vssd1 vccd1 vccd1 net935 sky130_fd_sc_hd__clkbuf_4
XFILLER_97_281 vssd1 vssd1 vccd1 vccd1 sky130_fd_sc_hd__fill_2
XANTENNA__07027__Y _02092_ vssd1 vssd1 vccd1 vccd1 sky130_fd_sc_hd__diode_2
X_08826_ _02738_ _03857_ vssd1 vssd1 vccd1 vccd1 _03858_ sky130_fd_sc_hd__or2_4
XANTENNA__07741__A2 cell1.SB0.route_sel\[35\] vssd1 vssd1 vccd1 vccd1 sky130_fd_sc_hd__diode_2
XANTENNA_fanout838_A net845 vssd1 vssd1 vccd1 vccd1 sky130_fd_sc_hd__diode_2
XTAP_TAPCELL_ROW_107_1912 vssd1 vccd1 sky130_fd_sc_hd__tapvpwrvgnd_1
X_08757_ _01660_ _03786_ _03787_ _03790_ vssd1 vssd1 vccd1 vccd1 _03791_ sky130_fd_sc_hd__o2bb2a_1
XANTENNA_fanout361_X net361 vssd1 vssd1 vccd1 vccd1 sky130_fd_sc_hd__diode_2
XFILLER_72_148 vssd1 vssd1 vccd1 vccd1 sky130_fd_sc_hd__fill_1
X_07708_ net345 _01947_ _02624_ _02620_ _01943_ vssd1 vssd1 vccd1 vccd1 _02755_ sky130_fd_sc_hd__o32a_1
XFILLER_54_25 vssd1 vssd1 vccd1 vccd1 sky130_fd_sc_hd__fill_1
XTAP_TAPCELL_ROW_49_1041 vssd1 vccd1 sky130_fd_sc_hd__tapvpwrvgnd_1
X_08688_ cell1.CB_1.config_dataB\[3\] cell1.CB_1.config_dataB\[2\] vssd1 vssd1 vccd1
+ vccd1 _03722_ sky130_fd_sc_hd__nor2_1
XFILLER_26_554 vssd1 vssd1 vccd1 vccd1 sky130_fd_sc_hd__fill_2
XFILLER_81_671 vssd1 vssd1 vccd1 vccd1 sky130_fd_sc_hd__fill_1
X_07639_ net320 net12 _02685_ vssd1 vssd1 vccd1 vccd1 _02688_ sky130_fd_sc_hd__mux2_1
X_10650_ net393 _05544_ _05607_ vssd1 vssd1 vccd1 vccd1 _05608_ sky130_fd_sc_hd__a21oi_1
XFILLER_80_192 vssd1 vssd1 vccd1 vccd1 sky130_fd_sc_hd__fill_1
X_09309_ cell2.SB0.route_sel\[27\] cell2.SB0.route_sel\[26\] vssd1 vssd1 vccd1 vccd1
+ _04334_ sky130_fd_sc_hd__nand2_1
XTAP_TAPCELL_ROW_62_1241 vssd1 vccd1 sky130_fd_sc_hd__tapvpwrvgnd_1
X_10581_ cell3.SB0.route_sel\[80\] _01728_ cell3.SB0.route_sel\[85\] cell3.SB0.route_sel\[84\]
+ _05538_ vssd1 vssd1 vccd1 vccd1 _05539_ sky130_fd_sc_hd__o221a_1
XFILLER_22_782 vssd1 vssd1 vccd1 vccd1 sky130_fd_sc_hd__fill_1
XFILLER_126_106 vssd1 vssd1 vccd1 vccd1 sky130_fd_sc_hd__fill_1
X_12320_ cell1.SB0.route_sel\[58\] cell1.SB0.route_sel\[57\] net856 vssd1 vssd1 vccd1
+ vccd1 _00753_ sky130_fd_sc_hd__mux2_1
XFILLER_119_51 vssd1 vssd1 vccd1 vccd1 sky130_fd_sc_hd__fill_4
X_12251_ cell2.CB_0.config_dataA\[14\] cell2.CB_0.config_dataA\[13\] net822 vssd1
+ vssd1 vccd1 vccd1 _00684_ sky130_fd_sc_hd__mux2_1
XANTENNA__10564__B _05521_ vssd1 vssd1 vccd1 vccd1 sky130_fd_sc_hd__diode_2
XFILLER_5_447 vssd1 vssd1 vccd1 vccd1 sky130_fd_sc_hd__fill_1
XANTENNA__08206__A0 bus1_0\[6\] vssd1 vssd1 vccd1 vccd1 sky130_fd_sc_hd__diode_2
X_11202_ _01802_ _05916_ _06153_ vssd1 vssd1 vccd1 vccd1 _06154_ sky130_fd_sc_hd__o21ai_1
X_12182_ net1267 net1348 net851 vssd1 vssd1 vccd1 vccd1 _00615_ sky130_fd_sc_hd__mux2_1
XFILLER_79_55 vssd1 vssd1 vccd1 vccd1 sky130_fd_sc_hd__fill_1
XANTENNA__08221__A3 net339 vssd1 vssd1 vccd1 vccd1 sky130_fd_sc_hd__diode_2
X_11133_ _06083_ _06084_ _01799_ vssd1 vssd1 vccd1 vccd1 _06085_ sky130_fd_sc_hd__mux2_1
XFILLER_1_653 vccd1 vssd1 vccd1 vssd1 sky130_ef_sc_hd__decap_40_12
X_11064_ _01812_ _06013_ _06014_ _06017_ vssd1 vssd1 vccd1 vccd1 _06018_ sky130_fd_sc_hd__o2bb2a_1
XFILLER_0_141 vssd1 vssd1 vccd1 vccd1 sky130_fd_sc_hd__fill_1
XANTENNA__06783__A3 net360 vssd1 vssd1 vccd1 vccd1 sky130_fd_sc_hd__diode_2
XANTENNA__07218__X _02278_ vssd1 vssd1 vccd1 vccd1 sky130_fd_sc_hd__diode_2
X_10015_ net403 _04498_ vssd1 vssd1 vccd1 vccd1 _05019_ sky130_fd_sc_hd__nand2_1
XFILLER_1_697 vccd1 vssd1 vccd1 vssd1 sky130_ef_sc_hd__decap_40_12
XFILLER_64_605 vssd1 vssd1 vccd1 vccd1 sky130_fd_sc_hd__fill_1
XFILLER_48_156 vssd1 vssd1 vccd1 vccd1 sky130_fd_sc_hd__fill_1
XFILLER_63_137 vssd1 vssd1 vccd1 vccd1 sky130_fd_sc_hd__fill_1
XANTENNA__06776__Y _01846_ vssd1 vssd1 vccd1 vccd1 sky130_fd_sc_hd__diode_2
XANTENNA__09485__A2 _04504_ vssd1 vssd1 vccd1 vccd1 sky130_fd_sc_hd__diode_2
X_11966_ cell0.SB0.route_sel\[72\] cell0.SB0.route_sel\[71\] net766 vssd1 vssd1 vccd1
+ vccd1 _00403_ sky130_fd_sc_hd__mux2_1
X_13705_ clknet_leaf_28_clk _00677_ net617 vssd1 vssd1 vccd1 vccd1 cell2.CB_0.config_dataA\[7\]
+ sky130_fd_sc_hd__dfstp_1
X_10917_ _04617_ _04623_ _04630_ _05870_ vssd1 vssd1 vccd1 vccd1 _05871_ sky130_fd_sc_hd__a211o_2
X_13636_ clknet_leaf_39_clk _00608_ net647 vssd1 vssd1 vccd1 vccd1 cell2.LE_1B.config_data\[8\]
+ sky130_fd_sc_hd__dfrtp_1
X_11897_ cell0.SB0.route_sel\[3\] cell0.SB0.route_sel\[2\] net781 vssd1 vssd1 vccd1
+ vccd1 _00334_ sky130_fd_sc_hd__mux2_1
X_10848_ cell3.CB_1.config_dataB\[16\] _05803_ vssd1 vssd1 vccd1 vccd1 _05804_ sky130_fd_sc_hd__nand2_1
XANTENNA__12446__S net827 vssd1 vssd1 vccd1 vccd1 sky130_fd_sc_hd__diode_2
X_10779_ _05553_ _05727_ vssd1 vssd1 vccd1 vccd1 _05735_ sky130_fd_sc_hd__nor2_1
X_13567_ clknet_leaf_118_clk _00539_ net668 vssd1 vssd1 vccd1 vccd1 cell1.LE_0A.config_data\[10\]
+ sky130_fd_sc_hd__dfrtp_1
XANTENNA__08445__A0 net4 vssd1 vssd1 vccd1 vccd1 sky130_fd_sc_hd__diode_2
X_12518_ net1095 cell2.LEI0.config_data\[31\] net847 vssd1 vssd1 vccd1 vccd1 _00947_
+ sky130_fd_sc_hd__mux2_1
XFILLER_8_241 vssd1 vssd1 vccd1 vccd1 sky130_fd_sc_hd__fill_1
X_13498_ clknet_leaf_98_clk _00470_ net683 vssd1 vssd1 vccd1 vccd1 cell1.CB_1.config_dataB\[11\]
+ sky130_fd_sc_hd__dfstp_1
XTAP_TAPCELL_ROW_30_758 vssd1 vccd1 sky130_fd_sc_hd__tapvpwrvgnd_1
X_12449_ net1279 cell2.LE_0B.config_data\[8\] net842 vssd1 vssd1 vccd1 vccd1 _00880_
+ sky130_fd_sc_hd__mux2_1
XTAP_TAPCELL_ROW_93_1702 vssd1 vccd1 sky130_fd_sc_hd__tapvpwrvgnd_1
XTAP_TAPCELL_ROW_10_460 vssd1 vccd1 sky130_fd_sc_hd__tapvpwrvgnd_1
XPHY_EDGE_ROW_136_Left_279 vssd1 vssd1 vccd1 vccd1 sky130_fd_sc_hd__decap_3
XFILLER_113_301 vssd1 vssd1 vccd1 vccd1 sky130_fd_sc_hd__fill_1
X_14119_ clknet_leaf_47_clk _01091_ net704 vssd1 vssd1 vccd1 vccd1 net262 sky130_fd_sc_hd__dfstp_4
X_07990_ net530 _02301_ vssd1 vssd1 vccd1 vccd1 _03032_ sky130_fd_sc_hd__nand2_1
X_06941_ _01990_ _01991_ _01999_ _02007_ net551 vssd1 vssd1 vccd1 vccd1 _02008_ sky130_fd_sc_hd__o311a_2
X_09660_ cell3.SB0.route_sel\[107\] cell3.SB0.route_sel\[106\] vssd1 vssd1 vccd1 vccd1
+ _04675_ sky130_fd_sc_hd__nand2_1
XANTENNA__09173__A1 _04174_ vssd1 vssd1 vccd1 vccd1 sky130_fd_sc_hd__diode_2
XFILLER_39_167 vssd1 vssd1 vccd1 vccd1 sky130_fd_sc_hd__fill_1
X_06872_ _01463_ _01464_ net126 cell0.SB0.route_sel\[60\] cell0.SB0.route_sel\[61\]
+ vssd1 vssd1 vccd1 vccd1 _01940_ sky130_fd_sc_hd__o2111a_1
X_08611_ _03637_ _03644_ cell1.CB_1.config_dataA\[17\] vssd1 vssd1 vccd1 vccd1 _03647_
+ sky130_fd_sc_hd__mux2_1
XANTENNA__08920__A1 _03871_ vssd1 vssd1 vccd1 vccd1 sky130_fd_sc_hd__diode_2
X_09591_ _02320_ _04607_ vssd1 vssd1 vccd1 vccd1 _04608_ sky130_fd_sc_hd__and2_2
XANTENNA__08920__B2 _03868_ vssd1 vssd1 vccd1 vccd1 sky130_fd_sc_hd__diode_2
XTAP_TAPCELL_ROW_120_2109 vssd1 vccd1 sky130_fd_sc_hd__tapvpwrvgnd_1
X_08542_ cell1.LEI0.config_data\[19\] _03577_ vssd1 vssd1 vccd1 vccd1 _03578_ sky130_fd_sc_hd__nor2_1
X_08473_ _03508_ _02780_ vssd1 vssd1 vccd1 vccd1 _03509_ sky130_fd_sc_hd__and2b_4
XTAP_TAPCELL_ROW_18_571 vssd1 vccd1 sky130_fd_sc_hd__tapvpwrvgnd_1
XTAP_TAPCELL_ROW_102_1831 vssd1 vccd1 sky130_fd_sc_hd__tapvpwrvgnd_1
XTAP_TAPCELL_ROW_18_582 vssd1 vccd1 sky130_fd_sc_hd__tapvpwrvgnd_1
X_07424_ cell0.CB_1.le_outA _02472_ _02476_ _02477_ vssd1 vssd1 vccd1 vccd1 _02478_
+ sky130_fd_sc_hd__a2bb2o_1
XTAP_TAPCELL_ROW_102_1842 vssd1 vccd1 sky130_fd_sc_hd__tapvpwrvgnd_1
XANTENNA__10936__Y _05890_ vssd1 vssd1 vccd1 vccd1 sky130_fd_sc_hd__diode_2
X_07355_ cell0.SB0.route_sel\[110\] cell0.SB0.route_sel\[111\] vssd1 vssd1 vccd1 vccd1
+ _02411_ sky130_fd_sc_hd__nand2_1
XANTENNA_fanout321_A net322 vssd1 vssd1 vccd1 vccd1 sky130_fd_sc_hd__diode_2
XTAP_TAPCELL_ROW_135_2330 vssd1 vccd1 sky130_fd_sc_hd__tapvpwrvgnd_1
XANTENNA__10243__A0 net61 vssd1 vssd1 vccd1 vccd1 sky130_fd_sc_hd__diode_2
X_07286_ _02337_ _02342_ _02343_ _02338_ vssd1 vssd1 vccd1 vccd1 _02344_ sky130_fd_sc_hd__o31a_1
XANTENNA__10384__B _05103_ vssd1 vssd1 vccd1 vccd1 sky130_fd_sc_hd__diode_2
XANTENNA__10794__A1 _05510_ vssd1 vssd1 vccd1 vccd1 sky130_fd_sc_hd__diode_2
X_09025_ net485 net484 vssd1 vssd1 vccd1 vccd1 _04055_ sky130_fd_sc_hd__nor2_1
Xhold230 cell3.LEI0.config_data\[43\] vssd1 vssd1 vccd1 vccd1 net1189 sky130_fd_sc_hd__dlygate4sd3_1
XANTENNA__11743__A0 cell0.LE_0A.config_data\[16\] vssd1 vssd1 vccd1 vccd1 sky130_fd_sc_hd__diode_2
XANTENNA_fanout690_A net691 vssd1 vssd1 vccd1 vccd1 sky130_fd_sc_hd__diode_2
XANTENNA__09400__A2 cell3.SB0.route_sel\[45\] vssd1 vssd1 vccd1 vccd1 sky130_fd_sc_hd__diode_2
Xhold252 _00150_ vssd1 vssd1 vccd1 vccd1 net1211 sky130_fd_sc_hd__dlygate4sd3_1
XFILLER_2_417 vssd1 vssd1 vccd1 vccd1 sky130_fd_sc_hd__fill_2
Xhold241 cell1.LE_1A.config_data\[1\] vssd1 vssd1 vccd1 vccd1 net1200 sky130_fd_sc_hd__dlygate4sd3_1
Xhold285 cell3.LE_0A.config_data\[9\] vssd1 vssd1 vccd1 vccd1 net1244 sky130_fd_sc_hd__dlygate4sd3_1
XFILLER_132_654 vssd1 vssd1 vccd1 vccd1 sky130_fd_sc_hd__fill_1
Xhold263 _01094_ vssd1 vssd1 vccd1 vccd1 net1222 sky130_fd_sc_hd__dlygate4sd3_1
Xhold274 cell3.LE_0A.config_data\[1\] vssd1 vssd1 vccd1 vccd1 net1233 sky130_fd_sc_hd__dlygate4sd3_1
Xhold296 _00156_ vssd1 vssd1 vccd1 vccd1 net1255 sky130_fd_sc_hd__dlygate4sd3_1
XANTENNA__08789__B _03820_ vssd1 vssd1 vccd1 vccd1 sky130_fd_sc_hd__diode_2
XANTENNA_fanout788_A net790 vssd1 vssd1 vccd1 vccd1 sky130_fd_sc_hd__diode_2
Xfanout721 net722 vssd1 vssd1 vccd1 vccd1 net721 sky130_fd_sc_hd__clkbuf_4
Xfanout732 net733 vssd1 vssd1 vccd1 vccd1 net732 sky130_fd_sc_hd__buf_2
Xfanout710 net713 vssd1 vssd1 vccd1 vccd1 net710 sky130_fd_sc_hd__clkbuf_2
X_09927_ net408 _04930_ vssd1 vssd1 vccd1 vccd1 _04931_ sky130_fd_sc_hd__and2_1
Xfanout743 net746 vssd1 vssd1 vccd1 vccd1 net743 sky130_fd_sc_hd__clkbuf_4
Xfanout754 net132 vssd1 vssd1 vccd1 vccd1 net754 sky130_fd_sc_hd__buf_4
XFILLER_58_421 vssd1 vssd1 vccd1 vccd1 sky130_fd_sc_hd__fill_1
Xfanout776 net780 vssd1 vssd1 vccd1 vccd1 net776 sky130_fd_sc_hd__buf_2
Xfanout765 net767 vssd1 vssd1 vccd1 vccd1 net765 sky130_fd_sc_hd__clkbuf_2
X_09858_ net312 net308 cell2.LEI0.config_data\[30\] vssd1 vssd1 vccd1 vccd1 _04864_
+ sky130_fd_sc_hd__mux2_1
Xfanout798 net806 vssd1 vssd1 vccd1 vccd1 net798 sky130_fd_sc_hd__clkbuf_2
Xfanout787 net807 vssd1 vssd1 vccd1 vccd1 net787 sky130_fd_sc_hd__buf_2
X_09789_ bus3_2\[12\] bus3_2\[14\] bus3_2\[13\] bus3_2\[15\] net446 net447 vssd1 vssd1
+ vccd1 vccd1 _04795_ sky130_fd_sc_hd__mux4_1
XFILLER_39_690 vssd1 vssd1 vccd1 vccd1 sky130_fd_sc_hd__fill_2
X_08809_ _03838_ _03839_ _03840_ _02230_ vssd1 vssd1 vccd1 vccd1 _03841_ sky130_fd_sc_hd__a31o_2
X_11820_ net496 net498 net894 vssd1 vssd1 vccd1 vccd1 _00257_ sky130_fd_sc_hd__mux2_1
XANTENNA__08124__C1 net351 vssd1 vssd1 vccd1 vccd1 sky130_fd_sc_hd__diode_2
X_11751_ net1113 net1423 net796 vssd1 vssd1 vccd1 vccd1 _00188_ sky130_fd_sc_hd__mux2_1
XANTENNA_input119_A SBwest_in[2] vssd1 vssd1 vccd1 vccd1 sky130_fd_sc_hd__diode_2
X_10702_ net13 _05642_ _05644_ net14 cell3.CB_1.config_dataA\[18\] vssd1 vssd1 vccd1
+ vccd1 _05660_ sky130_fd_sc_hd__a221o_1
Xclkbuf_leaf_80_clk clknet_4_12_0_clk vssd1 vssd1 vccd1 vccd1 clknet_leaf_80_clk sky130_fd_sc_hd__clkbuf_8
X_14470_ clknet_leaf_60_clk net1415 net740 vssd1 vssd1 vccd1 vccd1 cell3.LEI0.config_data\[35\]
+ sky130_fd_sc_hd__dfrtp_1
X_11682_ net1299 cell0.LE_1A.config_data\[0\] net801 vssd1 vssd1 vccd1 vccd1 _00122_
+ sky130_fd_sc_hd__mux2_1
XANTENNA__11026__A2 net42 vssd1 vssd1 vccd1 vccd1 sky130_fd_sc_hd__diode_2
X_10633_ _04354_ _04362_ _04370_ _05503_ _01785_ vssd1 vssd1 vccd1 vccd1 _05591_ sky130_fd_sc_hd__a2111o_1
X_13421_ clknet_leaf_131_clk _00393_ net557 vssd1 vssd1 vccd1 vccd1 cell0.SB0.route_sel\[62\]
+ sky130_fd_sc_hd__dfstp_1
X_10564_ net272 _05521_ vssd1 vssd1 vccd1 vccd1 _05522_ sky130_fd_sc_hd__nor2_1
X_13352_ clknet_leaf_117_clk _00324_ net671 vssd1 vssd1 vccd1 vccd1 cell1.CB_0.config_dataA\[18\]
+ sky130_fd_sc_hd__dfstp_1
XFILLER_6_701 vccd1 vssd1 vccd1 vssd1 sky130_ef_sc_hd__decap_40_12
XANTENNA_input84_A SBsouth_in[27] vssd1 vssd1 vccd1 vccd1 sky130_fd_sc_hd__diode_2
XFILLER_14_83 vssd1 vssd1 vccd1 vccd1 sky130_fd_sc_hd__fill_1
XANTENNA__10785__A1 net9 vssd1 vssd1 vccd1 vccd1 sky130_fd_sc_hd__diode_2
X_12303_ cell1.SB0.route_sel\[41\] cell1.SB0.route_sel\[40\] net859 vssd1 vssd1 vccd1
+ vccd1 _00736_ sky130_fd_sc_hd__mux2_1
X_13283_ clknet_leaf_90_clk _00255_ net699 vssd1 vssd1 vccd1 vccd1 cell1.LE_1B.reset_mode
+ sky130_fd_sc_hd__dfrtp_1
X_10495_ _01839_ _03533_ vssd1 vssd1 vccd1 vccd1 _05463_ sky130_fd_sc_hd__nand2b_1
X_12234_ cell2.CB_0.config_dataB\[22\] cell2.CB_0.config_dataB\[21\] net826 vssd1
+ vssd1 vccd1 vccd1 _00667_ sky130_fd_sc_hd__mux2_1
XANTENNA__10537__A1 net14 vssd1 vssd1 vccd1 vccd1 sky130_fd_sc_hd__diode_2
XANTENNA__10537__B2 net13 vssd1 vssd1 vccd1 vccd1 sky130_fd_sc_hd__diode_2
XTAP_TAPCELL_ROW_75_1432 vssd1 vccd1 sky130_fd_sc_hd__tapvpwrvgnd_1
XANTENNA__07402__A1 net354 vssd1 vssd1 vccd1 vccd1 sky130_fd_sc_hd__diode_2
X_12165_ net1384 net1326 net892 vssd1 vssd1 vccd1 vccd1 _00598_ sky130_fd_sc_hd__mux2_1
X_11116_ _06063_ _06066_ _06067_ _01795_ vssd1 vssd1 vccd1 vccd1 _06068_ sky130_fd_sc_hd__a2bb2o_1
XFILLER_96_516 vssd1 vssd1 vccd1 vccd1 sky130_fd_sc_hd__fill_4
XANTENNA__07953__A2 _02235_ vssd1 vssd1 vccd1 vccd1 sky130_fd_sc_hd__diode_2
XFILLER_1_461 vccd1 vssd1 vccd1 vssd1 sky130_ef_sc_hd__decap_40_12
XANTENNA_output240_A net240 vssd1 vssd1 vccd1 vccd1 sky130_fd_sc_hd__diode_2
X_12096_ net1045 net1149 net877 vssd1 vssd1 vccd1 vccd1 _00530_ sky130_fd_sc_hd__mux2_1
X_11047_ net53 net54 net56 net57 net373 cell3.CB_0.config_dataA\[16\] vssd1 vssd1
+ vccd1 vccd1 _06001_ sky130_fd_sc_hd__mux4_1
XANTENNA_clkbuf_4_10_0_clk_X clknet_4_10_0_clk vssd1 vssd1 vccd1 vccd1 sky130_fd_sc_hd__diode_2
Xinput9 CBeast_in[17] vssd1 vssd1 vccd1 vccd1 net9 sky130_fd_sc_hd__buf_2
XFILLER_92_755 vssd1 vssd1 vccd1 vccd1 sky130_fd_sc_hd__fill_1
XFILLER_91_221 vssd1 vssd1 vccd1 vccd1 sky130_fd_sc_hd__fill_2
X_12998_ net1389 cell3.LEI0.config_data\[18\] net946 vssd1 vssd1 vccd1 vccd1 _01426_
+ sky130_fd_sc_hd__mux2_1
XANTENNA__07469__A1 net317 vssd1 vssd1 vccd1 vccd1 sky130_fd_sc_hd__diode_2
XFILLER_64_479 vssd1 vssd1 vccd1 vccd1 sky130_fd_sc_hd__fill_1
XTAP_TAPCELL_ROW_35_828 vssd1 vccd1 sky130_fd_sc_hd__tapvpwrvgnd_1
XTAP_TAPCELL_ROW_35_839 vssd1 vccd1 sky130_fd_sc_hd__tapvpwrvgnd_1
Xclkbuf_leaf_71_clk clknet_4_14_0_clk vssd1 vssd1 vccd1 vccd1 clknet_leaf_71_clk sky130_fd_sc_hd__clkbuf_8
XTAP_TAPCELL_ROW_86_1594 vssd1 vccd1 sky130_fd_sc_hd__tapvpwrvgnd_1
X_11949_ cell0.SB0.route_sel\[55\] cell0.SB0.route_sel\[54\] net759 vssd1 vssd1 vccd1
+ vccd1 _00386_ sky130_fd_sc_hd__mux2_1
XFILLER_17_395 vssd1 vssd1 vccd1 vccd1 sky130_fd_sc_hd__fill_1
XTAP_TAPCELL_ROW_15_530 vssd1 vccd1 sky130_fd_sc_hd__tapvpwrvgnd_1
XFILLER_32_365 vssd1 vssd1 vccd1 vccd1 sky130_fd_sc_hd__fill_1
XANTENNA__07411__X _02466_ vssd1 vssd1 vccd1 vccd1 sky130_fd_sc_hd__diode_2
X_13619_ clknet_leaf_87_clk _00591_ net687 vssd1 vssd1 vccd1 vccd1 cell1.LEI0.config_data\[40\]
+ sky130_fd_sc_hd__dfrtp_1
XANTENNA__07778__B net355 vssd1 vssd1 vccd1 vccd1 sky130_fd_sc_hd__diode_2
XANTENNA__11080__S _05930_ vssd1 vssd1 vccd1 vccd1 sky130_fd_sc_hd__diode_2
X_07140_ _01862_ _02027_ vssd1 vssd1 vccd1 vccd1 _02202_ sky130_fd_sc_hd__or2_1
XTAP_TAPCELL_ROW_117_2060 vssd1 vccd1 sky130_fd_sc_hd__tapvpwrvgnd_1
XANTENNA__10240__A3 _05139_ vssd1 vssd1 vccd1 vccd1 sky130_fd_sc_hd__diode_2
X_07071_ cell0.SB0.route_sel\[72\] cell0.SB0.route_sel\[73\] vssd1 vssd1 vccd1 vccd1
+ _02135_ sky130_fd_sc_hd__nand2b_1
XTAP_TAPCELL_ROW_130_2260 vssd1 vccd1 sky130_fd_sc_hd__tapvpwrvgnd_1
XFILLER_101_326 vssd1 vssd1 vccd1 vccd1 sky130_fd_sc_hd__fill_1
X_09712_ _02591_ _02603_ _04723_ _02593_ vssd1 vssd1 vccd1 vccd1 _04725_ sky130_fd_sc_hd__a31o_1
X_07973_ cell0.LE_0A.config_data\[13\] cell0.LE_0A.config_data\[12\] _02947_ vssd1
+ vssd1 vccd1 vccd1 _03017_ sky130_fd_sc_hd__mux2_1
XFILLER_142_29 vssd1 vssd1 vccd1 vccd1 sky130_fd_sc_hd__fill_2
X_06924_ cell2.SB0.route_sel\[56\] cell2.SB0.route_sel\[57\] vssd1 vssd1 vccd1 vccd1
+ _01991_ sky130_fd_sc_hd__nand2_1
XFILLER_83_700 vssd1 vssd1 vccd1 vccd1 sky130_fd_sc_hd__fill_1
XFILLER_19_39 vccd1 vssd1 vccd1 vssd1 sky130_ef_sc_hd__decap_40_12
X_06855_ _01922_ _01923_ vssd1 vssd1 vccd1 vccd1 _01924_ sky130_fd_sc_hd__nor2_1
X_09643_ net53 _04655_ _04657_ _04658_ vssd1 vssd1 vccd1 vccd1 _04659_ sky130_fd_sc_hd__o211a_1
XFILLER_82_210 vssd1 vssd1 vccd1 vccd1 sky130_fd_sc_hd__fill_4
X_09574_ _04307_ _04534_ vssd1 vssd1 vccd1 vccd1 _04592_ sky130_fd_sc_hd__nor2_1
XTAP_TAPCELL_ROW_46_1000 vssd1 vccd1 sky130_fd_sc_hd__tapvpwrvgnd_1
XFILLER_42_118 vssd1 vssd1 vccd1 vccd1 sky130_fd_sc_hd__fill_1
X_06786_ _01853_ _01855_ _01854_ vssd1 vssd1 vccd1 vccd1 _01856_ sky130_fd_sc_hd__a21o_1
X_08525_ _03540_ _03549_ _03550_ _03537_ vssd1 vssd1 vccd1 vccd1 _03561_ sky130_fd_sc_hd__a22o_1
XFILLER_35_27 vccd1 vssd1 vccd1 vssd1 sky130_ef_sc_hd__decap_40_12
Xclkbuf_leaf_62_clk clknet_4_15_0_clk vssd1 vssd1 vccd1 vccd1 clknet_leaf_62_clk sky130_fd_sc_hd__clkbuf_8
XANTENNA_clkbuf_leaf_60_clk_A clknet_4_15_0_clk vssd1 vssd1 vccd1 vccd1 sky130_fd_sc_hd__diode_2
XANTENNA__10947__X _05901_ vssd1 vssd1 vccd1 vccd1 sky130_fd_sc_hd__diode_2
XFILLER_70_438 vssd1 vssd1 vccd1 vccd1 sky130_fd_sc_hd__fill_1
XANTENNA__10464__B1 cell3.SB0.route_sel\[101\] vssd1 vssd1 vccd1 vccd1 sky130_fd_sc_hd__diode_2
X_08456_ cell1.SB0.route_sel\[104\] cell1.SB0.route_sel\[105\] vssd1 vssd1 vccd1 vccd1
+ _03492_ sky130_fd_sc_hd__nand2b_1
X_07407_ cell2.SB0.route_sel\[107\] cell2.SB0.route_sel\[106\] _02459_ _02461_ _02452_
+ vssd1 vssd1 vccd1 vccd1 _02462_ sky130_fd_sc_hd__a41o_1
XANTENNA__08672__A3 net3 vssd1 vssd1 vccd1 vccd1 sky130_fd_sc_hd__diode_2
X_08387_ bus1_0\[8\] bus1_0\[9\] bus1_0\[10\] bus1_0\[11\] net501 net499 vssd1 vssd1
+ vccd1 vccd1 _03425_ sky130_fd_sc_hd__mux4_1
XANTENNA__08409__A0 net344 vssd1 vssd1 vccd1 vccd1 sky130_fd_sc_hd__diode_2
X_07338_ _02095_ _02394_ vssd1 vssd1 vccd1 vccd1 _02395_ sky130_fd_sc_hd__nor2_1
XANTENNA__07040__Y _02105_ vssd1 vssd1 vccd1 vccd1 sky130_fd_sc_hd__diode_2
XANTENNA_fanout703_A net724 vssd1 vssd1 vccd1 vccd1 sky130_fd_sc_hd__diode_2
XFILLER_51_37 vssd1 vssd1 vccd1 vccd1 sky130_fd_sc_hd__fill_1
XANTENNA_clkbuf_leaf_75_clk_A clknet_4_14_0_clk vssd1 vssd1 vccd1 vccd1 sky130_fd_sc_hd__diode_2
X_07269_ net340 net358 _02326_ _02324_ _02011_ vssd1 vssd1 vccd1 vccd1 _02327_ sky130_fd_sc_hd__o32ai_4
X_10280_ net431 _05131_ _05278_ net430 vssd1 vssd1 vccd1 vccd1 _05279_ sky130_fd_sc_hd__o211a_1
X_09008_ _03830_ _04020_ _04021_ _03826_ _01670_ vssd1 vssd1 vccd1 vccd1 _04038_ sky130_fd_sc_hd__a221o_1
XTAP_TAPCELL_ROW_57_1162 vssd1 vccd1 sky130_fd_sc_hd__tapvpwrvgnd_1
XANTENNA__11192__A1 net48 vssd1 vssd1 vccd1 vccd1 sky130_fd_sc_hd__diode_2
XFILLER_116_41 vccd1 vssd1 vccd1 vssd1 sky130_ef_sc_hd__decap_40_12
XANTENNA__07209__A net344 vssd1 vssd1 vccd1 vccd1 sky130_fd_sc_hd__diode_2
XFILLER_104_197 vssd1 vssd1 vccd1 vccd1 sky130_fd_sc_hd__fill_1
Xfanout551 _01495_ vssd1 vssd1 vccd1 vccd1 net551 sky130_fd_sc_hd__clkbuf_8
Xfanout540 cell0.CB_1.config_dataA\[10\] vssd1 vssd1 vccd1 vccd1 net540 sky130_fd_sc_hd__dlymetal6s2s_1
XANTENNA_clkbuf_leaf_133_clk_A clknet_4_0_0_clk vssd1 vssd1 vccd1 vccd1 sky130_fd_sc_hd__diode_2
X_13970_ clknet_leaf_34_clk _00942_ net638 vssd1 vssd1 vccd1 vccd1 cell2.LEI0.config_data\[27\]
+ sky130_fd_sc_hd__dfrtp_1
XANTENNA__10035__A1_N _04527_ vssd1 vssd1 vccd1 vccd1 sky130_fd_sc_hd__diode_2
Xfanout573 net574 vssd1 vssd1 vccd1 vccd1 net573 sky130_fd_sc_hd__clkbuf_2
XTAP_TAPCELL_ROW_70_1362 vssd1 vccd1 sky130_fd_sc_hd__tapvpwrvgnd_1
XTAP_TAPCELL_ROW_70_1351 vssd1 vccd1 sky130_fd_sc_hd__tapvpwrvgnd_1
XANTENNA_clkbuf_leaf_13_clk_A clknet_4_3_0_clk vssd1 vssd1 vccd1 vccd1 sky130_fd_sc_hd__diode_2
Xfanout562 net563 vssd1 vssd1 vccd1 vccd1 net562 sky130_fd_sc_hd__clkbuf_4
Xfanout584 net602 vssd1 vssd1 vccd1 vccd1 net584 sky130_fd_sc_hd__buf_2
X_12921_ net1228 net1392 net942 vssd1 vssd1 vccd1 vccd1 _01350_ sky130_fd_sc_hd__mux2_1
Xfanout595 net596 vssd1 vssd1 vccd1 vccd1 net595 sky130_fd_sc_hd__clkbuf_4
XANTENNA__07699__A1 _01933_ vssd1 vssd1 vccd1 vccd1 sky130_fd_sc_hd__diode_2
XFILLER_132_73 vssd1 vssd1 vccd1 vccd1 sky130_fd_sc_hd__fill_1
XANTENNA__09711__X _04724_ vssd1 vssd1 vccd1 vccd1 sky130_fd_sc_hd__diode_2
X_12852_ cell2.SB0.route_sel\[94\] cell2.SB0.route_sel\[93\] net831 vssd1 vssd1 vccd1
+ vccd1 _01281_ sky130_fd_sc_hd__mux2_1
XFILLER_74_788 vssd1 vssd1 vccd1 vccd1 sky130_fd_sc_hd__fill_1
XANTENNA_clkbuf_leaf_28_clk_A clknet_4_5_0_clk vssd1 vssd1 vccd1 vccd1 sky130_fd_sc_hd__diode_2
Xclkbuf_leaf_53_clk clknet_4_13_0_clk vssd1 vssd1 vccd1 vccd1 clknet_leaf_53_clk sky130_fd_sc_hd__clkbuf_8
X_12783_ cell2.SB0.route_sel\[25\] cell2.SB0.route_sel\[24\] net816 vssd1 vssd1 vccd1
+ vccd1 _01212_ sky130_fd_sc_hd__mux2_1
X_11803_ cell1.LE_1B.config_data\[4\] net1027 net902 vssd1 vssd1 vccd1 vccd1 _00240_
+ sky130_fd_sc_hd__mux2_1
X_11734_ net1059 cell0.LE_0A.config_data\[6\] net772 vssd1 vssd1 vccd1 vccd1 _00172_
+ sky130_fd_sc_hd__mux2_1
X_14453_ clknet_leaf_59_clk _01425_ net735 vssd1 vssd1 vccd1 vccd1 cell3.LEI0.config_data\[18\]
+ sky130_fd_sc_hd__dfrtp_1
X_11665_ net502 net503 net783 vssd1 vssd1 vccd1 vccd1 _00106_ sky130_fd_sc_hd__mux2_1
XANTENNA__10207__A0 net63 vssd1 vssd1 vccd1 vccd1 sky130_fd_sc_hd__diode_2
Xclkbuf_4_6_0_clk clknet_0_clk vssd1 vssd1 vccd1 vccd1 clknet_4_6_0_clk sky130_fd_sc_hd__clkbuf_8
X_10616_ cell3.CB_1.config_dataA\[2\] _05573_ cell3.CB_1.config_dataA\[3\] vssd1 vssd1
+ vccd1 vccd1 _05574_ sky130_fd_sc_hd__a21bo_1
X_13404_ clknet_leaf_0_clk _00376_ net553 vssd1 vssd1 vccd1 vccd1 cell0.SB0.route_sel\[45\]
+ sky130_fd_sc_hd__dfstp_1
XANTENNA_output190_A net190 vssd1 vssd1 vccd1 vccd1 sky130_fd_sc_hd__diode_2
X_14384_ clknet_leaf_66_clk net1220 net743 vssd1 vssd1 vccd1 vccd1 cell3.LE_1A.config_data\[15\]
+ sky130_fd_sc_hd__dfrtp_1
XANTENNA__10758__A1 _04354_ vssd1 vssd1 vccd1 vccd1 sky130_fd_sc_hd__diode_2
XANTENNA_input87_X net87 vssd1 vssd1 vccd1 vccd1 sky130_fd_sc_hd__diode_2
X_11596_ cell0.CB_1.config_dataA\[17\] cell0.CB_1.config_dataA\[16\] net789 vssd1
+ vssd1 vccd1 vccd1 _00037_ sky130_fd_sc_hd__mux2_1
X_10547_ _05504_ vssd1 vssd1 vccd1 vccd1 _05505_ sky130_fd_sc_hd__inv_2
X_13335_ clknet_leaf_84_clk _00307_ net674 vssd1 vssd1 vccd1 vccd1 cell1.CB_0.config_dataA\[1\]
+ sky130_fd_sc_hd__dfstp_1
XANTENNA__07110__C _02171_ vssd1 vssd1 vccd1 vccd1 sky130_fd_sc_hd__diode_2
XFILLER_108_470 vssd1 vssd1 vccd1 vccd1 sky130_fd_sc_hd__fill_4
X_10478_ net597 cell0.LE_1A.reset_mode vssd1 vssd1 vccd1 vccd1 _10478_/X sky130_fd_sc_hd__xor2_2
X_13266_ clknet_leaf_92_clk _00238_ net694 vssd1 vssd1 vccd1 vccd1 cell1.LE_1B.config_data\[2\]
+ sky130_fd_sc_hd__dfrtp_1
X_12217_ net432 cell2.CB_0.config_dataB\[4\] net827 vssd1 vssd1 vccd1 vccd1 _00650_
+ sky130_fd_sc_hd__mux2_1
XFILLER_111_613 vssd1 vssd1 vccd1 vccd1 sky130_fd_sc_hd__fill_2
XFILLER_97_836 vssd1 vssd1 vccd1 vccd1 sky130_fd_sc_hd__fill_2
X_13197_ clknet_leaf_23_clk _00169_ net603 vssd1 vssd1 vccd1 vccd1 cell0.LE_0A.config_data\[4\]
+ sky130_fd_sc_hd__dfrtp_1
XFILLER_69_505 vssd1 vssd1 vccd1 vccd1 sky130_fd_sc_hd__fill_2
X_12148_ net1437 net1380 net893 vssd1 vssd1 vccd1 vccd1 _00581_ sky130_fd_sc_hd__mux2_1
XFILLER_2_781 vccd1 vssd1 vccd1 vssd1 sky130_ef_sc_hd__decap_40_12
XFILLER_96_357 vssd1 vssd1 vccd1 vccd1 sky130_fd_sc_hd__fill_1
X_12079_ cell1.LE_0B.config_data\[7\] net1032 net938 vssd1 vssd1 vccd1 vccd1 _00514_
+ sky130_fd_sc_hd__mux2_1
XANTENNA__14013__Q cell3.SB0.route_sel\[21\] vssd1 vssd1 vccd1 vccd1 sky130_fd_sc_hd__diode_2
XFILLER_2_53 vccd1 vssd1 vccd1 vssd1 sky130_ef_sc_hd__decap_40_12
XPHY_EDGE_ROW_10_Right_10 vssd1 vssd1 vccd1 vccd1 sky130_fd_sc_hd__decap_3
XTAP_TAPCELL_ROW_88_1634 vssd1 vccd1 sky130_fd_sc_hd__tapvpwrvgnd_1
XTAP_TAPCELL_ROW_88_1623 vssd1 vccd1 sky130_fd_sc_hd__tapvpwrvgnd_1
XPHY_EDGE_ROW_139_Right_139 vssd1 vssd1 vccd1 vccd1 sky130_fd_sc_hd__decap_3
X_06640_ cell3.SB0.route_sel\[51\] vssd1 vssd1 vccd1 vccd1 _01710_ sky130_fd_sc_hd__inv_2
XANTENNA__10694__A0 _05540_ vssd1 vssd1 vccd1 vccd1 sky130_fd_sc_hd__diode_2
XFILLER_2_97 vccd1 vssd1 vccd1 vssd1 sky130_ef_sc_hd__decap_40_12
XANTENNA__08351__A2 bus1_0\[14\] vssd1 vssd1 vccd1 vccd1 sky130_fd_sc_hd__diode_2
Xclkbuf_leaf_44_clk clknet_4_6_0_clk vssd1 vssd1 vccd1 vccd1 clknet_leaf_44_clk sky130_fd_sc_hd__clkbuf_8
X_06571_ cell2.SB0.route_sel\[105\] vssd1 vssd1 vccd1 vccd1 _01641_ sky130_fd_sc_hd__inv_2
XANTENNA__08639__A0 net1 vssd1 vssd1 vccd1 vccd1 sky130_fd_sc_hd__diode_2
X_09290_ _04219_ _04315_ vssd1 vssd1 vccd1 vccd1 _04316_ sky130_fd_sc_hd__nor2_1
XANTENNA__11803__S net902 vssd1 vssd1 vccd1 vccd1 sky130_fd_sc_hd__diode_2
X_08310_ net509 _02761_ vssd1 vssd1 vccd1 vccd1 _03348_ sky130_fd_sc_hd__nand2_1
XANTENNA__10997__A1 net48 vssd1 vssd1 vccd1 vccd1 sky130_fd_sc_hd__diode_2
XTAP_TAPCELL_ROW_119_2100 vssd1 vccd1 sky130_fd_sc_hd__tapvpwrvgnd_1
XANTENNA_14 cell1.LE_1B.config_data\[0\] vssd1 vssd1 vccd1 vccd1 sky130_fd_sc_hd__diode_2
XANTENNA__08654__A3 net7 vssd1 vssd1 vccd1 vccd1 sky130_fd_sc_hd__diode_2
X_08241_ net536 _01956_ vssd1 vssd1 vccd1 vccd1 _03281_ sky130_fd_sc_hd__nand2_1
XANTENNA_47 net1539 vssd1 vssd1 vccd1 vccd1 sky130_fd_sc_hd__diode_2
XANTENNA_36 bus3_2\[14\] vssd1 vssd1 vccd1 vccd1 sky130_fd_sc_hd__diode_2
XANTENNA_25 net163 vssd1 vssd1 vccd1 vccd1 sky130_fd_sc_hd__diode_2
XFILLER_32_195 vssd1 vssd1 vccd1 vccd1 sky130_fd_sc_hd__fill_1
X_08172_ net543 _02719_ vssd1 vssd1 vccd1 vccd1 _03212_ sky130_fd_sc_hd__or2_1
XTAP_TAPCELL_ROW_99_1796 vssd1 vccd1 sky130_fd_sc_hd__tapvpwrvgnd_1
X_07123_ cell2.SB0.route_sel\[72\] cell2.SB0.route_sel\[73\] _02177_ _02185_ net777
+ vssd1 vssd1 vccd1 vccd1 _02186_ sky130_fd_sc_hd__a311oi_1
XANTENNA__07614__A1 _02658_ vssd1 vssd1 vccd1 vccd1 sky130_fd_sc_hd__diode_2
X_07054_ cell0.SB0.route_sel\[77\] cell0.SB0.route_sel\[76\] net96 vssd1 vssd1 vccd1
+ vccd1 _02118_ sky130_fd_sc_hd__a21boi_1
Xoutput143 net143 vssd1 vssd1 vccd1 vccd1 CBeast_out[18] sky130_fd_sc_hd__buf_2
XFILLER_142_782 vssd1 vssd1 vccd1 vccd1 sky130_fd_sc_hd__fill_2
Xoutput176 net176 vssd1 vssd1 vccd1 vccd1 CBnorth_out[19] sky130_fd_sc_hd__buf_2
XANTENNA__11174__A1 net48 vssd1 vssd1 vccd1 vccd1 sky130_fd_sc_hd__diode_2
Xoutput154 net154 vssd1 vssd1 vccd1 vccd1 CBeast_out[28] sky130_fd_sc_hd__buf_2
XFILLER_0_729 vssd1 vssd1 vccd1 vccd1 sky130_fd_sc_hd__fill_1
Xoutput165 net165 vssd1 vssd1 vccd1 vccd1 CBeast_out[9] sky130_fd_sc_hd__buf_2
XANTENNA__07378__A0 net5 vssd1 vssd1 vccd1 vccd1 sky130_fd_sc_hd__diode_2
Xoutput187 net187 vssd1 vssd1 vccd1 vccd1 CBnorth_out[29] sky130_fd_sc_hd__buf_2
XFILLER_87_335 vssd1 vssd1 vccd1 vccd1 sky130_fd_sc_hd__fill_1
XANTENNA__09119__A1 bus3_1\[13\] vssd1 vssd1 vccd1 vccd1 sky130_fd_sc_hd__diode_2
Xoutput198 net198 vssd1 vssd1 vccd1 vccd1 SBsouth_out[0] sky130_fd_sc_hd__buf_2
XTAP_TAPCELL_ROW_110_1963 vssd1 vccd1 sky130_fd_sc_hd__tapvpwrvgnd_1
XTAP_TAPCELL_ROW_110_1952 vssd1 vccd1 sky130_fd_sc_hd__tapvpwrvgnd_1
X_07956_ net512 _02585_ vssd1 vssd1 vccd1 vccd1 _03000_ sky130_fd_sc_hd__nand2_1
XANTENNA__08590__A2 _03504_ vssd1 vssd1 vccd1 vccd1 sky130_fd_sc_hd__diode_2
XANTENNA__08878__A0 bus3_1\[12\] vssd1 vssd1 vccd1 vccd1 sky130_fd_sc_hd__diode_2
XTAP_TAPCELL_ROW_52_1092 vssd1 vccd1 sky130_fd_sc_hd__tapvpwrvgnd_1
XTAP_TAPCELL_ROW_52_1081 vssd1 vccd1 sky130_fd_sc_hd__tapvpwrvgnd_1
X_06907_ bus3_1\[7\] _01974_ vssd1 vssd1 vccd1 vccd1 _01975_ sky130_fd_sc_hd__and2_1
XFILLER_46_15 vssd1 vssd1 vccd1 vccd1 sky130_fd_sc_hd__fill_1
XPHY_EDGE_ROW_106_Right_106 vssd1 vssd1 vccd1 vccd1 sky130_fd_sc_hd__decap_3
X_07887_ bus2_0\[0\] bus2_0\[1\] bus2_0\[2\] bus2_0\[3\] net521 net520 vssd1 vssd1
+ vccd1 vccd1 _02931_ sky130_fd_sc_hd__mux4_1
XFILLER_102_21 vssd1 vssd1 vccd1 vccd1 sky130_fd_sc_hd__fill_4
X_09626_ _02380_ _02402_ _04640_ _02381_ vssd1 vssd1 vccd1 vccd1 _04642_ sky130_fd_sc_hd__a31o_1
X_06838_ _01904_ _01906_ bus3_2\[6\] vssd1 vssd1 vccd1 vccd1 _01907_ sky130_fd_sc_hd__o21a_1
XANTENNA__10677__X _05635_ vssd1 vssd1 vccd1 vccd1 sky130_fd_sc_hd__diode_2
XFILLER_102_54 vssd1 vssd1 vccd1 vccd1 sky130_fd_sc_hd__fill_2
X_09557_ _04563_ _04569_ _04575_ vssd1 vssd1 vccd1 vccd1 _04576_ sky130_fd_sc_hd__o21a_1
X_06769_ _01837_ _01838_ vssd1 vssd1 vccd1 vccd1 _01839_ sky130_fd_sc_hd__nor2_1
Xclkbuf_leaf_35_clk clknet_4_7_0_clk vssd1 vssd1 vccd1 vccd1 clknet_leaf_35_clk sky130_fd_sc_hd__clkbuf_8
X_09488_ _04358_ _04404_ vssd1 vssd1 vccd1 vccd1 _04509_ sky130_fd_sc_hd__nand2_1
XFILLER_62_25 vssd1 vssd1 vccd1 vccd1 sky130_fd_sc_hd__fill_1
X_08508_ net331 net326 net336 net323 cell1.LEI0.config_data\[6\] cell1.LEI0.config_data\[7\]
+ vssd1 vssd1 vccd1 vccd1 _03544_ sky130_fd_sc_hd__mux4_1
X_08439_ cell1.SB0.route_sel\[64\] cell1.SB0.route_sel\[65\] vssd1 vssd1 vccd1 vccd1
+ _03475_ sky130_fd_sc_hd__nand2b_1
XFILLER_127_3 vccd1 vssd1 vccd1 vssd1 sky130_ef_sc_hd__decap_40_12
X_11450_ _06300_ _02780_ vssd1 vssd1 vccd1 vccd1 net208 sky130_fd_sc_hd__and2b_1
X_10401_ net424 _05144_ vssd1 vssd1 vccd1 vccd1 _05400_ sky130_fd_sc_hd__nand2_1
X_11381_ _06254_ net299 vssd1 vssd1 vccd1 vccd1 net226 sky130_fd_sc_hd__and2b_1
X_10332_ net436 _05084_ vssd1 vssd1 vccd1 vccd1 _05331_ sky130_fd_sc_hd__nand2_1
X_13120_ clknet_leaf_8_clk _00092_ net573 vssd1 vssd1 vccd1 vccd1 cell0.CB_0.config_dataA\[22\]
+ sky130_fd_sc_hd__dfstp_1
XFILLER_3_501 vssd1 vssd1 vccd1 vccd1 sky130_fd_sc_hd__fill_2
XFILLER_11_51 vssd1 vssd1 vccd1 vccd1 sky130_fd_sc_hd__fill_4
XFILLER_127_51 vssd1 vssd1 vccd1 vccd1 sky130_fd_sc_hd__fill_4
XANTENNA__13937__Q cell2.LE_0A.config_data\[16\] vssd1 vssd1 vccd1 vccd1 sky130_fd_sc_hd__diode_2
X_13051_ clknet_leaf_126_clk _00023_ net582 vssd1 vssd1 vccd1 vccd1 cell0.CB_1.config_dataA\[3\]
+ sky130_fd_sc_hd__dfstp_1
XANTENNA__11165__A1 net54 vssd1 vssd1 vccd1 vccd1 sky130_fd_sc_hd__diode_2
X_10263_ cell2.CB_0.config_dataA\[19\] _05235_ _05243_ _05261_ _05263_ vssd1 vssd1
+ vccd1 vccd1 _05264_ sky130_fd_sc_hd__a311o_1
X_12002_ cell0.SB0.route_sel\[108\] cell0.SB0.route_sel\[107\] net770 vssd1 vssd1
+ vccd1 vccd1 _00439_ sky130_fd_sc_hd__mux2_1
XANTENNA_input47_A CBnorth_in[22] vssd1 vssd1 vccd1 vccd1 sky130_fd_sc_hd__diode_2
XANTENNA__10912__A1 net50 vssd1 vssd1 vccd1 vccd1 sky130_fd_sc_hd__diode_2
X_10194_ cell2.CB_0.config_dataA\[4\] _05167_ _05175_ _05194_ _01764_ vssd1 vssd1
+ vccd1 vccd1 _05195_ sky130_fd_sc_hd__a32o_1
XFILLER_87_66 vssd1 vssd1 vccd1 vccd1 sky130_fd_sc_hd__fill_1
XFILLER_87_55 vssd1 vssd1 vccd1 vccd1 sky130_fd_sc_hd__fill_1
XANTENNA__09706__X _04719_ vssd1 vssd1 vccd1 vccd1 sky130_fd_sc_hd__diode_2
Xfanout381 cell3.CB_0.config_dataB\[22\] vssd1 vssd1 vccd1 vccd1 net381 sky130_fd_sc_hd__clkbuf_2
Xfanout392 cell3.CB_1.config_dataA\[11\] vssd1 vssd1 vccd1 vccd1 net392 sky130_fd_sc_hd__buf_2
XFILLER_93_316 vssd1 vssd1 vccd1 vccd1 sky130_fd_sc_hd__fill_1
Xfanout370 cell3.CB_1.config_dataB\[1\] vssd1 vssd1 vccd1 vccd1 net370 sky130_fd_sc_hd__buf_2
XTAP_TAPCELL_ROW_6_394 vssd1 vccd1 sky130_fd_sc_hd__tapvpwrvgnd_1
X_13953_ clknet_leaf_42_clk _00925_ net641 vssd1 vssd1 vccd1 vccd1 cell2.LEI0.config_data\[10\]
+ sky130_fd_sc_hd__dfrtp_1
XANTENNA__08333__A2 bus1_0\[14\] vssd1 vssd1 vccd1 vccd1 sky130_fd_sc_hd__diode_2
X_13884_ clknet_leaf_53_clk net1047 net715 vssd1 vssd1 vccd1 vccd1 cell2.LE_1A.config_data\[7\]
+ sky130_fd_sc_hd__dfrtp_1
X_12904_ cell3.CB_1.config_dataB\[18\] cell3.CB_1.config_dataB\[17\] net939 vssd1
+ vssd1 vccd1 vccd1 _01333_ sky130_fd_sc_hd__mux2_1
XANTENNA__12719__S net932 vssd1 vssd1 vccd1 vccd1 sky130_fd_sc_hd__diode_2
XANTENNA__10691__A3 net25 vssd1 vssd1 vccd1 vccd1 sky130_fd_sc_hd__diode_2
X_12835_ cell2.SB0.route_sel\[77\] cell2.SB0.route_sel\[76\] net778 vssd1 vssd1 vccd1
+ vccd1 _01264_ sky130_fd_sc_hd__mux2_1
XANTENNA_output203_A net203 vssd1 vssd1 vccd1 vccd1 sky130_fd_sc_hd__diode_2
Xclkbuf_leaf_26_clk clknet_4_4_0_clk vssd1 vssd1 vccd1 vccd1 clknet_leaf_26_clk sky130_fd_sc_hd__clkbuf_8
XTAP_TAPCELL_ROW_83_1553 vssd1 vccd1 sky130_fd_sc_hd__tapvpwrvgnd_1
XANTENNA__11623__S net780 vssd1 vssd1 vccd1 vccd1 sky130_fd_sc_hd__diode_2
XTAP_TAPCELL_ROW_45_989 vssd1 vccd1 sky130_fd_sc_hd__tapvpwrvgnd_1
XTAP_TAPCELL_ROW_45_978 vssd1 vccd1 sky130_fd_sc_hd__tapvpwrvgnd_1
XFILLER_99_7 vssd1 vssd1 vccd1 vccd1 sky130_fd_sc_hd__fill_1
X_12766_ cell2.SB0.route_sel\[8\] cell2.SB0.route_sel\[7\] net829 vssd1 vssd1 vccd1
+ vccd1 _01195_ sky130_fd_sc_hd__mux2_1
X_12697_ cell3.CB_1.config_dataA\[14\] cell3.CB_1.config_dataA\[13\] net941 vssd1
+ vssd1 vccd1 vccd1 _01126_ sky130_fd_sc_hd__mux2_1
X_11717_ cell0.LE_0B.config_data\[13\] net1254 net805 vssd1 vssd1 vccd1 vccd1 _00156_
+ sky130_fd_sc_hd__mux2_1
XTAP_TAPCELL_ROW_25_680 vssd1 vccd1 sky130_fd_sc_hd__tapvpwrvgnd_1
X_14436_ clknet_leaf_67_clk _01408_ net734 vssd1 vssd1 vccd1 vccd1 cell3.LEI0.config_data\[1\]
+ sky130_fd_sc_hd__dfrtp_1
Xinput12 CBeast_in[1] vssd1 vssd1 vccd1 vccd1 net12 sky130_fd_sc_hd__clkbuf_4
X_11648_ cell0.CB_0.config_dataA\[19\] cell0.CB_0.config_dataA\[18\] net770 vssd1
+ vssd1 vccd1 vccd1 _00089_ sky130_fd_sc_hd__mux2_1
XFILLER_30_699 vssd1 vssd1 vccd1 vccd1 sky130_fd_sc_hd__fill_1
Xinput45 CBnorth_in[20] vssd1 vssd1 vccd1 vccd1 net45 sky130_fd_sc_hd__clkbuf_4
Xinput34 CBnorth_in[10] vssd1 vssd1 vccd1 vccd1 net34 sky130_fd_sc_hd__buf_2
Xinput23 CBeast_in[2] vssd1 vssd1 vccd1 vccd1 net23 sky130_fd_sc_hd__clkbuf_4
X_14367_ clknet_leaf_74_clk _01339_ net688 vssd1 vssd1 vccd1 vccd1 cell3.CB_1.config_dataB\[24\]
+ sky130_fd_sc_hd__dfstp_1
X_11579_ cell0.CB_1.config_dataA\[0\] cell0.CB_0.config_dataB\[24\] net782 vssd1 vssd1
+ vccd1 vccd1 _00020_ sky130_fd_sc_hd__mux2_1
Xinput56 CBnorth_in[30] vssd1 vssd1 vccd1 vccd1 net56 sky130_fd_sc_hd__buf_2
XFILLER_128_587 vssd1 vssd1 vccd1 vccd1 sky130_fd_sc_hd__fill_1
XANTENNA__10600__A0 net286 vssd1 vssd1 vccd1 vccd1 sky130_fd_sc_hd__diode_2
X_13318_ clknet_leaf_88_clk _00290_ net688 vssd1 vssd1 vccd1 vccd1 cell1.CB_0.config_dataB\[9\]
+ sky130_fd_sc_hd__dfstp_1
Xinput89 SBsouth_in[31] vssd1 vssd1 vccd1 vccd1 net89 sky130_fd_sc_hd__clkbuf_2
Xinput67 SBsouth_in[11] vssd1 vssd1 vccd1 vccd1 net67 sky130_fd_sc_hd__clkbuf_2
Xinput78 SBsouth_in[21] vssd1 vssd1 vccd1 vccd1 net78 sky130_fd_sc_hd__dlymetal6s2s_1
X_14298_ clknet_leaf_13_clk _01270_ net590 vssd1 vssd1 vccd1 vccd1 cell2.SB0.route_sel\[83\]
+ sky130_fd_sc_hd__dfstp_1
X_13249_ clknet_leaf_122_clk net1420 net586 vssd1 vssd1 vccd1 vccd1 cell0.LEI0.config_data\[34\]
+ sky130_fd_sc_hd__dfrtp_1
X_08790_ net470 _03817_ _03821_ net469 vssd1 vssd1 vccd1 vccd1 _03822_ sky130_fd_sc_hd__o211a_1
XANTENNA__07791__B net354 vssd1 vssd1 vccd1 vccd1 sky130_fd_sc_hd__diode_2
X_07810_ _01842_ _02146_ vssd1 vssd1 vccd1 vccd1 _02855_ sky130_fd_sc_hd__nor2_1
XFILLER_97_688 vssd1 vssd1 vccd1 vccd1 sky130_fd_sc_hd__fill_1
XANTENNA__08379__S _03347_ vssd1 vssd1 vccd1 vccd1 sky130_fd_sc_hd__diode_2
X_07741_ cell1.SB0.route_sel\[34\] cell1.SB0.route_sel\[35\] net333 _02785_ vssd1
+ vssd1 vccd1 vccd1 _02787_ sky130_fd_sc_hd__a22o_1
XFILLER_77_390 vssd1 vssd1 vccd1 vccd1 sky130_fd_sc_hd__fill_2
XANTENNA__10131__A2 _05131_ vssd1 vssd1 vccd1 vccd1 sky130_fd_sc_hd__diode_2
XANTENNA__10667__B1 _04370_ vssd1 vssd1 vccd1 vccd1 sky130_fd_sc_hd__diode_2
X_07672_ net361 net353 net265 _02718_ vssd1 vssd1 vccd1 vccd1 _02720_ sky130_fd_sc_hd__o211ai_2
XTAP_TAPCELL_ROW_125_2181 vssd1 vccd1 sky130_fd_sc_hd__tapvpwrvgnd_1
X_09411_ net110 cell2.SB0.route_sel\[44\] cell2.SB0.route_sel\[45\] vssd1 vssd1 vccd1
+ vccd1 _04434_ sky130_fd_sc_hd__and3_1
X_06623_ cell3.SB0.route_sel\[21\] vssd1 vssd1 vccd1 vccd1 _01693_ sky130_fd_sc_hd__inv_2
XFILLER_16_29 vccd1 vssd1 vccd1 vssd1 sky130_ef_sc_hd__decap_40_12
XANTENNA__09351__X _04375_ vssd1 vssd1 vccd1 vccd1 sky130_fd_sc_hd__diode_2
X_09342_ _04219_ _04366_ vssd1 vssd1 vccd1 vccd1 _04367_ sky130_fd_sc_hd__nor2_1
Xclkbuf_leaf_17_clk clknet_4_6_0_clk vssd1 vssd1 vccd1 vccd1 clknet_leaf_17_clk sky130_fd_sc_hd__clkbuf_8
X_06554_ cell2.SB0.route_sel\[73\] vssd1 vssd1 vccd1 vccd1 _01624_ sky130_fd_sc_hd__inv_2
XANTENNA__08088__A1 _02902_ vssd1 vssd1 vccd1 vccd1 sky130_fd_sc_hd__diode_2
XANTENNA__08088__B2 _02905_ vssd1 vssd1 vccd1 vccd1 sky130_fd_sc_hd__diode_2
X_09273_ _04280_ net263 _04297_ _04281_ vssd1 vssd1 vccd1 vccd1 _04299_ sky130_fd_sc_hd__a31o_1
X_06485_ cell0.LEI0.config_data\[5\] vssd1 vssd1 vccd1 vccd1 _01555_ sky130_fd_sc_hd__inv_2
XFILLER_20_110 vssd1 vssd1 vccd1 vccd1 sky130_fd_sc_hd__fill_1
XANTENNA__10944__Y _05898_ vssd1 vssd1 vccd1 vccd1 sky130_fd_sc_hd__diode_2
X_08224_ cell0.LE_1A.config_data\[5\] cell0.LE_1A.config_data\[4\] _03198_ vssd1 vssd1
+ vccd1 vccd1 _03264_ sky130_fd_sc_hd__mux2_1
X_08155_ cell0.CB_1.config_dataA\[3\] _03168_ cell0.CB_1.config_dataA\[2\] cell0.CB_1.config_dataA\[4\]
+ vssd1 vssd1 vccd1 vccd1 _03195_ sky130_fd_sc_hd__or4b_2
XFILLER_21_699 vssd1 vssd1 vccd1 vccd1 sky130_fd_sc_hd__fill_1
XANTENNA__10198__A2 _05107_ vssd1 vssd1 vccd1 vccd1 sky130_fd_sc_hd__diode_2
X_07106_ cell2.SB0.route_sel\[75\] cell2.SB0.route_sel\[74\] _02168_ vssd1 vssd1 vccd1
+ vccd1 _02169_ sky130_fd_sc_hd__a21oi_1
XANTENNA__07063__A2 net354 vssd1 vssd1 vccd1 vccd1 sky130_fd_sc_hd__diode_2
X_08086_ net524 _02897_ vssd1 vssd1 vccd1 vccd1 _03128_ sky130_fd_sc_hd__nand2_1
X_07037_ net306 _02095_ _02097_ vssd1 vssd1 vccd1 vccd1 _02102_ sky130_fd_sc_hd__or3_1
XTAP_TAPCELL_ROW_54_1121 vssd1 vccd1 sky130_fd_sc_hd__tapvpwrvgnd_1
XANTENNA__13351__SET_B net675 vssd1 vssd1 vccd1 vccd1 sky130_fd_sc_hd__diode_2
XANTENNA_fanout770_A net780 vssd1 vssd1 vccd1 vccd1 sky130_fd_sc_hd__diode_2
XANTENNA__06869__Y _01937_ vssd1 vssd1 vccd1 vccd1 sky130_fd_sc_hd__diode_2
XFILLER_88_699 vssd1 vssd1 vccd1 vccd1 sky130_fd_sc_hd__fill_1
X_08988_ _01684_ cell1.LE_0A.dff_out vssd1 vssd1 vccd1 vccd1 _04019_ sky130_fd_sc_hd__or2_1
XANTENNA__06598__A cell1.LE_1A.config_data\[16\] vssd1 vssd1 vccd1 vccd1 sky130_fd_sc_hd__diode_2
X_07939_ net511 net512 vssd1 vssd1 vccd1 vccd1 _02983_ sky130_fd_sc_hd__nor2_1
XTAP_TAPCELL_ROW_3_353 vssd1 vccd1 sky130_fd_sc_hd__tapvpwrvgnd_1
X_10950_ cell3.CB_0.config_dataA\[3\] cell3.CB_0.config_dataA\[2\] vssd1 vssd1 vccd1
+ vccd1 _05904_ sky130_fd_sc_hd__nor2_1
XFILLER_71_500 vssd1 vssd1 vccd1 vccd1 sky130_fd_sc_hd__fill_4
XFILLER_56_563 vssd1 vssd1 vccd1 vccd1 sky130_fd_sc_hd__fill_1
XANTENNA__08315__A2 bus1_0\[2\] vssd1 vssd1 vccd1 vccd1 sky130_fd_sc_hd__diode_2
X_10881_ cell3.LE_1B.config_data\[12\] cell3.LE_1B.config_data\[13\] _05722_ vssd1
+ vssd1 vccd1 vccd1 _05837_ sky130_fd_sc_hd__mux2_1
X_09609_ net277 net52 _04624_ vssd1 vssd1 vccd1 vccd1 _04626_ sky130_fd_sc_hd__mux2_1
XFILLER_71_533 vssd1 vssd1 vccd1 vccd1 sky130_fd_sc_hd__fill_1
XFILLER_44_725 vssd1 vssd1 vccd1 vccd1 sky130_fd_sc_hd__fill_1
X_12620_ cell3.SB0.route_sel\[85\] cell3.SB0.route_sel\[84\] net878 vssd1 vssd1 vccd1
+ vccd1 _01049_ sky130_fd_sc_hd__mux2_1
XANTENNA_input101_A SBwest_in[13] vssd1 vssd1 vccd1 vccd1 sky130_fd_sc_hd__diode_2
XTAP_TAPCELL_ROW_65_1283 vssd1 vccd1 sky130_fd_sc_hd__tapvpwrvgnd_1
XTAP_TAPCELL_ROW_42_937 vssd1 vccd1 sky130_fd_sc_hd__tapvpwrvgnd_1
XANTENNA__07222__A net84 vssd1 vssd1 vccd1 vccd1 sky130_fd_sc_hd__diode_2
X_12551_ cell3.SB0.route_sel\[16\] cell3.SB0.route_sel\[15\] net920 vssd1 vssd1 vccd1
+ vccd1 _00980_ sky130_fd_sc_hd__mux2_1
X_12482_ cell2.LE_0A.reset_mode cell2.LE_0A.reset_val net841 vssd1 vssd1 vccd1 vccd1
+ _00912_ sky130_fd_sc_hd__mux2_1
X_11502_ cell2.SB0.route_sel\[44\] cell2.SB0.route_sel\[45\] vssd1 vssd1 vccd1 vccd1
+ _06335_ sky130_fd_sc_hd__nand2b_1
XFILLER_12_688 vssd1 vssd1 vccd1 vccd1 sky130_fd_sc_hd__fill_1
X_14221_ clknet_leaf_12_clk _01193_ net588 vssd1 vssd1 vccd1 vccd1 cell2.SB0.route_sel\[6\]
+ sky130_fd_sc_hd__dfstp_1
XANTENNA__11679__A net755 vssd1 vssd1 vccd1 vccd1 sky130_fd_sc_hd__diode_2
X_11433_ cell0.SB0.route_sel\[126\] cell0.SB0.config_data_out vssd1 vssd1 vccd1 vccd1
+ _06289_ sky130_fd_sc_hd__nor2_1
XFILLER_7_125 vccd1 vssd1 vccd1 vssd1 sky130_ef_sc_hd__decap_40_12
XFILLER_12_699 vssd1 vssd1 vccd1 vccd1 sky130_fd_sc_hd__fill_1
XANTENNA__10189__A2 net38 vssd1 vssd1 vccd1 vccd1 sky130_fd_sc_hd__diode_2
X_14152_ clknet_leaf_70_clk _01124_ net730 vssd1 vssd1 vccd1 vccd1 cell3.CB_1.config_dataA\[12\]
+ sky130_fd_sc_hd__dfstp_2
XFILLER_7_169 vssd1 vssd1 vccd1 vccd1 sky130_fd_sc_hd__fill_4
XFILLER_4_810 vssd1 vssd1 vccd1 vccd1 sky130_fd_sc_hd__fill_2
XFILLER_138_83 vssd1 vssd1 vccd1 vccd1 sky130_fd_sc_hd__fill_1
X_11364_ net747 cell3.LE_0B.reset_mode vssd1 vssd1 vccd1 vccd1 _11364_/X sky130_fd_sc_hd__xor2_2
XFILLER_98_21 vssd1 vssd1 vccd1 vccd1 sky130_fd_sc_hd__fill_4
X_10315_ _05136_ _05313_ vssd1 vssd1 vccd1 vccd1 _05314_ sky130_fd_sc_hd__nand2_1
X_11295_ _01826_ _05510_ _04229_ vssd1 vssd1 vccd1 vccd1 _06212_ sky130_fd_sc_hd__mux2_1
X_14083_ clknet_leaf_78_clk _01055_ net707 vssd1 vssd1 vccd1 vccd1 cell3.SB0.route_sel\[91\]
+ sky130_fd_sc_hd__dfstp_1
X_13103_ clknet_leaf_5_clk _00075_ net566 vssd1 vssd1 vccd1 vccd1 cell0.CB_0.config_dataA\[5\]
+ sky130_fd_sc_hd__dfstp_1
X_10246_ _05243_ _05246_ vssd1 vssd1 vccd1 vccd1 _05247_ sky130_fd_sc_hd__nor2_1
XFILLER_112_218 vssd1 vssd1 vccd1 vccd1 sky130_fd_sc_hd__fill_1
XFILLER_98_87 vssd1 vssd1 vccd1 vccd1 sky130_fd_sc_hd__fill_1
XANTENNA__08003__B2 _02905_ vssd1 vssd1 vccd1 vccd1 sky130_fd_sc_hd__diode_2
XANTENNA__08003__A1 _02902_ vssd1 vssd1 vccd1 vccd1 sky130_fd_sc_hd__diode_2
X_13034_ clknet_leaf_120_clk _00006_ net596 vssd1 vssd1 vccd1 vccd1 cell0.LE_1B.config_data\[6\]
+ sky130_fd_sc_hd__dfrtp_1
XFILLER_3_386 vssd1 vssd1 vccd1 vccd1 sky130_fd_sc_hd__fill_4
XFILLER_94_603 vssd1 vssd1 vccd1 vccd1 sky130_fd_sc_hd__fill_1
XFILLER_79_677 vccd1 vssd1 vccd1 vssd1 sky130_ef_sc_hd__decap_40_12
XANTENNA__10361__A2 net55 vssd1 vssd1 vccd1 vccd1 sky130_fd_sc_hd__diode_2
X_10177_ cell2.CB_0.config_dataA\[1\] _05176_ _05177_ vssd1 vssd1 vccd1 vccd1 _05178_
+ sky130_fd_sc_hd__a21oi_1
XANTENNA__07762__B1 _02804_ vssd1 vssd1 vccd1 vccd1 sky130_fd_sc_hd__diode_2
XFILLER_94_669 vssd1 vssd1 vccd1 vccd1 sky130_fd_sc_hd__fill_1
XFILLER_93_124 vssd1 vssd1 vccd1 vccd1 sky130_fd_sc_hd__fill_1
XANTENNA__13136__SET_B net581 vssd1 vssd1 vccd1 vccd1 sky130_fd_sc_hd__diode_2
X_13936_ clknet_leaf_28_clk net1030 net617 vssd1 vssd1 vccd1 vccd1 cell2.LE_0A.config_data\[15\]
+ sky130_fd_sc_hd__dfrtp_1
XFILLER_47_552 vssd1 vssd1 vccd1 vccd1 sky130_fd_sc_hd__fill_1
XANTENNA__06868__A2 _01933_ vssd1 vssd1 vccd1 vccd1 sky130_fd_sc_hd__diode_2
X_13867_ clknet_leaf_18_clk _00839_ net627 vssd1 vssd1 vccd1 vccd1 cell2.CB_1.config_dataB\[16\]
+ sky130_fd_sc_hd__dfstp_1
X_12818_ cell2.SB0.route_sel\[60\] cell2.SB0.route_sel\[59\] net809 vssd1 vssd1 vccd1
+ vccd1 _01247_ sky130_fd_sc_hd__mux2_1
XFILLER_43_780 vssd1 vssd1 vccd1 vccd1 sky130_fd_sc_hd__fill_1
X_13798_ clknet_leaf_105_clk _00770_ net661 vssd1 vssd1 vccd1 vccd1 cell1.SB0.route_sel\[75\]
+ sky130_fd_sc_hd__dfstp_1
XFILLER_22_419 vssd1 vssd1 vccd1 vccd1 sky130_fd_sc_hd__fill_1
X_12749_ net372 cell3.CB_0.config_dataA\[15\] net929 vssd1 vssd1 vccd1 vccd1 _01178_
+ sky130_fd_sc_hd__mux2_1
XFILLER_43_791 vssd1 vssd1 vccd1 vccd1 sky130_fd_sc_hd__fill_1
XANTENNA__10821__A0 _05519_ vssd1 vssd1 vccd1 vccd1 sky130_fd_sc_hd__diode_2
XFILLER_8_41 vccd1 vssd1 vccd1 vssd1 sky130_ef_sc_hd__decap_40_12
XTAP_TAPCELL_ROW_20_609 vssd1 vccd1 sky130_fd_sc_hd__tapvpwrvgnd_1
X_14419_ clknet_leaf_38_clk net987 net717 vssd1 vssd1 vccd1 vccd1 cell3.LE_0A.config_data\[6\]
+ sky130_fd_sc_hd__dfrtp_1
XFILLER_129_841 vssd1 vssd1 vccd1 vccd1 sky130_fd_sc_hd__fill_1
XFILLER_8_85 vccd1 vssd1 vccd1 vssd1 sky130_ef_sc_hd__decap_40_12
XTAP_TAPCELL_ROW_96_1744 vssd1 vccd1 sky130_fd_sc_hd__tapvpwrvgnd_1
XTAP_TAPCELL_ROW_96_1755 vssd1 vccd1 sky130_fd_sc_hd__tapvpwrvgnd_1
XANTENNA__11129__A1 _05856_ vssd1 vssd1 vccd1 vccd1 sky130_fd_sc_hd__diode_2
X_09960_ bus3_2\[4\] _04957_ _04958_ bus3_2\[5\] cell2.CB_1.config_dataB\[8\] vssd1
+ vssd1 vccd1 vccd1 _04964_ sky130_fd_sc_hd__a221o_1
Xmax_cap356 _02081_ vssd1 vssd1 vccd1 vccd1 net356 sky130_fd_sc_hd__buf_1
Xclkbuf_leaf_6_clk clknet_4_1_0_clk vssd1 vssd1 vccd1 vccd1 clknet_leaf_6_clk sky130_fd_sc_hd__clkbuf_8
XANTENNA__11129__B2 _05861_ vssd1 vssd1 vccd1 vccd1 sky130_fd_sc_hd__diode_2
X_08911_ net466 _03938_ _03939_ _03942_ vssd1 vssd1 vccd1 vccd1 _03943_ sky130_fd_sc_hd__a31o_1
X_09891_ cell2.CB_1.config_dataA\[17\] _04892_ _04893_ _04896_ vssd1 vssd1 vccd1 vccd1
+ _04897_ sky130_fd_sc_hd__o22a_1
XTAP_TAPCELL_ROW_127_2210 vssd1 vccd1 sky130_fd_sc_hd__tapvpwrvgnd_1
X_08842_ bus3_1\[5\] _03827_ _03831_ bus3_1\[4\] cell1.CB_0.config_dataA\[8\] vssd1
+ vssd1 vccd1 vccd1 _03874_ sky130_fd_sc_hd__a221o_1
X_08773_ _03805_ _03806_ _03702_ vssd1 vssd1 vccd1 vccd1 _03807_ sky130_fd_sc_hd__mux2_1
XTAP_TAPCELL_ROW_0_301 vssd1 vccd1 sky130_fd_sc_hd__tapvpwrvgnd_1
XTAP_TAPCELL_ROW_0_312 vssd1 vccd1 sky130_fd_sc_hd__tapvpwrvgnd_1
X_07724_ cell1.SB0.route_sel\[26\] cell1.SB0.route_sel\[27\] _02770_ vssd1 vssd1 vccd1
+ vccd1 _02771_ sky130_fd_sc_hd__a21oi_1
XFILLER_27_39 vccd1 vssd1 vccd1 vssd1 sky130_ef_sc_hd__decap_40_12
XFILLER_26_703 vssd1 vssd1 vccd1 vccd1 sky130_fd_sc_hd__fill_1
XTAP_TAPCELL_ROW_140_2410 vssd1 vccd1 sky130_fd_sc_hd__tapvpwrvgnd_1
XFILLER_53_533 vssd1 vssd1 vccd1 vccd1 sky130_fd_sc_hd__fill_1
X_07655_ _01850_ net353 bus1_0\[2\] vssd1 vssd1 vccd1 vccd1 _02703_ sky130_fd_sc_hd__o21ai_1
X_06606_ cell3.SB0.route_sel\[6\] vssd1 vssd1 vccd1 vccd1 _01676_ sky130_fd_sc_hd__inv_2
XANTENNA_fanout351_A _03025_ vssd1 vssd1 vccd1 vccd1 sky130_fd_sc_hd__diode_2
XANTENNA__11065__A0 _05912_ vssd1 vssd1 vccd1 vccd1 sky130_fd_sc_hd__diode_2
XTAP_TAPCELL_ROW_105_1884 vssd1 vccd1 sky130_fd_sc_hd__tapvpwrvgnd_1
X_07586_ cell1.SB0.route_sel\[6\] cell1.SB0.route_sel\[7\] _02612_ _02635_ vssd1 vssd1
+ vccd1 vccd1 _02636_ sky130_fd_sc_hd__a211o_1
X_06537_ cell2.SB0.route_sel\[42\] vssd1 vssd1 vccd1 vccd1 _01607_ sky130_fd_sc_hd__inv_2
X_09325_ cell3.SB0.route_sel\[31\] cell3.SB0.route_sel\[30\] vssd1 vssd1 vccd1 vccd1
+ _04350_ sky130_fd_sc_hd__nand2_1
XFILLER_33_290 vssd1 vssd1 vccd1 vccd1 sky130_fd_sc_hd__fill_1
XANTENNA_fanout616_A net623 vssd1 vssd1 vccd1 vccd1 sky130_fd_sc_hd__diode_2
X_09256_ bus3_2\[2\] _04280_ _04281_ vssd1 vssd1 vccd1 vccd1 _04282_ sky130_fd_sc_hd__a21o_1
X_06468_ cell1.SB0.route_sel\[94\] vssd1 vssd1 vccd1 vccd1 _01538_ sky130_fd_sc_hd__inv_2
XTAP_TAPCELL_ROW_138_2383 vssd1 vccd1 sky130_fd_sc_hd__tapvpwrvgnd_1
XTAP_TAPCELL_ROW_138_2372 vssd1 vccd1 sky130_fd_sc_hd__tapvpwrvgnd_1
X_08207_ bus1_0\[5\] _03233_ _03234_ bus1_0\[4\] cell0.CB_1.config_dataA\[13\] vssd1
+ vssd1 vccd1 vccd1 _03247_ sky130_fd_sc_hd__a221o_1
X_09187_ cell3.CB_0.config_dataB\[24\] cell3.CB_0.config_dataB\[21\] cell3.CB_0.config_dataB\[20\]
+ vssd1 vssd1 vccd1 vccd1 _04215_ sky130_fd_sc_hd__or3_2
XFILLER_5_629 vccd1 vssd1 vccd1 vssd1 sky130_ef_sc_hd__decap_40_12
X_06399_ cell0.SB0.route_sel\[76\] vssd1 vssd1 vccd1 vccd1 _01469_ sky130_fd_sc_hd__inv_2
XFILLER_4_139 vssd1 vssd1 vccd1 vccd1 sky130_fd_sc_hd__fill_1
X_08138_ _02425_ _03168_ _03177_ vssd1 vssd1 vccd1 vccd1 _03178_ sky130_fd_sc_hd__o21ai_1
XANTENNA__13487__Q cell1.CB_1.config_dataB\[0\] vssd1 vssd1 vccd1 vccd1 sky130_fd_sc_hd__diode_2
XANTENNA__08233__A1 _02350_ vssd1 vssd1 vccd1 vccd1 sky130_fd_sc_hd__diode_2
XANTENNA__10040__A1 bus3_2\[14\] vssd1 vssd1 vccd1 vccd1 sky130_fd_sc_hd__diode_2
X_08069_ cell0.CB_0.config_dataB\[11\] _03110_ vssd1 vssd1 vccd1 vccd1 _03111_ sky130_fd_sc_hd__and2_1
XFILLER_134_387 vssd1 vssd1 vccd1 vccd1 sky130_fd_sc_hd__fill_2
X_11080_ cell3.LE_0A.config_data\[0\] cell3.LE_0A.config_data\[1\] _05930_ vssd1 vssd1
+ vccd1 vccd1 _06034_ sky130_fd_sc_hd__mux2_1
X_10100_ cell2.SB0.route_sel\[123\] cell2.SB0.route_sel\[122\] vssd1 vssd1 vccd1 vccd1
+ _05101_ sky130_fd_sc_hd__nor2_1
XTAP_TAPCELL_ROW_8_434 vssd1 vccd1 sky130_fd_sc_hd__tapvpwrvgnd_1
XTAP_TAPCELL_ROW_8_423 vssd1 vccd1 sky130_fd_sc_hd__tapvpwrvgnd_1
XFILLER_1_835 vssd1 vssd1 vccd1 vccd1 sky130_fd_sc_hd__fill_2
X_10031_ net399 net400 vssd1 vssd1 vccd1 vccd1 _05035_ sky130_fd_sc_hd__and2b_1
XANTENNA_fanout773_X net773 vssd1 vssd1 vccd1 vccd1 sky130_fd_sc_hd__diode_2
XFILLER_0_345 vssd1 vssd1 vccd1 vccd1 sky130_fd_sc_hd__fill_1
XANTENNA__08536__A2 _03465_ vssd1 vssd1 vccd1 vccd1 sky130_fd_sc_hd__diode_2
XANTENNA__10343__A2 net318 vssd1 vssd1 vccd1 vccd1 sky130_fd_sc_hd__diode_2
XFILLER_76_614 vssd1 vssd1 vccd1 vccd1 sky130_fd_sc_hd__fill_1
XFILLER_124_41 vccd1 vssd1 vccd1 vssd1 sky130_ef_sc_hd__decap_40_12
XANTENNA_fanout940_X net940 vssd1 vssd1 vccd1 vccd1 sky130_fd_sc_hd__diode_2
XFILLER_75_113 vssd1 vssd1 vccd1 vccd1 sky130_fd_sc_hd__fill_2
XFILLER_91_617 vssd1 vssd1 vccd1 vccd1 sky130_fd_sc_hd__fill_2
XFILLER_29_563 vssd1 vssd1 vccd1 vccd1 sky130_fd_sc_hd__fill_1
X_13721_ clknet_leaf_34_clk _00693_ net636 vssd1 vssd1 vccd1 vccd1 cell2.CB_0.config_dataA\[23\]
+ sky130_fd_sc_hd__dfstp_1
XTAP_TAPCELL_ROW_67_1312 vssd1 vccd1 sky130_fd_sc_hd__tapvpwrvgnd_1
XFILLER_17_725 vssd1 vssd1 vccd1 vccd1 sky130_fd_sc_hd__fill_1
XTAP_TAPCELL_ROW_27_720 vssd1 vccd1 sky130_fd_sc_hd__tapvpwrvgnd_1
X_11982_ cell0.SB0.route_sel\[88\] cell0.SB0.route_sel\[87\] net786 vssd1 vssd1 vccd1
+ vccd1 _00419_ sky130_fd_sc_hd__mux2_1
XANTENNA__10646__A3 net25 vssd1 vssd1 vccd1 vccd1 sky130_fd_sc_hd__diode_2
X_10933_ _05853_ _05863_ _05868_ _05886_ vssd1 vssd1 vccd1 vccd1 _05887_ sky130_fd_sc_hd__o211ai_1
XANTENNA__10297__B _05103_ vssd1 vssd1 vccd1 vccd1 sky130_fd_sc_hd__diode_2
X_13652_ clknet_leaf_41_clk _00624_ net641 vssd1 vssd1 vccd1 vccd1 cell2.CB_1.config_dataA\[4\]
+ sky130_fd_sc_hd__dfstp_1
X_10864_ _05501_ _05504_ net365 vssd1 vssd1 vccd1 vccd1 _05820_ sky130_fd_sc_hd__mux2_1
XTAP_TAPCELL_ROW_80_1512 vssd1 vccd1 sky130_fd_sc_hd__tapvpwrvgnd_1
XTAP_TAPCELL_ROW_80_1501 vssd1 vccd1 sky130_fd_sc_hd__tapvpwrvgnd_1
XANTENNA_input104_X net104 vssd1 vssd1 vccd1 vccd1 sky130_fd_sc_hd__diode_2
XANTENNA__11056__A0 _05893_ vssd1 vssd1 vccd1 vccd1 sky130_fd_sc_hd__diode_2
X_10795_ _05739_ _05740_ _05746_ _05750_ vssd1 vssd1 vccd1 vccd1 _05751_ sky130_fd_sc_hd__a211oi_1
X_12603_ cell3.SB0.route_sel\[68\] cell3.SB0.route_sel\[67\] net910 vssd1 vssd1 vccd1
+ vccd1 _01032_ sky130_fd_sc_hd__mux2_1
X_13583_ clknet_leaf_88_clk _00555_ net688 vssd1 vssd1 vccd1 vccd1 cell1.LEI0.config_data\[4\]
+ sky130_fd_sc_hd__dfrtp_1
X_12534_ net1404 net549 _06384_ vssd1 vssd1 vccd1 vccd1 _00963_ sky130_fd_sc_hd__a21bo_1
XANTENNA__09620__A1_N cell1.CB_0.le_outA vssd1 vssd1 vccd1 vccd1 sky130_fd_sc_hd__diode_2
Xclkbuf_1_1__f_cell3.LE_0A.sel_clk clknet_0_cell3.LE_0A.sel_clk vssd1 vssd1 vccd1
+ vccd1 clknet_1_1__leaf_cell3.LE_0A.sel_clk sky130_fd_sc_hd__clkbuf_16
XFILLER_126_822 vssd1 vssd1 vccd1 vccd1 sky130_fd_sc_hd__fill_4
X_12465_ net1087 net1034 net812 vssd1 vssd1 vccd1 vccd1 _00895_ sky130_fd_sc_hd__mux2_1
XANTENNA__12556__A0 cell3.SB0.route_sel\[21\] vssd1 vssd1 vccd1 vccd1 sky130_fd_sc_hd__diode_2
XPHY_EDGE_ROW_49_Left_192 vssd1 vssd1 vccd1 vccd1 sky130_fd_sc_hd__decap_3
XFILLER_8_467 vssd1 vssd1 vccd1 vccd1 sky130_fd_sc_hd__fill_8
X_14204_ clknet_leaf_54_clk _01176_ net719 vssd1 vssd1 vccd1 vccd1 cell3.CB_0.config_dataA\[14\]
+ sky130_fd_sc_hd__dfstp_1
XFILLER_126_844 vssd1 vssd1 vccd1 vccd1 sky130_fd_sc_hd__fill_4
X_12396_ cell2.CB_1.config_dataB\[6\] net407 net848 vssd1 vssd1 vccd1 vccd1 _00829_
+ sky130_fd_sc_hd__mux2_1
Xclkbuf_1_0__f_cell1.LE_0B.sel_clk clknet_0_cell1.LE_0B.sel_clk vssd1 vssd1 vccd1
+ vccd1 clknet_1_0__leaf_cell1.LE_0B.sel_clk sky130_fd_sc_hd__clkbuf_16
X_11416_ cell0.SB0.route_sel\[102\] cell0.SB0.route_sel\[103\] _01478_ cell0.SB0.route_sel\[98\]
+ _06277_ vssd1 vssd1 vccd1 vccd1 _06278_ sky130_fd_sc_hd__o221a_1
X_14135_ clknet_leaf_66_clk net1305 net743 vssd1 vssd1 vccd1 vccd1 cell3.LE_1B.config_data\[15\]
+ sky130_fd_sc_hd__dfrtp_1
X_11347_ _04596_ _05874_ vssd1 vssd1 vccd1 vccd1 _06239_ sky130_fd_sc_hd__nand2b_1
XANTENNA__09972__A1 _04671_ vssd1 vssd1 vccd1 vccd1 sky130_fd_sc_hd__diode_2
XANTENNA__12732__S net933 vssd1 vssd1 vccd1 vccd1 sky130_fd_sc_hd__diode_2
XTAP_TAPCELL_ROW_78_1485 vssd1 vccd1 sky130_fd_sc_hd__tapvpwrvgnd_1
XTAP_TAPCELL_ROW_78_1474 vssd1 vccd1 sky130_fd_sc_hd__tapvpwrvgnd_1
XFILLER_141_847 vssd1 vssd1 vccd1 vccd1 sky130_fd_sc_hd__fill_1
XFILLER_3_161 vssd1 vssd1 vccd1 vccd1 sky130_fd_sc_hd__fill_4
X_11278_ net311 _02398_ _02399_ _06207_ vssd1 vssd1 vccd1 vccd1 net169 sky130_fd_sc_hd__a22o_2
XTAP_TAPCELL_ROW_91_1674 vssd1 vccd1 sky130_fd_sc_hd__tapvpwrvgnd_1
X_14066_ clknet_leaf_82_clk _01038_ net668 vssd1 vssd1 vccd1 vccd1 cell3.SB0.route_sel\[74\]
+ sky130_fd_sc_hd__dfstp_1
X_13017_ cell3.LEI0.config_data\[38\] net1477 net949 vssd1 vssd1 vccd1 vccd1 _01445_
+ sky130_fd_sc_hd__mux2_1
X_10229_ cell2.CB_0.config_dataA\[14\] _05200_ _05220_ _05227_ _05229_ vssd1 vssd1
+ vccd1 vccd1 _05230_ sky130_fd_sc_hd__a311o_1
XFILLER_94_400 vssd1 vssd1 vccd1 vccd1 sky130_fd_sc_hd__fill_1
XFILLER_67_625 vssd1 vssd1 vccd1 vccd1 sky130_fd_sc_hd__fill_1
XANTENNA__13956__RESET_B net635 vssd1 vssd1 vccd1 vccd1 sky130_fd_sc_hd__diode_2
Xhold1 cell0.LE_1A.dff0_out vssd1 vssd1 vccd1 vccd1 net960 sky130_fd_sc_hd__dlygate4sd3_1
XANTENNA__07414__X _02469_ vssd1 vssd1 vccd1 vccd1 sky130_fd_sc_hd__diode_2
XFILLER_66_179 vssd1 vssd1 vccd1 vccd1 sky130_fd_sc_hd__fill_1
XANTENNA__11083__S _05930_ vssd1 vssd1 vccd1 vccd1 sky130_fd_sc_hd__diode_2
XTAP_TAPCELL_ROW_122_2140 vssd1 vccd1 sky130_fd_sc_hd__tapvpwrvgnd_1
X_13919_ clknet_1_1__leaf_cell2.LE_1A.sel_clk _00891_ net752 vssd1 vssd1 vccd1 vccd1
+ cell2.LE_1A.dff1_out sky130_fd_sc_hd__dfstp_1
XPHY_EDGE_ROW_8_Right_8 vssd1 vssd1 vccd1 vccd1 sky130_fd_sc_hd__decap_3
X_07440_ net266 _02493_ vssd1 vssd1 vccd1 vccd1 _02494_ sky130_fd_sc_hd__nand2_4
XANTENNA__11047__A0 net53 vssd1 vssd1 vccd1 vccd1 sky130_fd_sc_hd__diode_2
X_07371_ cell1.SB0.route_sel\[111\] cell1.SB0.route_sel\[110\] vssd1 vssd1 vccd1 vccd1
+ _02427_ sky130_fd_sc_hd__nand2_1
XANTENNA__12907__S net936 vssd1 vssd1 vccd1 vccd1 sky130_fd_sc_hd__diode_2
X_09110_ net476 _03881_ vssd1 vssd1 vccd1 vccd1 _04140_ sky130_fd_sc_hd__nand2_1
XANTENNA__11811__S net902 vssd1 vssd1 vccd1 vccd1 sky130_fd_sc_hd__diode_2
X_09041_ bus3_1\[12\] bus3_1\[13\] bus3_1\[14\] bus3_1\[15\] net486 cell1.CB_0.config_dataB\[1\]
+ vssd1 vssd1 vccd1 vccd1 _04071_ sky130_fd_sc_hd__mux4_1
XFILLER_31_794 vssd1 vssd1 vccd1 vccd1 sky130_fd_sc_hd__fill_1
Xhold401 cell1.LEI0.config_data\[8\] vssd1 vssd1 vccd1 vccd1 net1360 sky130_fd_sc_hd__dlygate4sd3_1
Xhold423 cell2.LEI0.config_data\[39\] vssd1 vssd1 vccd1 vccd1 net1382 sky130_fd_sc_hd__dlygate4sd3_1
Xhold434 _01349_ vssd1 vssd1 vccd1 vccd1 net1393 sky130_fd_sc_hd__dlygate4sd3_1
Xhold412 _00928_ vssd1 vssd1 vccd1 vccd1 net1371 sky130_fd_sc_hd__dlygate4sd3_1
Xhold445 cell2.LE_0A.dff1_out vssd1 vssd1 vccd1 vccd1 net1404 sky130_fd_sc_hd__dlygate4sd3_1
Xhold467 cell3.LEI0.config_data\[39\] vssd1 vssd1 vccd1 vccd1 net1426 sky130_fd_sc_hd__dlygate4sd3_1
Xhold456 _01442_ vssd1 vssd1 vccd1 vccd1 net1415 sky130_fd_sc_hd__dlygate4sd3_1
Xhold478 cell1.LEI0.config_data\[30\] vssd1 vssd1 vccd1 vccd1 net1437 sky130_fd_sc_hd__dlygate4sd3_1
XFILLER_1_109 vssd1 vssd1 vccd1 vccd1 sky130_fd_sc_hd__fill_2
Xfanout925 net926 vssd1 vssd1 vccd1 vccd1 net925 sky130_fd_sc_hd__clkbuf_4
Xfanout914 net916 vssd1 vssd1 vccd1 vccd1 net914 sky130_fd_sc_hd__clkbuf_4
X_09943_ cell2.CB_1.config_dataB\[2\] _04944_ _04946_ cell2.CB_1.config_dataB\[3\]
+ vssd1 vssd1 vccd1 vccd1 _04947_ sky130_fd_sc_hd__o211a_1
Xfanout903 net907 vssd1 vssd1 vccd1 vccd1 net903 sky130_fd_sc_hd__clkbuf_4
XPHY_EDGE_ROW_39_Right_39 vssd1 vssd1 vccd1 vccd1 sky130_fd_sc_hd__decap_3
Xhold489 cell1.LE_1B.config_data\[4\] vssd1 vssd1 vccd1 vccd1 net1448 sky130_fd_sc_hd__dlygate4sd3_1
XANTENNA__10325__A2 net55 vssd1 vssd1 vccd1 vccd1 sky130_fd_sc_hd__diode_2
Xfanout958 net959 vssd1 vssd1 vccd1 vccd1 net958 sky130_fd_sc_hd__clkbuf_2
Xfanout947 net952 vssd1 vssd1 vccd1 vccd1 net947 sky130_fd_sc_hd__clkbuf_4
Xfanout936 net944 vssd1 vssd1 vccd1 vccd1 net936 sky130_fd_sc_hd__buf_2
X_09874_ bus3_2\[8\] bus3_2\[9\] bus3_2\[10\] bus3_2\[11\] net439 cell2.CB_1.config_dataA\[16\]
+ vssd1 vssd1 vccd1 vccd1 _04880_ sky130_fd_sc_hd__mux4_1
XFILLER_57_113 vssd1 vssd1 vccd1 vccd1 sky130_fd_sc_hd__fill_1
X_08825_ cell1.SB0.route_sel\[18\] cell1.SB0.route_sel\[19\] cell1.SB0.route_sel\[21\]
+ _01507_ _03856_ vssd1 vssd1 vccd1 vccd1 _03857_ sky130_fd_sc_hd__o221a_1
XFILLER_46_809 vssd1 vssd1 vccd1 vccd1 sky130_fd_sc_hd__fill_1
XTAP_TAPCELL_ROW_107_1913 vssd1 vccd1 sky130_fd_sc_hd__tapvpwrvgnd_1
X_08756_ net451 _03788_ _03789_ vssd1 vssd1 vccd1 vccd1 _03790_ sky130_fd_sc_hd__a21oi_1
XFILLER_26_500 vssd1 vssd1 vccd1 vccd1 sky130_fd_sc_hd__fill_1
XANTENNA_fanout733_A net749 vssd1 vssd1 vccd1 vccd1 sky130_fd_sc_hd__diode_2
X_07707_ _01947_ _02624_ bus2_0\[3\] vssd1 vssd1 vccd1 vccd1 _02754_ sky130_fd_sc_hd__o21ai_1
XTAP_TAPCELL_ROW_49_1042 vssd1 vccd1 sky130_fd_sc_hd__tapvpwrvgnd_1
XANTENNA_fanout354_X net354 vssd1 vssd1 vccd1 vccd1 sky130_fd_sc_hd__diode_2
X_08687_ net1 net12 net23 net26 net461 net460 vssd1 vssd1 vccd1 vccd1 _03721_ sky130_fd_sc_hd__mux4_1
X_07638_ net320 _02685_ vssd1 vssd1 vccd1 vccd1 _02687_ sky130_fd_sc_hd__or2_1
XFILLER_110_21 vssd1 vssd1 vccd1 vccd1 sky130_fd_sc_hd__fill_4
XTAP_TAPCELL_ROW_62_1231 vssd1 vccd1 sky130_fd_sc_hd__tapvpwrvgnd_1
XPHY_EDGE_ROW_48_Right_48 vssd1 vssd1 vccd1 vccd1 sky130_fd_sc_hd__decap_3
X_07569_ _02617_ _02618_ _02614_ _02615_ vssd1 vssd1 vccd1 vccd1 _02619_ sky130_fd_sc_hd__a2bb2o_1
XANTENNA_fanout900_A net907 vssd1 vssd1 vccd1 vccd1 sky130_fd_sc_hd__diode_2
XANTENNA_fanout619_X net619 vssd1 vssd1 vccd1 vccd1 sky130_fd_sc_hd__diode_2
XTAP_TAPCELL_ROW_62_1242 vssd1 vccd1 sky130_fd_sc_hd__tapvpwrvgnd_1
X_09308_ cell2.SB0.route_sel\[29\] cell2.SB0.route_sel\[28\] _02755_ _04332_ _02753_
+ vssd1 vssd1 vccd1 vccd1 _04333_ sky130_fd_sc_hd__a221o_1
X_10580_ _01730_ cell3.SB0.route_sel\[86\] vssd1 vssd1 vccd1 vccd1 _05538_ sky130_fd_sc_hd__nand2_1
XANTENNA__08155__X _03195_ vssd1 vssd1 vccd1 vccd1 sky130_fd_sc_hd__diode_2
XANTENNA__10261__A1 net305 vssd1 vssd1 vccd1 vccd1 sky130_fd_sc_hd__diode_2
X_09239_ net381 net380 _04265_ vssd1 vssd1 vccd1 vccd1 _04266_ sky130_fd_sc_hd__or3_1
X_12250_ cell2.CB_0.config_dataA\[13\] cell2.CB_0.config_dataA\[12\] net822 vssd1
+ vssd1 vccd1 vccd1 _00683_ sky130_fd_sc_hd__mux2_1
X_12181_ net1348 net1357 net850 vssd1 vssd1 vccd1 vccd1 _00614_ sky130_fd_sc_hd__mux2_1
X_11201_ net383 _05912_ net382 vssd1 vssd1 vccd1 vccd1 _06153_ sky130_fd_sc_hd__o21a_1
X_11132_ net49 net50 net51 net52 cell3.CB_0.config_dataB\[5\] cell3.CB_0.config_dataB\[6\]
+ vssd1 vssd1 vccd1 vccd1 _06084_ sky130_fd_sc_hd__mux4_1
XFILLER_123_847 vssd1 vssd1 vccd1 vccd1 sky130_fd_sc_hd__fill_1
XPHY_EDGE_ROW_57_Right_57 vssd1 vssd1 vccd1 vccd1 sky130_fd_sc_hd__decap_3
XFILLER_135_51 vssd1 vssd1 vccd1 vccd1 sky130_fd_sc_hd__fill_4
X_11063_ net372 _06015_ _06016_ vssd1 vssd1 vccd1 vccd1 _06017_ sky130_fd_sc_hd__a21oi_1
XFILLER_89_761 vssd1 vssd1 vccd1 vccd1 sky130_fd_sc_hd__fill_1
XANTENNA_hold566_X net1525 vssd1 vssd1 vccd1 vccd1 sky130_fd_sc_hd__diode_2
XFILLER_1_665 vssd1 vssd1 vccd1 vccd1 sky130_fd_sc_hd__fill_4
X_10014_ _05012_ _05015_ _05017_ cell2.CB_1.config_dataB\[12\] vssd1 vssd1 vccd1 vccd1
+ _05018_ sky130_fd_sc_hd__o22a_1
XFILLER_95_55 vssd1 vssd1 vccd1 vccd1 sky130_fd_sc_hd__fill_1
XFILLER_0_197 vssd1 vssd1 vccd1 vccd1 sky130_fd_sc_hd__fill_4
XFILLER_95_99 vssd1 vssd1 vccd1 vccd1 sky130_fd_sc_hd__fill_4
XFILLER_76_477 vssd1 vssd1 vccd1 vccd1 sky130_fd_sc_hd__fill_8
XFILLER_76_466 vssd1 vssd1 vccd1 vccd1 sky130_fd_sc_hd__fill_1
XANTENNA__12069__A2 net550 vssd1 vssd1 vccd1 vccd1 sky130_fd_sc_hd__diode_2
X_11965_ cell0.SB0.route_sel\[71\] cell0.SB0.route_sel\[70\] net764 vssd1 vssd1 vccd1
+ vccd1 _00402_ sky130_fd_sc_hd__mux2_1
X_13704_ clknet_leaf_28_clk _00676_ net617 vssd1 vssd1 vccd1 vccd1 cell2.CB_0.config_dataA\[6\]
+ sky130_fd_sc_hd__dfstp_1
X_10916_ cell3.SB0.route_sel\[91\] cell3.SB0.route_sel\[90\] _01734_ cell3.SB0.route_sel\[94\]
+ _05869_ vssd1 vssd1 vccd1 vccd1 _05870_ sky130_fd_sc_hd__o221a_1
XPHY_EDGE_ROW_66_Right_66 vssd1 vssd1 vccd1 vccd1 sky130_fd_sc_hd__decap_3
X_13635_ clknet_leaf_39_clk _00607_ net647 vssd1 vssd1 vccd1 vccd1 cell2.LE_1B.config_data\[7\]
+ sky130_fd_sc_hd__dfrtp_1
X_11896_ cell0.SB0.route_sel\[2\] cell0.SB0.route_sel\[1\] net782 vssd1 vssd1 vccd1
+ vccd1 _00333_ sky130_fd_sc_hd__mux2_1
X_10847_ _05540_ _05543_ cell3.CB_1.config_dataB\[15\] vssd1 vssd1 vccd1 vccd1 _05803_
+ sky130_fd_sc_hd__mux2_1
XANTENNA__09237__A3 _04263_ vssd1 vssd1 vccd1 vccd1 sky130_fd_sc_hd__diode_2
XANTENNA__10595__X _05553_ vssd1 vssd1 vccd1 vccd1 sky130_fd_sc_hd__diode_2
X_10778_ _05540_ _05543_ net369 vssd1 vssd1 vccd1 vccd1 _05734_ sky130_fd_sc_hd__mux2_1
X_13566_ clknet_leaf_118_clk net1178 net668 vssd1 vssd1 vccd1 vccd1 cell1.LE_0A.config_data\[9\]
+ sky130_fd_sc_hd__dfrtp_1
XPHY_EDGE_ROW_57_Left_200 vssd1 vssd1 vccd1 vccd1 sky130_fd_sc_hd__decap_3
XFILLER_9_721 vssd1 vssd1 vccd1 vccd1 sky130_fd_sc_hd__fill_4
XANTENNA__08445__A1 net5 vssd1 vssd1 vccd1 vccd1 sky130_fd_sc_hd__diode_2
XANTENNA__10252__A1 _05111_ vssd1 vssd1 vccd1 vccd1 sky130_fd_sc_hd__diode_2
X_12517_ net1537 cell2.LEI0.config_data\[30\] net847 vssd1 vssd1 vccd1 vccd1 _00946_
+ sky130_fd_sc_hd__mux2_1
X_13497_ clknet_leaf_93_clk _00469_ net693 vssd1 vssd1 vccd1 vccd1 cell1.CB_1.config_dataB\[10\]
+ sky130_fd_sc_hd__dfstp_1
XFILLER_8_253 vccd1 vssd1 vccd1 vssd1 sky130_ef_sc_hd__decap_40_12
XTAP_TAPCELL_ROW_30_759 vssd1 vccd1 sky130_fd_sc_hd__tapvpwrvgnd_1
X_12448_ cell2.LE_0B.config_data\[8\] net1367 net842 vssd1 vssd1 vccd1 vccd1 _00879_
+ sky130_fd_sc_hd__mux2_1
XFILLER_8_297 vssd1 vssd1 vccd1 vccd1 sky130_fd_sc_hd__fill_1
XTAP_TAPCELL_ROW_10_461 vssd1 vccd1 sky130_fd_sc_hd__tapvpwrvgnd_1
XTAP_TAPCELL_ROW_93_1703 vssd1 vccd1 sky130_fd_sc_hd__tapvpwrvgnd_1
XPHY_EDGE_ROW_75_Right_75 vssd1 vssd1 vccd1 vccd1 sky130_fd_sc_hd__decap_3
X_12379_ cell1.SB0.route_sel\[117\] cell1.SB0.route_sel\[116\] net881 vssd1 vssd1
+ vccd1 vccd1 _00812_ sky130_fd_sc_hd__mux2_1
X_14118_ clknet_leaf_47_clk _01090_ net704 vssd1 vssd1 vccd1 vccd1 cell3.SB0.route_sel\[126\]
+ sky130_fd_sc_hd__dfstp_1
XFILLER_101_519 vssd1 vssd1 vccd1 vccd1 sky130_fd_sc_hd__fill_1
X_14049_ clknet_leaf_46_clk _01021_ net703 vssd1 vssd1 vccd1 vccd1 cell3.SB0.route_sel\[57\]
+ sky130_fd_sc_hd__dfstp_1
X_06940_ _02006_ _01991_ vssd1 vssd1 vccd1 vccd1 _02007_ sky130_fd_sc_hd__nand2b_1
XANTENNA__09173__A2 _04198_ vssd1 vssd1 vccd1 vccd1 sky130_fd_sc_hd__diode_2
X_06871_ cell0.SB0.route_sel\[61\] cell0.SB0.route_sel\[60\] vssd1 vssd1 vccd1 vccd1
+ _01939_ sky130_fd_sc_hd__nand2_1
X_08610_ _03639_ _03645_ vssd1 vssd1 vccd1 vccd1 _03646_ sky130_fd_sc_hd__nor2_1
X_09590_ _04606_ vssd1 vssd1 vccd1 vccd1 _04607_ sky130_fd_sc_hd__inv_2
XPHY_EDGE_ROW_84_Right_84 vssd1 vssd1 vccd1 vccd1 sky130_fd_sc_hd__decap_3
XANTENNA__06931__A1 net303 vssd1 vssd1 vccd1 vccd1 sky130_fd_sc_hd__diode_2
X_08541_ net332 net326 cell1.LEI0.config_data\[18\] vssd1 vssd1 vccd1 vccd1 _03577_
+ sky130_fd_sc_hd__mux2_1
XANTENNA__13590__Q cell1.LEI0.config_data\[11\] vssd1 vssd1 vccd1 vccd1 sky130_fd_sc_hd__diode_2
XANTENNA__08133__A0 bus1_0\[8\] vssd1 vssd1 vccd1 vccd1 sky130_fd_sc_hd__diode_2
X_08472_ cell1.SB0.route_sel\[29\] cell1.SB0.route_sel\[28\] _01511_ cell1.SB0.route_sel\[31\]
+ _03507_ vssd1 vssd1 vccd1 vccd1 _03508_ sky130_fd_sc_hd__o221a_1
XFILLER_23_503 vssd1 vssd1 vccd1 vccd1 sky130_fd_sc_hd__fill_1
XTAP_TAPCELL_ROW_102_1832 vssd1 vccd1 sky130_fd_sc_hd__tapvpwrvgnd_1
XTAP_TAPCELL_ROW_18_572 vssd1 vccd1 sky130_fd_sc_hd__tapvpwrvgnd_1
XTAP_TAPCELL_ROW_18_583 vssd1 vccd1 sky130_fd_sc_hd__tapvpwrvgnd_1
XFILLER_24_29 vccd1 vssd1 vccd1 vssd1 sky130_ef_sc_hd__decap_40_12
X_07423_ net361 _02326_ bus1_0\[14\] vssd1 vssd1 vccd1 vccd1 _02477_ sky130_fd_sc_hd__o21ai_1
XTAP_TAPCELL_ROW_102_1843 vssd1 vccd1 sky130_fd_sc_hd__tapvpwrvgnd_1
XFILLER_50_399 vssd1 vssd1 vccd1 vccd1 sky130_fd_sc_hd__fill_1
X_07354_ cell0.SB0.route_sel\[107\] cell0.SB0.route_sel\[106\] vssd1 vssd1 vccd1 vccd1
+ _02410_ sky130_fd_sc_hd__nand2_1
XFILLER_136_416 vssd1 vssd1 vccd1 vccd1 sky130_fd_sc_hd__fill_4
XTAP_TAPCELL_ROW_135_2331 vssd1 vccd1 sky130_fd_sc_hd__tapvpwrvgnd_1
XANTENNA__10243__A1 net62 vssd1 vssd1 vccd1 vccd1 sky130_fd_sc_hd__diode_2
XANTENNA_fanout314_A net316 vssd1 vssd1 vccd1 vccd1 sky130_fd_sc_hd__diode_2
X_07285_ net347 _02030_ _02339_ vssd1 vssd1 vccd1 vccd1 _02343_ sky130_fd_sc_hd__and3_1
XPHY_EDGE_ROW_93_Right_93 vssd1 vssd1 vccd1 vccd1 sky130_fd_sc_hd__decap_3
X_09024_ net484 net485 vssd1 vssd1 vccd1 vccd1 _04054_ sky130_fd_sc_hd__and2b_1
Xhold220 cell2.LE_0A.config_data\[7\] vssd1 vssd1 vccd1 vccd1 net1179 sky130_fd_sc_hd__dlygate4sd3_1
Xhold253 cell3.LE_0A.config_data\[8\] vssd1 vssd1 vccd1 vccd1 net1212 sky130_fd_sc_hd__dlygate4sd3_1
Xhold231 cell3.LE_0A.config_data\[6\] vssd1 vssd1 vccd1 vccd1 net1190 sky130_fd_sc_hd__dlygate4sd3_1
XANTENNA__07947__A0 bus2_0\[0\] vssd1 vssd1 vccd1 vccd1 sky130_fd_sc_hd__diode_2
Xhold242 _00486_ vssd1 vssd1 vccd1 vccd1 net1201 sky130_fd_sc_hd__dlygate4sd3_1
Xhold286 cell2.LE_0B.config_data\[14\] vssd1 vssd1 vccd1 vccd1 net1245 sky130_fd_sc_hd__dlygate4sd3_1
XFILLER_131_121 vssd1 vssd1 vccd1 vccd1 sky130_fd_sc_hd__fill_1
Xhold275 _01386_ vssd1 vssd1 vccd1 vccd1 net1234 sky130_fd_sc_hd__dlygate4sd3_1
Xhold264 cell2.LE_0A.config_data\[12\] vssd1 vssd1 vccd1 vccd1 net1223 sky130_fd_sc_hd__dlygate4sd3_1
Xfanout700 net750 vssd1 vssd1 vccd1 vccd1 net700 sky130_fd_sc_hd__clkbuf_2
XFILLER_49_37 vssd1 vssd1 vccd1 vccd1 sky130_fd_sc_hd__fill_1
XANTENNA_fanout683_A net684 vssd1 vssd1 vccd1 vccd1 sky130_fd_sc_hd__diode_2
Xfanout722 net723 vssd1 vssd1 vccd1 vccd1 net722 sky130_fd_sc_hd__clkbuf_4
Xfanout733 net749 vssd1 vssd1 vccd1 vccd1 net733 sky130_fd_sc_hd__clkbuf_2
Xfanout711 net712 vssd1 vssd1 vccd1 vccd1 net711 sky130_fd_sc_hd__clkbuf_4
X_09926_ bus3_2\[6\] bus3_2\[7\] net409 vssd1 vssd1 vccd1 vccd1 _04930_ sky130_fd_sc_hd__mux2_1
Xhold297 cell0.LE_1B.config_data\[8\] vssd1 vssd1 vccd1 vccd1 net1256 sky130_fd_sc_hd__dlygate4sd3_1
Xfanout744 net746 vssd1 vssd1 vccd1 vccd1 net744 sky130_fd_sc_hd__clkbuf_4
Xfanout755 net756 vssd1 vssd1 vccd1 vccd1 net755 sky130_fd_sc_hd__buf_4
Xfanout766 net767 vssd1 vssd1 vccd1 vccd1 net766 sky130_fd_sc_hd__clkbuf_4
XANTENNA_fanout850_A net854 vssd1 vssd1 vccd1 vccd1 sky130_fd_sc_hd__diode_2
XANTENNA_fanout948_A net952 vssd1 vssd1 vccd1 vccd1 sky130_fd_sc_hd__diode_2
X_09857_ cell2.CB_1.config_dataA\[13\] _04843_ _04847_ _04862_ vssd1 vssd1 vccd1 vccd1
+ _04863_ sky130_fd_sc_hd__a31o_1
Xfanout777 net779 vssd1 vssd1 vccd1 vccd1 net777 sky130_fd_sc_hd__clkbuf_4
Xfanout799 net806 vssd1 vssd1 vccd1 vccd1 net799 sky130_fd_sc_hd__clkbuf_4
XFILLER_46_606 vssd1 vssd1 vccd1 vccd1 sky130_fd_sc_hd__fill_1
Xfanout788 net790 vssd1 vssd1 vccd1 vccd1 net788 sky130_fd_sc_hd__clkbuf_4
X_09788_ net448 net446 vssd1 vssd1 vccd1 vccd1 _04794_ sky130_fd_sc_hd__or2_1
XANTENNA__09253__Y _04279_ vssd1 vssd1 vccd1 vccd1 sky130_fd_sc_hd__diode_2
XFILLER_73_414 vssd1 vssd1 vccd1 vccd1 sky130_fd_sc_hd__fill_1
X_08808_ cell1.SB0.route_sel\[85\] cell1.SB0.route_sel\[84\] vssd1 vssd1 vccd1 vccd1
+ _03840_ sky130_fd_sc_hd__nand2b_1
X_08739_ net451 net453 vssd1 vssd1 vccd1 vccd1 _03773_ sky130_fd_sc_hd__and2b_1
X_11750_ net1423 cell0.LE_1A.reset_mode net803 vssd1 vssd1 vccd1 vccd1 _00187_ sky130_fd_sc_hd__mux2_1
XFILLER_54_661 vssd1 vssd1 vccd1 vccd1 sky130_fd_sc_hd__fill_1
XTAP_TAPCELL_ROW_37_870 vssd1 vccd1 sky130_fd_sc_hd__tapvpwrvgnd_1
X_10701_ net15 net16 cell3.CB_1.config_dataA\[15\] vssd1 vssd1 vccd1 vccd1 _05659_
+ sky130_fd_sc_hd__mux2_1
XANTENNA__12547__S net936 vssd1 vssd1 vccd1 vccd1 sky130_fd_sc_hd__diode_2
XANTENNA__11304__X net147 vssd1 vssd1 vccd1 vccd1 sky130_fd_sc_hd__diode_2
XFILLER_81_57 vssd1 vssd1 vccd1 vccd1 sky130_fd_sc_hd__fill_1
X_11681_ net1498 cell0.LE_0B.reset_mode net804 vssd1 vssd1 vccd1 vccd1 _00121_ sky130_fd_sc_hd__mux2_1
XANTENNA__06878__A_N cell0.CB_0.config_dataB\[24\] vssd1 vssd1 vccd1 vccd1 sky130_fd_sc_hd__diode_2
XANTENNA__11026__A3 net43 vssd1 vssd1 vccd1 vccd1 sky130_fd_sc_hd__diode_2
X_10632_ _05585_ _05588_ _05589_ _01784_ vssd1 vssd1 vccd1 vccd1 _05590_ sky130_fd_sc_hd__a22oi_1
X_13420_ clknet_leaf_131_clk _00392_ net557 vssd1 vssd1 vccd1 vccd1 cell0.SB0.route_sel\[61\]
+ sky130_fd_sc_hd__dfstp_1
XANTENNA__14189__SET_B net723 vssd1 vssd1 vccd1 vccd1 sky130_fd_sc_hd__diode_2
X_10563_ cell3.SB0.route_sel\[120\] _01747_ cell3.SB0.route_sel\[125\] cell3.SB0.route_sel\[124\]
+ _05520_ vssd1 vssd1 vccd1 vccd1 _05521_ sky130_fd_sc_hd__o221a_2
X_13351_ clknet_leaf_117_clk _00323_ net675 vssd1 vssd1 vccd1 vccd1 cell1.CB_0.config_dataA\[17\]
+ sky130_fd_sc_hd__dfstp_2
XANTENNA__10785__A2 net10 vssd1 vssd1 vccd1 vccd1 sky130_fd_sc_hd__diode_2
XFILLER_6_713 vccd1 vssd1 vccd1 vssd1 sky130_ef_sc_hd__decap_40_12
X_12302_ cell1.SB0.route_sel\[40\] cell1.SB0.route_sel\[39\] net859 vssd1 vssd1 vccd1
+ vccd1 _00735_ sky130_fd_sc_hd__mux2_1
X_13282_ clknet_leaf_91_clk _00254_ net698 vssd1 vssd1 vccd1 vccd1 cell1.LE_1B.reset_val
+ sky130_fd_sc_hd__dfrtp_1
XFILLER_6_757 vssd1 vssd1 vccd1 vccd1 sky130_fd_sc_hd__fill_4
XFILLER_5_234 vssd1 vssd1 vccd1 vccd1 sky130_fd_sc_hd__fill_4
XFILLER_5_223 vssd1 vssd1 vccd1 vccd1 sky130_fd_sc_hd__fill_1
XANTENNA_input77_A SBsouth_in[20] vssd1 vssd1 vccd1 vccd1 sky130_fd_sc_hd__diode_2
X_10494_ net333 _02855_ _02856_ _05462_ vssd1 vssd1 vccd1 vccd1 net161 sky130_fd_sc_hd__a22o_1
X_12233_ cell2.CB_0.config_dataB\[21\] cell2.CB_0.config_dataB\[20\] net826 vssd1
+ vssd1 vccd1 vccd1 _00666_ sky130_fd_sc_hd__mux2_1
XTAP_TAPCELL_ROW_75_1433 vssd1 vccd1 sky130_fd_sc_hd__tapvpwrvgnd_1
XFILLER_30_83 vssd1 vssd1 vccd1 vccd1 sky130_fd_sc_hd__fill_1
XANTENNA__07229__X _02289_ vssd1 vssd1 vccd1 vccd1 sky130_fd_sc_hd__diode_2
X_12164_ net1326 net1303 net892 vssd1 vssd1 vccd1 vccd1 _00597_ sky130_fd_sc_hd__mux2_1
X_11115_ net40 net41 net42 net43 net389 net388 vssd1 vssd1 vccd1 vccd1 _06067_ sky130_fd_sc_hd__mux4_1
X_12095_ net1149 cell0.SB0.config_data_out net804 vssd1 vssd1 vccd1 vccd1 _00529_
+ sky130_fd_sc_hd__mux2_1
X_11046_ _05856_ _05997_ _05999_ _05861_ _01812_ vssd1 vssd1 vccd1 vccd1 _06000_ sky130_fd_sc_hd__a221o_1
XANTENNA_input32_X net32 vssd1 vssd1 vccd1 vccd1 sky130_fd_sc_hd__diode_2
XFILLER_1_473 vccd1 vssd1 vccd1 vssd1 sky130_ef_sc_hd__decap_40_12
XANTENNA_output233_A net233 vssd1 vssd1 vccd1 vccd1 sky130_fd_sc_hd__diode_2
XANTENNA__08363__A0 bus1_0\[0\] vssd1 vssd1 vccd1 vccd1 sky130_fd_sc_hd__diode_2
XANTENNA__10102__Y _05103_ vssd1 vssd1 vccd1 vccd1 sky130_fd_sc_hd__diode_2
X_12997_ net1401 cell3.LEI0.config_data\[17\] net946 vssd1 vssd1 vccd1 vccd1 _01425_
+ sky130_fd_sc_hd__mux2_1
XFILLER_91_277 vssd1 vssd1 vccd1 vccd1 sky130_fd_sc_hd__fill_1
XFILLER_17_341 vssd1 vssd1 vccd1 vccd1 sky130_fd_sc_hd__fill_2
XTAP_TAPCELL_ROW_35_829 vssd1 vccd1 sky130_fd_sc_hd__tapvpwrvgnd_1
XANTENNA__12462__A2 net549 vssd1 vssd1 vccd1 vccd1 sky130_fd_sc_hd__diode_2
XFILLER_91_299 vssd1 vssd1 vccd1 vccd1 sky130_fd_sc_hd__fill_1
XTAP_TAPCELL_ROW_86_1595 vssd1 vccd1 sky130_fd_sc_hd__tapvpwrvgnd_1
X_11948_ cell0.SB0.route_sel\[54\] cell0.SB0.route_sel\[53\] net759 vssd1 vssd1 vccd1
+ vccd1 _00385_ sky130_fd_sc_hd__mux2_1
XANTENNA__13328__SET_B net691 vssd1 vssd1 vccd1 vccd1 sky130_fd_sc_hd__diode_2
X_11879_ cell1.CB_0.config_dataA\[10\] cell1.CB_0.config_dataA\[9\] net881 vssd1 vssd1
+ vccd1 vccd1 _00316_ sky130_fd_sc_hd__mux2_1
XTAP_TAPCELL_ROW_15_531 vssd1 vccd1 sky130_fd_sc_hd__tapvpwrvgnd_1
X_13618_ clknet_leaf_87_clk _00590_ net686 vssd1 vssd1 vccd1 vccd1 cell1.LEI0.config_data\[39\]
+ sky130_fd_sc_hd__dfrtp_1
X_13549_ clknet_leaf_90_clk net1520 net699 vssd1 vssd1 vccd1 vccd1 cell1.LE_0B.config_data\[14\]
+ sky130_fd_sc_hd__dfrtp_1
X_07070_ cell0.SB0.route_sel\[77\] cell0.SB0.route_sel\[76\] vssd1 vssd1 vccd1 vccd1
+ _02134_ sky130_fd_sc_hd__or2_1
XTAP_TAPCELL_ROW_117_2061 vssd1 vccd1 sky130_fd_sc_hd__tapvpwrvgnd_1
XANTENNA__07929__A0 bus2_0\[12\] vssd1 vssd1 vccd1 vccd1 sky130_fd_sc_hd__diode_2
XTAP_TAPCELL_ROW_130_2261 vssd1 vccd1 sky130_fd_sc_hd__tapvpwrvgnd_1
X_09711_ _02603_ _04723_ vssd1 vssd1 vccd1 vccd1 _04724_ sky130_fd_sc_hd__and2_2
X_07972_ _03015_ _02980_ _02978_ vssd1 vssd1 vccd1 vccd1 _03016_ sky130_fd_sc_hd__mux2_1
X_06923_ _01983_ _01988_ _01989_ vssd1 vssd1 vccd1 vccd1 _01990_ sky130_fd_sc_hd__o21ba_1
XANTENNA__07157__A1 net322 vssd1 vssd1 vccd1 vccd1 sky130_fd_sc_hd__diode_2
X_06854_ cell2.CB_0.config_dataA\[23\] cell2.CB_0.config_dataA\[22\] vssd1 vssd1 vccd1
+ vccd1 _01923_ sky130_fd_sc_hd__nand2b_1
X_09642_ _01825_ _04655_ vssd1 vssd1 vccd1 vccd1 _04658_ sky130_fd_sc_hd__nand2_1
XFILLER_83_723 vssd1 vssd1 vccd1 vccd1 sky130_fd_sc_hd__fill_1
XFILLER_28_617 vssd1 vssd1 vccd1 vccd1 sky130_fd_sc_hd__fill_1
X_09573_ _04304_ _04537_ vssd1 vssd1 vccd1 vccd1 _04591_ sky130_fd_sc_hd__or2_1
XFILLER_55_447 vssd1 vssd1 vccd1 vccd1 sky130_fd_sc_hd__fill_1
X_06785_ net361 net360 bus1_0\[6\] vssd1 vssd1 vccd1 vccd1 _01855_ sky130_fd_sc_hd__o21ai_1
XTAP_TAPCELL_ROW_46_1001 vssd1 vccd1 sky130_fd_sc_hd__tapvpwrvgnd_1
X_08524_ net494 _03533_ _03559_ net493 vssd1 vssd1 vccd1 vccd1 _03560_ sky130_fd_sc_hd__o211a_1
XFILLER_35_39 vccd1 vssd1 vccd1 vssd1 sky130_ef_sc_hd__decap_40_12
X_08455_ net497 _03486_ _03490_ net496 vssd1 vssd1 vccd1 vccd1 _03491_ sky130_fd_sc_hd__o211a_1
XANTENNA__11124__X _06076_ vssd1 vssd1 vccd1 vccd1 sky130_fd_sc_hd__diode_2
X_07406_ cell2.SB0.route_sel\[110\] cell2.SB0.route_sel\[111\] _02460_ vssd1 vssd1
+ vccd1 vccd1 _02461_ sky130_fd_sc_hd__a21bo_1
XANTENNA__07880__A2 _02894_ vssd1 vssd1 vccd1 vccd1 sky130_fd_sc_hd__diode_2
XFILLER_23_388 vssd1 vssd1 vccd1 vccd1 sky130_fd_sc_hd__fill_1
X_08386_ _02350_ _03421_ _03423_ _03419_ cell0.CB_1.config_dataB\[17\] vssd1 vssd1
+ vccd1 vccd1 _03424_ sky130_fd_sc_hd__o2111a_1
XANTENNA__08409__A1 net347 vssd1 vssd1 vccd1 vccd1 sky130_fd_sc_hd__diode_2
X_07337_ cell2.CB_0.config_dataB\[22\] cell2.CB_0.config_dataB\[23\] vssd1 vssd1 vccd1
+ vccd1 _02394_ sky130_fd_sc_hd__nand2_1
XFILLER_137_747 vccd1 vssd1 vccd1 vssd1 sky130_ef_sc_hd__decap_40_12
XANTENNA_fanout317_X net317 vssd1 vssd1 vccd1 vccd1 sky130_fd_sc_hd__diode_2
XFILLER_109_449 vccd1 vssd1 vccd1 vssd1 sky130_ef_sc_hd__decap_40_12
XANTENNA_fanout898_A net908 vssd1 vssd1 vccd1 vccd1 sky130_fd_sc_hd__diode_2
X_07268_ cell0.CB_1.config_dataB\[22\] cell0.CB_1.config_dataB\[23\] vssd1 vssd1 vccd1
+ vccd1 _02326_ sky130_fd_sc_hd__nand2_4
X_09007_ net483 _03817_ _04036_ net481 vssd1 vssd1 vccd1 vccd1 _04037_ sky130_fd_sc_hd__o211a_1
XFILLER_3_727 vssd1 vssd1 vccd1 vccd1 sky130_fd_sc_hd__fill_1
X_07199_ net338 _01933_ net357 vssd1 vssd1 vccd1 vccd1 _02259_ sky130_fd_sc_hd__or3_1
XTAP_TAPCELL_ROW_57_1163 vssd1 vccd1 sky130_fd_sc_hd__tapvpwrvgnd_1
XFILLER_104_143 vssd1 vssd1 vccd1 vccd1 sky130_fd_sc_hd__fill_1
XANTENNA__07396__A1 net314 vssd1 vssd1 vccd1 vccd1 sky130_fd_sc_hd__diode_2
XANTENNA__08593__A0 net29 vssd1 vssd1 vccd1 vccd1 sky130_fd_sc_hd__diode_2
XFILLER_116_53 vssd1 vssd1 vccd1 vccd1 sky130_fd_sc_hd__fill_4
Xfanout530 net531 vssd1 vssd1 vccd1 vccd1 net530 sky130_fd_sc_hd__buf_2
Xfanout541 cell0.CB_1.config_dataA\[6\] vssd1 vssd1 vccd1 vccd1 net541 sky130_fd_sc_hd__clkbuf_2
X_09909_ _04913_ _04914_ _04791_ vssd1 vssd1 vccd1 vccd1 _04915_ sky130_fd_sc_hd__mux2_1
Xfanout552 _01495_ vssd1 vssd1 vccd1 vccd1 net552 sky130_fd_sc_hd__clkbuf_2
Xfanout574 net575 vssd1 vssd1 vccd1 vccd1 net574 sky130_fd_sc_hd__clkbuf_2
XTAP_TAPCELL_ROW_70_1363 vssd1 vccd1 sky130_fd_sc_hd__tapvpwrvgnd_1
XTAP_TAPCELL_ROW_70_1352 vssd1 vccd1 sky130_fd_sc_hd__tapvpwrvgnd_1
Xfanout563 net602 vssd1 vssd1 vccd1 vccd1 net563 sky130_fd_sc_hd__dlymetal6s2s_1
X_12920_ net1392 cell3.LE_1A.config_data\[7\] net942 vssd1 vssd1 vccd1 vccd1 _01349_
+ sky130_fd_sc_hd__mux2_1
Xfanout596 net601 vssd1 vssd1 vccd1 vccd1 net596 sky130_fd_sc_hd__clkbuf_4
XANTENNA__09542__C1 _04557_ vssd1 vssd1 vccd1 vccd1 sky130_fd_sc_hd__diode_2
Xfanout585 net592 vssd1 vssd1 vccd1 vccd1 net585 sky130_fd_sc_hd__clkbuf_4
XANTENNA_input131_A le_en vssd1 vssd1 vccd1 vccd1 sky130_fd_sc_hd__diode_2
XANTENNA__07699__A2 _02609_ vssd1 vssd1 vccd1 vccd1 sky130_fd_sc_hd__diode_2
XFILLER_132_41 vccd1 vssd1 vccd1 vssd1 sky130_ef_sc_hd__decap_40_12
X_12851_ cell2.SB0.route_sel\[93\] cell2.SB0.route_sel\[92\] net795 vssd1 vssd1 vccd1
+ vccd1 _01280_ sky130_fd_sc_hd__mux2_1
X_11802_ net1027 net1154 net902 vssd1 vssd1 vccd1 vccd1 _00239_ sky130_fd_sc_hd__mux2_1
XANTENNA__09845__A0 bus3_2\[0\] vssd1 vssd1 vccd1 vccd1 sky130_fd_sc_hd__diode_2
X_12782_ cell2.SB0.route_sel\[24\] cell2.SB0.route_sel\[23\] net816 vssd1 vssd1 vccd1
+ vccd1 _01211_ sky130_fd_sc_hd__mux2_1
X_11733_ net1063 net993 net772 vssd1 vssd1 vccd1 vccd1 _00171_ sky130_fd_sc_hd__mux2_1
XANTENNA__07879__B _02897_ vssd1 vssd1 vccd1 vccd1 sky130_fd_sc_hd__diode_2
X_14452_ clknet_leaf_60_clk _01424_ net738 vssd1 vssd1 vccd1 vccd1 cell3.LEI0.config_data\[17\]
+ sky130_fd_sc_hd__dfrtp_1
X_11664_ net503 cell0.CB_1.config_dataB\[9\] net783 vssd1 vssd1 vccd1 vccd1 _00105_
+ sky130_fd_sc_hd__mux2_1
XANTENNA__10207__A1 net64 vssd1 vssd1 vccd1 vccd1 sky130_fd_sc_hd__diode_2
X_10615_ net21 net22 net24 net25 net398 net397 vssd1 vssd1 vccd1 vccd1 _05573_ sky130_fd_sc_hd__mux4_1
X_13403_ clknet_leaf_134_clk _00375_ net553 vssd1 vssd1 vccd1 vccd1 cell0.SB0.route_sel\[44\]
+ sky130_fd_sc_hd__dfstp_1
XANTENNA__10873__X _05829_ vssd1 vssd1 vccd1 vccd1 sky130_fd_sc_hd__diode_2
X_14383_ clknet_leaf_66_clk net979 net743 vssd1 vssd1 vccd1 vccd1 cell3.LE_1A.config_data\[14\]
+ sky130_fd_sc_hd__dfrtp_1
XANTENNA__10758__A2 _04362_ vssd1 vssd1 vccd1 vccd1 sky130_fd_sc_hd__diode_2
X_11595_ cell0.CB_1.config_dataA\[16\] net537 net789 vssd1 vssd1 vccd1 vccd1 _00036_
+ sky130_fd_sc_hd__mux2_1
XANTENNA_output183_A net183 vssd1 vssd1 vccd1 vccd1 sky130_fd_sc_hd__diode_2
X_10546_ _05503_ _04371_ vssd1 vssd1 vccd1 vccd1 _05504_ sky130_fd_sc_hd__nand2b_2
X_13334_ clknet_leaf_89_clk _00306_ net688 vssd1 vssd1 vccd1 vccd1 cell1.CB_0.config_dataA\[0\]
+ sky130_fd_sc_hd__dfstp_1
XFILLER_115_419 vssd1 vssd1 vccd1 vccd1 sky130_fd_sc_hd__fill_1
X_10477_ clknet_leaf_118_clk cell0.LE_1A.edge_mode vssd1 vssd1 vccd1 vccd1 cell0.LE_1A.sel_clk
+ sky130_fd_sc_hd__xnor2_2
X_13265_ clknet_leaf_92_clk _00237_ net693 vssd1 vssd1 vccd1 vccd1 cell1.LE_1B.config_data\[1\]
+ sky130_fd_sc_hd__dfrtp_1
XFILLER_6_587 vssd1 vssd1 vccd1 vccd1 sky130_fd_sc_hd__fill_1
X_12216_ cell2.CB_0.config_dataB\[4\] cell2.CB_0.config_dataB\[3\] net825 vssd1 vssd1
+ vccd1 vccd1 _00649_ sky130_fd_sc_hd__mux2_1
XFILLER_6_598 vccd1 vssd1 vccd1 vssd1 sky130_ef_sc_hd__decap_40_12
X_13196_ clknet_leaf_23_clk _00168_ net603 vssd1 vssd1 vccd1 vccd1 cell0.LE_0A.config_data\[3\]
+ sky130_fd_sc_hd__dfrtp_1
X_12147_ net1380 net1364 net895 vssd1 vssd1 vccd1 vccd1 _00580_ sky130_fd_sc_hd__mux2_1
XANTENNA__09174__X _04202_ vssd1 vssd1 vccd1 vccd1 sky130_fd_sc_hd__diode_2
XFILLER_2_793 vccd1 vssd1 vccd1 vssd1 sky130_ef_sc_hd__decap_40_12
X_12078_ cell1.LE_0B.config_data\[6\] net1010 net938 vssd1 vssd1 vccd1 vccd1 _00513_
+ sky130_fd_sc_hd__mux2_1
XANTENNA__09128__A2 net336 vssd1 vssd1 vccd1 vccd1 sky130_fd_sc_hd__diode_2
XFILLER_1_281 vccd1 vssd1 vccd1 vssd1 sky130_ef_sc_hd__decap_40_12
X_11029_ net45 _05963_ _05965_ net46 cell3.CB_0.config_dataA\[13\] vssd1 vssd1 vccd1
+ vccd1 _05983_ sky130_fd_sc_hd__a221o_1
XTAP_TAPCELL_ROW_88_1624 vssd1 vccd1 sky130_fd_sc_hd__tapvpwrvgnd_1
XFILLER_77_572 vssd1 vssd1 vccd1 vccd1 sky130_fd_sc_hd__fill_1
XFILLER_2_65 vccd1 vssd1 vccd1 vssd1 sky130_ef_sc_hd__decap_40_12
XFILLER_92_531 vssd1 vssd1 vccd1 vccd1 sky130_fd_sc_hd__fill_1
XTAP_TAPCELL_ROW_88_1635 vssd1 vccd1 sky130_fd_sc_hd__tapvpwrvgnd_1
XANTENNA__08351__A3 bus1_0\[15\] vssd1 vssd1 vccd1 vccd1 sky130_fd_sc_hd__diode_2
XFILLER_92_564 vssd1 vssd1 vccd1 vccd1 sky130_fd_sc_hd__fill_1
X_06570_ cell2.SB0.route_sel\[101\] vssd1 vssd1 vccd1 vccd1 _01640_ sky130_fd_sc_hd__inv_2
XFILLER_80_759 vssd1 vssd1 vccd1 vccd1 sky130_fd_sc_hd__fill_1
XANTENNA__09621__Y _04637_ vssd1 vssd1 vccd1 vccd1 sky130_fd_sc_hd__diode_2
XANTENNA__08639__A1 net12 vssd1 vssd1 vccd1 vccd1 sky130_fd_sc_hd__diode_2
XANTENNA__06974__A _02037_ vssd1 vssd1 vccd1 vccd1 sky130_fd_sc_hd__diode_2
XFILLER_17_193 vssd1 vssd1 vccd1 vccd1 sky130_fd_sc_hd__fill_1
XANTENNA__07141__Y _02203_ vssd1 vssd1 vccd1 vccd1 sky130_fd_sc_hd__diode_2
X_08240_ cell0.CB_1.config_dataA\[17\] _03279_ vssd1 vssd1 vccd1 vccd1 _03280_ sky130_fd_sc_hd__nand2b_1
XANTENNA_37 cell1.LE_1A.config_data\[16\] vssd1 vssd1 vccd1 vccd1 sky130_fd_sc_hd__diode_2
XANTENNA__07862__A2 _02902_ vssd1 vssd1 vccd1 vccd1 sky130_fd_sc_hd__diode_2
X_08171_ net543 _02761_ vssd1 vssd1 vccd1 vccd1 _03211_ sky130_fd_sc_hd__nand2_1
XANTENNA_26 net164 vssd1 vssd1 vccd1 vccd1 sky130_fd_sc_hd__diode_2
XANTENNA_15 cell1.LE_1B.config_data\[11\] vssd1 vssd1 vccd1 vccd1 sky130_fd_sc_hd__diode_2
XANTENNA_48 net32 vssd1 vssd1 vccd1 vccd1 sky130_fd_sc_hd__diode_2
XANTENNA__10749__A2 _05475_ vssd1 vssd1 vccd1 vccd1 sky130_fd_sc_hd__diode_2
X_07122_ cell2.SB0.route_sel\[72\] cell2.SB0.route_sel\[73\] _02184_ vssd1 vssd1 vccd1
+ vccd1 _02185_ sky130_fd_sc_hd__a21oi_1
XANTENNA__09064__A1 bus3_1\[9\] vssd1 vssd1 vccd1 vccd1 sky130_fd_sc_hd__diode_2
XTAP_TAPCELL_ROW_99_1797 vssd1 vccd1 sky130_fd_sc_hd__tapvpwrvgnd_1
XTAP_TAPCELL_ROW_99_1786 vssd1 vccd1 sky130_fd_sc_hd__tapvpwrvgnd_1
XANTENNA__09349__X bus3_1\[3\] vssd1 vssd1 vccd1 vccd1 sky130_fd_sc_hd__diode_2
X_07053_ cell0.SB0.route_sel\[78\] cell0.SB0.route_sel\[79\] vssd1 vssd1 vccd1 vccd1
+ _02117_ sky130_fd_sc_hd__nand2_1
Xoutput166 net166 vssd1 vssd1 vccd1 vccd1 CBnorth_out[0] sky130_fd_sc_hd__buf_2
Xoutput177 net177 vssd1 vssd1 vccd1 vccd1 CBnorth_out[1] sky130_fd_sc_hd__buf_2
XFILLER_99_163 vssd1 vssd1 vccd1 vccd1 sky130_fd_sc_hd__fill_4
XFILLER_88_826 vssd1 vssd1 vccd1 vccd1 sky130_fd_sc_hd__fill_1
Xoutput155 net155 vssd1 vssd1 vccd1 vccd1 CBeast_out[29] sky130_fd_sc_hd__buf_2
Xoutput144 net144 vssd1 vssd1 vccd1 vccd1 CBeast_out[19] sky130_fd_sc_hd__buf_2
XANTENNA__07378__A1 net322 vssd1 vssd1 vccd1 vccd1 sky130_fd_sc_hd__diode_2
XFILLER_142_794 vssd1 vssd1 vccd1 vccd1 sky130_fd_sc_hd__fill_4
Xoutput188 net188 vssd1 vssd1 vccd1 vccd1 CBnorth_out[2] sky130_fd_sc_hd__buf_2
XFILLER_102_625 vssd1 vssd1 vccd1 vccd1 sky130_fd_sc_hd__fill_1
Xoutput199 net199 vssd1 vssd1 vccd1 vccd1 SBsouth_out[10] sky130_fd_sc_hd__buf_2
XTAP_TAPCELL_ROW_110_1964 vssd1 vccd1 sky130_fd_sc_hd__tapvpwrvgnd_1
XTAP_TAPCELL_ROW_110_1953 vssd1 vccd1 sky130_fd_sc_hd__tapvpwrvgnd_1
XFILLER_102_658 vssd1 vssd1 vccd1 vccd1 sky130_fd_sc_hd__fill_1
XFILLER_87_347 vssd1 vssd1 vccd1 vccd1 sky130_fd_sc_hd__fill_1
XFILLER_68_550 vssd1 vssd1 vccd1 vccd1 sky130_fd_sc_hd__fill_1
XANTENNA__09119__A2 bus3_1\[14\] vssd1 vssd1 vccd1 vccd1 sky130_fd_sc_hd__diode_2
X_07955_ _02997_ _02998_ vssd1 vssd1 vccd1 vccd1 _02999_ sky130_fd_sc_hd__or2_1
XANTENNA__08878__A1 bus3_1\[13\] vssd1 vssd1 vccd1 vccd1 sky130_fd_sc_hd__diode_2
XTAP_TAPCELL_ROW_52_1093 vssd1 vccd1 sky130_fd_sc_hd__tapvpwrvgnd_1
XTAP_TAPCELL_ROW_52_1082 vssd1 vccd1 sky130_fd_sc_hd__tapvpwrvgnd_1
X_06906_ _01889_ _01972_ vssd1 vssd1 vccd1 vccd1 _01974_ sky130_fd_sc_hd__nand2_1
X_09625_ _02402_ _04640_ vssd1 vssd1 vccd1 vccd1 _04641_ sky130_fd_sc_hd__and2_2
X_07886_ cell0.CB_0.config_dataA\[1\] _02928_ _02929_ vssd1 vssd1 vccd1 vccd1 _02930_
+ sky130_fd_sc_hd__a21o_1
XFILLER_28_458 vssd1 vssd1 vccd1 vccd1 sky130_fd_sc_hd__fill_1
XANTENNA_fanout646_A net649 vssd1 vssd1 vccd1 vccd1 sky130_fd_sc_hd__diode_2
X_06837_ cell2.CB_1.config_dataB\[23\] cell2.CB_1.config_dataB\[22\] vssd1 vssd1 vccd1
+ vccd1 _01906_ sky130_fd_sc_hd__nand2b_2
XANTENNA__10958__X _05912_ vssd1 vssd1 vccd1 vccd1 sky130_fd_sc_hd__diode_2
X_09556_ net910 _04574_ vssd1 vssd1 vccd1 vccd1 _04575_ sky130_fd_sc_hd__nor2_1
XFILLER_70_236 vssd1 vssd1 vccd1 vccd1 sky130_fd_sc_hd__fill_4
X_06768_ cell1.CB_1.config_dataB\[23\] cell1.CB_1.config_dataB\[22\] vssd1 vssd1 vccd1
+ vccd1 _01838_ sky130_fd_sc_hd__nand2b_2
X_06699_ cell2.CB_0.config_dataA\[13\] vssd1 vssd1 vccd1 vccd1 _01769_ sky130_fd_sc_hd__inv_2
X_09487_ _04356_ _04406_ vssd1 vssd1 vccd1 vccd1 _04508_ sky130_fd_sc_hd__or2_1
XFILLER_36_491 vssd1 vssd1 vccd1 vccd1 sky130_fd_sc_hd__fill_2
X_08507_ _03520_ _03542_ cell1.CB_1.config_dataA\[4\] vssd1 vssd1 vccd1 vccd1 _03543_
+ sky130_fd_sc_hd__a21oi_1
X_08438_ cell1.CB_1.config_dataA\[1\] net498 vssd1 vssd1 vccd1 vccd1 _03474_ sky130_fd_sc_hd__and2b_1
XANTENNA_fanout601_X net601 vssd1 vssd1 vccd1 vccd1 sky130_fd_sc_hd__diode_2
XANTENNA__07211__C _02032_ vssd1 vssd1 vccd1 vccd1 sky130_fd_sc_hd__diode_2
X_08369_ cell0.CB_1.config_dataB\[12\] _03402_ _03403_ _03406_ vssd1 vssd1 vccd1 vccd1
+ _03407_ sky130_fd_sc_hd__o22a_1
X_10400_ net424 net423 _05139_ _05398_ cell2.CB_0.config_dataB\[17\] vssd1 vssd1 vccd1
+ vccd1 _05399_ sky130_fd_sc_hd__o311a_1
XPHY_EDGE_ROW_12_Left_155 vssd1 vssd1 vccd1 vccd1 sky130_fd_sc_hd__decap_3
X_11380_ _01456_ cell0.SB0.route_sel\[49\] _01460_ cell0.SB0.route_sel\[50\] _06253_
+ vssd1 vssd1 vccd1 vccd1 _06254_ sky130_fd_sc_hd__o221a_1
X_10331_ net435 net433 _05114_ _05329_ cell2.CB_0.config_dataB\[2\] vssd1 vssd1 vccd1
+ vccd1 _05330_ sky130_fd_sc_hd__o311a_1
X_10262_ cell2.LEI0.config_data\[38\] _05262_ vssd1 vssd1 vccd1 vccd1 _05263_ sky130_fd_sc_hd__nor2_1
X_13050_ clknet_leaf_126_clk _00022_ net582 vssd1 vssd1 vccd1 vccd1 cell0.CB_1.config_dataA\[2\]
+ sky130_fd_sc_hd__dfstp_2
XFILLER_11_85 vssd1 vssd1 vccd1 vccd1 sky130_fd_sc_hd__fill_2
XANTENNA__11165__A2 net56 vssd1 vssd1 vccd1 vccd1 sky130_fd_sc_hd__diode_2
X_12001_ cell0.SB0.route_sel\[107\] cell0.SB0.route_sel\[106\] net770 vssd1 vssd1
+ vccd1 vccd1 _00438_ sky130_fd_sc_hd__mux2_1
XFILLER_2_3 vccd1 vssd1 vccd1 vssd1 sky130_ef_sc_hd__decap_40_12
XANTENNA__10373__A0 net36 vssd1 vssd1 vccd1 vccd1 sky130_fd_sc_hd__diode_2
XFILLER_133_783 vssd1 vssd1 vccd1 vccd1 sky130_fd_sc_hd__fill_1
X_10193_ net312 net308 net318 net304 cell2.LEI0.config_data\[0\] cell2.LEI0.config_data\[1\]
+ vssd1 vssd1 vccd1 vccd1 _05194_ sky130_fd_sc_hd__mux4_1
XANTENNA__10912__A2 net51 vssd1 vssd1 vccd1 vccd1 sky130_fd_sc_hd__diode_2
XANTENNA__09435__A net46 vssd1 vssd1 vccd1 vccd1 sky130_fd_sc_hd__diode_2
XANTENNA__08318__A0 bus1_0\[6\] vssd1 vssd1 vccd1 vccd1 sky130_fd_sc_hd__diode_2
Xfanout382 cell3.CB_0.config_dataB\[16\] vssd1 vssd1 vccd1 vccd1 net382 sky130_fd_sc_hd__buf_2
X_13952_ clknet_leaf_42_clk _00924_ net633 vssd1 vssd1 vccd1 vccd1 cell2.LEI0.config_data\[9\]
+ sky130_fd_sc_hd__dfrtp_1
Xfanout393 cell3.CB_1.config_dataA\[10\] vssd1 vssd1 vccd1 vccd1 net393 sky130_fd_sc_hd__clkbuf_4
Xfanout371 cell3.CB_1.config_dataB\[0\] vssd1 vssd1 vccd1 vccd1 net371 sky130_fd_sc_hd__buf_2
XFILLER_47_701 vssd1 vssd1 vccd1 vccd1 sky130_fd_sc_hd__fill_1
XTAP_TAPCELL_ROW_6_395 vssd1 vccd1 sky130_fd_sc_hd__tapvpwrvgnd_1
Xfanout360 _01852_ vssd1 vssd1 vccd1 vccd1 net360 sky130_fd_sc_hd__clkbuf_4
X_12903_ cell3.CB_1.config_dataB\[17\] net364 net940 vssd1 vssd1 vccd1 vccd1 _01332_
+ sky130_fd_sc_hd__mux2_1
XPHY_EDGE_ROW_21_Left_164 vssd1 vssd1 vccd1 vccd1 sky130_fd_sc_hd__decap_3
X_13883_ clknet_leaf_53_clk _00855_ net715 vssd1 vssd1 vccd1 vccd1 cell2.LE_1A.config_data\[6\]
+ sky130_fd_sc_hd__dfrtp_1
XANTENNA__08333__A3 bus1_0\[15\] vssd1 vssd1 vccd1 vccd1 sky130_fd_sc_hd__diode_2
X_12834_ cell2.SB0.route_sel\[76\] cell2.SB0.route_sel\[75\] net778 vssd1 vssd1 vccd1
+ vccd1 _01263_ sky130_fd_sc_hd__mux2_1
XTAP_TAPCELL_ROW_83_1554 vssd1 vccd1 sky130_fd_sc_hd__tapvpwrvgnd_1
X_12765_ cell2.SB0.route_sel\[7\] cell2.SB0.route_sel\[6\] net829 vssd1 vssd1 vccd1
+ vccd1 _01194_ sky130_fd_sc_hd__mux2_1
XTAP_TAPCELL_ROW_45_979 vssd1 vccd1 sky130_fd_sc_hd__tapvpwrvgnd_1
XANTENNA__07242__X _02301_ vssd1 vssd1 vccd1 vccd1 sky130_fd_sc_hd__diode_2
X_11716_ net1254 net1185 net805 vssd1 vssd1 vccd1 vccd1 _00155_ sky130_fd_sc_hd__mux2_1
X_12696_ cell3.CB_1.config_dataA\[13\] cell3.CB_1.config_dataA\[12\] net941 vssd1
+ vssd1 vccd1 vccd1 _01125_ sky130_fd_sc_hd__mux2_1
XTAP_TAPCELL_ROW_25_681 vssd1 vccd1 sky130_fd_sc_hd__tapvpwrvgnd_1
XFILLER_30_645 vssd1 vssd1 vccd1 vccd1 sky130_fd_sc_hd__fill_1
Xinput13 CBeast_in[20] vssd1 vssd1 vccd1 vccd1 net13 sky130_fd_sc_hd__clkbuf_4
X_14435_ clknet_leaf_67_clk _01407_ net737 vssd1 vssd1 vccd1 vccd1 cell3.LEI0.config_data\[0\]
+ sky130_fd_sc_hd__dfrtp_1
XANTENNA__09046__A1 _03849_ vssd1 vssd1 vccd1 vccd1 sky130_fd_sc_hd__diode_2
XANTENNA__09046__B2 _03853_ vssd1 vssd1 vccd1 vccd1 sky130_fd_sc_hd__diode_2
X_11647_ cell0.CB_0.config_dataA\[18\] cell0.CB_0.config_dataA\[17\] net770 vssd1
+ vssd1 vccd1 vccd1 _00088_ sky130_fd_sc_hd__mux2_1
XPHY_EDGE_ROW_30_Left_173 vssd1 vssd1 vccd1 vccd1 sky130_fd_sc_hd__decap_3
Xinput35 CBnorth_in[11] vssd1 vssd1 vccd1 vccd1 net35 sky130_fd_sc_hd__buf_2
Xinput46 CBnorth_in[21] vssd1 vssd1 vccd1 vccd1 net46 sky130_fd_sc_hd__clkbuf_4
Xinput24 CBeast_in[30] vssd1 vssd1 vccd1 vccd1 net24 sky130_fd_sc_hd__clkbuf_4
X_14366_ clknet_leaf_74_clk _01338_ net729 vssd1 vssd1 vccd1 vccd1 cell3.CB_1.config_dataB\[23\]
+ sky130_fd_sc_hd__dfstp_1
X_11578_ cell0.LE_1B.reset_mode net1512 net803 vssd1 vssd1 vccd1 vccd1 _00019_ sky130_fd_sc_hd__mux2_1
XFILLER_7_830 vssd1 vssd1 vccd1 vccd1 sky130_fd_sc_hd__fill_1
Xinput57 CBnorth_in[31] vssd1 vssd1 vccd1 vccd1 net57 sky130_fd_sc_hd__buf_2
XANTENNA__10600__A1 net279 vssd1 vssd1 vccd1 vccd1 sky130_fd_sc_hd__diode_2
XTAP_TAPCELL_ROW_114_2020 vssd1 vccd1 sky130_fd_sc_hd__tapvpwrvgnd_1
X_10529_ cell3.SB0.route_sel\[32\] _01698_ cell3.SB0.route_sel\[36\] cell3.SB0.route_sel\[37\]
+ vssd1 vssd1 vccd1 vccd1 _05487_ sky130_fd_sc_hd__o22a_1
X_13317_ clknet_leaf_88_clk _00289_ net688 vssd1 vssd1 vccd1 vccd1 cell1.CB_0.config_dataB\[8\]
+ sky130_fd_sc_hd__dfstp_1
Xinput68 SBsouth_in[12] vssd1 vssd1 vccd1 vccd1 net68 sky130_fd_sc_hd__clkbuf_2
Xinput79 SBsouth_in[22] vssd1 vssd1 vccd1 vccd1 net79 sky130_fd_sc_hd__buf_1
X_14297_ clknet_leaf_13_clk _01269_ net590 vssd1 vssd1 vccd1 vccd1 cell2.SB0.route_sel\[82\]
+ sky130_fd_sc_hd__dfstp_1
X_13248_ clknet_leaf_121_clk net1465 net594 vssd1 vssd1 vccd1 vccd1 cell0.LEI0.config_data\[33\]
+ sky130_fd_sc_hd__dfrtp_1
XFILLER_111_411 vssd1 vssd1 vccd1 vccd1 sky130_fd_sc_hd__fill_1
XFILLER_96_111 vssd1 vssd1 vccd1 vccd1 sky130_fd_sc_hd__fill_1
X_13179_ clknet_leaf_14_clk _00151_ net599 vssd1 vssd1 vccd1 vccd1 cell0.LE_0B.config_data\[8\]
+ sky130_fd_sc_hd__dfrtp_1
XFILLER_35_3 vccd1 vssd1 vccd1 vssd1 sky130_ef_sc_hd__decap_40_12
XANTENNA__07417__X bus2_0\[13\] vssd1 vssd1 vccd1 vccd1 sky130_fd_sc_hd__diode_2
X_07740_ net321 _01838_ _02046_ _02050_ _01842_ vssd1 vssd1 vccd1 vccd1 _02786_ sky130_fd_sc_hd__o32a_1
XANTENNA_clkbuf_leaf_74_clk_A clknet_4_14_0_clk vssd1 vssd1 vccd1 vccd1 sky130_fd_sc_hd__diode_2
XANTENNA__10667__A1 _04354_ vssd1 vssd1 vccd1 vccd1 sky130_fd_sc_hd__diode_2
X_07671_ net265 _02718_ vssd1 vssd1 vccd1 vccd1 _02719_ sky130_fd_sc_hd__nand2_4
XTAP_TAPCELL_ROW_125_2182 vssd1 vccd1 sky130_fd_sc_hd__tapvpwrvgnd_1
XANTENNA__09809__A0 bus3_2\[6\] vssd1 vssd1 vccd1 vccd1 sky130_fd_sc_hd__diode_2
X_09410_ cell2.SB0.route_sel\[44\] cell2.SB0.route_sel\[45\] _02839_ _04432_ _02835_
+ vssd1 vssd1 vccd1 vccd1 _04433_ sky130_fd_sc_hd__a221o_1
XFILLER_80_523 vssd1 vssd1 vccd1 vccd1 sky130_fd_sc_hd__fill_1
X_06622_ cell3.SB0.route_sel\[23\] vssd1 vssd1 vccd1 vccd1 _01692_ sky130_fd_sc_hd__inv_2
XANTENNA__11814__S net905 vssd1 vssd1 vccd1 vccd1 sky130_fd_sc_hd__diode_2
X_09341_ cell3.CB_0.config_dataA\[24\] cell3.CB_0.config_dataA\[21\] cell3.CB_0.config_dataA\[20\]
+ vssd1 vssd1 vccd1 vccd1 _04366_ sky130_fd_sc_hd__nand3b_2
X_06553_ cell2.SB0.route_sel\[69\] vssd1 vssd1 vccd1 vccd1 _01623_ sky130_fd_sc_hd__inv_2
XANTENNA_clkbuf_leaf_89_clk_A clknet_4_11_0_clk vssd1 vssd1 vccd1 vccd1 sky130_fd_sc_hd__diode_2
XFILLER_33_461 vssd1 vssd1 vccd1 vccd1 sky130_fd_sc_hd__fill_1
XFILLER_139_809 vccd1 vssd1 vccd1 vssd1 sky130_ef_sc_hd__decap_40_12
X_09272_ net263 _04297_ vssd1 vssd1 vccd1 vccd1 _04298_ sky130_fd_sc_hd__nand2_4
X_06484_ cell1.SB0.route_sel\[126\] vssd1 vssd1 vccd1 vccd1 _01554_ sky130_fd_sc_hd__inv_2
XANTENNA_clkbuf_leaf_132_clk_A clknet_4_0_0_clk vssd1 vssd1 vccd1 vccd1 sky130_fd_sc_hd__diode_2
XFILLER_32_29 vccd1 vssd1 vccd1 vssd1 sky130_ef_sc_hd__decap_40_12
X_08223_ cell0.CB_1.config_dataA\[14\] _03233_ _03245_ _03260_ _03262_ vssd1 vssd1
+ vccd1 vccd1 _03263_ sky130_fd_sc_hd__a311o_1
XANTENNA_clkbuf_leaf_12_clk_A clknet_4_3_0_clk vssd1 vssd1 vccd1 vccd1 sky130_fd_sc_hd__diode_2
XANTENNA__11402__X net261 vssd1 vssd1 vccd1 vccd1 sky130_fd_sc_hd__diode_2
X_08154_ _03183_ _03193_ cell0.CB_1.config_dataA\[4\] _03179_ vssd1 vssd1 vccd1 vccd1
+ _03194_ sky130_fd_sc_hd__a211o_1
X_07105_ net314 _02163_ _02166_ _02167_ vssd1 vssd1 vccd1 vccd1 _02168_ sky130_fd_sc_hd__a22oi_2
X_08085_ _02887_ _03125_ _03126_ _02890_ _01561_ vssd1 vssd1 vccd1 vccd1 _03127_ sky130_fd_sc_hd__a221o_1
X_07036_ _02099_ _02100_ vssd1 vssd1 vccd1 vccd1 _02101_ sky130_fd_sc_hd__nor2_1
XFILLER_106_9 vccd1 vssd1 vccd1 vssd1 sky130_ef_sc_hd__decap_40_12
XTAP_TAPCELL_ROW_54_1111 vssd1 vccd1 sky130_fd_sc_hd__tapvpwrvgnd_1
XANTENNA_fanout596_A net601 vssd1 vssd1 vccd1 vccd1 sky130_fd_sc_hd__diode_2
XANTENNA_clkbuf_leaf_27_clk_A clknet_4_5_0_clk vssd1 vssd1 vccd1 vccd1 sky130_fd_sc_hd__diode_2
XTAP_TAPCELL_ROW_54_1122 vssd1 vccd1 sky130_fd_sc_hd__tapvpwrvgnd_1
XANTENNA__09760__A2 _04724_ vssd1 vssd1 vccd1 vccd1 sky130_fd_sc_hd__diode_2
XFILLER_88_678 vssd1 vssd1 vccd1 vccd1 sky130_fd_sc_hd__fill_1
XANTENNA__09255__A net301 vssd1 vssd1 vccd1 vccd1 sky130_fd_sc_hd__diode_2
XANTENNA__07220__B1 _02260_ vssd1 vssd1 vccd1 vccd1 sky130_fd_sc_hd__diode_2
Xclkbuf_4_5_0_clk clknet_0_clk vssd1 vssd1 vccd1 vccd1 clknet_4_5_0_clk sky130_fd_sc_hd__clkbuf_8
XFILLER_102_477 vssd1 vssd1 vccd1 vccd1 sky130_fd_sc_hd__fill_1
XFILLER_75_317 vssd1 vssd1 vccd1 vccd1 sky130_fd_sc_hd__fill_2
X_08987_ cell1.LE_0A.dff0_out cell1.LE_0A.dff1_out cell1.LE_0A.reset_val vssd1 vssd1
+ vccd1 vccd1 cell1.LE_0A.dff_out sky130_fd_sc_hd__mux2_1
XANTENNA_fanout763_A net768 vssd1 vssd1 vccd1 vccd1 sky130_fd_sc_hd__diode_2
X_07938_ net513 _01913_ _02981_ net511 vssd1 vssd1 vccd1 vccd1 _02982_ sky130_fd_sc_hd__o211a_1
XTAP_TAPCELL_ROW_3_354 vssd1 vccd1 sky130_fd_sc_hd__tapvpwrvgnd_1
XANTENNA_fanout930_A net933 vssd1 vssd1 vccd1 vccd1 sky130_fd_sc_hd__diode_2
XANTENNA_fanout551_X net551 vssd1 vssd1 vccd1 vccd1 sky130_fd_sc_hd__diode_2
X_07869_ _02908_ _02911_ _02912_ _01571_ _02907_ vssd1 vssd1 vccd1 vccd1 _02913_ sky130_fd_sc_hd__a221o_1
XANTENNA__08315__A3 bus1_0\[3\] vssd1 vssd1 vccd1 vccd1 sky130_fd_sc_hd__diode_2
XANTENNA_fanout649_X net649 vssd1 vssd1 vccd1 vccd1 sky130_fd_sc_hd__diode_2
X_10880_ cell3.LE_1B.config_data\[14\] cell3.LE_1B.config_data\[15\] _05722_ vssd1
+ vssd1 vccd1 vccd1 _05836_ sky130_fd_sc_hd__mux2_1
X_09608_ _04366_ _04545_ vssd1 vssd1 vccd1 vccd1 _04625_ sky130_fd_sc_hd__nor2_1
XFILLER_43_225 vssd1 vssd1 vccd1 vccd1 sky130_fd_sc_hd__fill_1
X_09539_ cell3.SB0.route_sel\[78\] cell3.SB0.route_sel\[79\] net314 _02163_ _04557_
+ vssd1 vssd1 vccd1 vccd1 _04558_ sky130_fd_sc_hd__a221o_1
XTAP_TAPCELL_ROW_42_938 vssd1 vccd1 sky130_fd_sc_hd__tapvpwrvgnd_1
X_12550_ cell3.SB0.route_sel\[15\] cell3.SB0.route_sel\[14\] net919 vssd1 vssd1 vccd1
+ vccd1 _00979_ sky130_fd_sc_hd__mux2_1
XTAP_TAPCELL_ROW_65_1284 vssd1 vccd1 sky130_fd_sc_hd__tapvpwrvgnd_1
XFILLER_11_111 vssd1 vssd1 vccd1 vccd1 sky130_fd_sc_hd__fill_1
XFILLER_12_645 vccd1 vssd1 vccd1 vssd1 sky130_ef_sc_hd__decap_40_12
X_12481_ cell2.LE_0A.reset_val cell2.LE_0A.edge_mode net840 vssd1 vssd1 vccd1 vccd1
+ _00911_ sky130_fd_sc_hd__mux2_1
X_11501_ _04396_ _06334_ vssd1 vssd1 vccd1 vccd1 net242 sky130_fd_sc_hd__and2_1
XTAP_TAPCELL_ROW_22_640 vssd1 vccd1 sky130_fd_sc_hd__tapvpwrvgnd_1
X_14220_ clknet_leaf_12_clk _01192_ net588 vssd1 vssd1 vccd1 vccd1 cell2.SB0.route_sel\[5\]
+ sky130_fd_sc_hd__dfstp_1
X_11432_ _06288_ _02491_ vssd1 vssd1 vccd1 vccd1 net235 sky130_fd_sc_hd__and2b_2
XFILLER_7_137 vssd1 vssd1 vccd1 vccd1 sky130_fd_sc_hd__fill_1
XANTENNA__10189__A3 net39 vssd1 vssd1 vccd1 vccd1 sky130_fd_sc_hd__diode_2
X_14151_ clknet_leaf_70_clk _01123_ net730 vssd1 vssd1 vccd1 vccd1 cell3.CB_1.config_dataA\[11\]
+ sky130_fd_sc_hd__dfstp_1
XANTENNA__08787__B1 cell1.SB0.config_data_out vssd1 vssd1 vccd1 vccd1 sky130_fd_sc_hd__diode_2
X_11363_ clknet_leaf_61_clk cell3.LE_0B.edge_mode vssd1 vssd1 vccd1 vccd1 cell3.LE_0B.sel_clk
+ sky130_fd_sc_hd__xnor2_2
X_13102_ clknet_leaf_5_clk _00074_ net566 vssd1 vssd1 vccd1 vccd1 cell0.CB_0.config_dataA\[4\]
+ sky130_fd_sc_hd__dfstp_1
XFILLER_4_833 vssd1 vssd1 vccd1 vccd1 sky130_fd_sc_hd__fill_1
X_10314_ net433 net436 vssd1 vssd1 vccd1 vccd1 _05313_ sky130_fd_sc_hd__and2b_1
XFILLER_98_55 vssd1 vssd1 vccd1 vccd1 sky130_fd_sc_hd__fill_1
X_14082_ clknet_leaf_79_clk _01054_ net709 vssd1 vssd1 vccd1 vccd1 cell3.SB0.route_sel\[90\]
+ sky130_fd_sc_hd__dfstp_1
X_11294_ net293 _06211_ _04209_ vssd1 vssd1 vccd1 vccd1 net141 sky130_fd_sc_hd__mux2_1
X_10245_ net411 _05244_ _05245_ vssd1 vssd1 vccd1 vccd1 _05246_ sky130_fd_sc_hd__a21oi_1
XFILLER_78_100 vssd1 vssd1 vccd1 vccd1 sky130_fd_sc_hd__fill_1
XANTENNA__07892__B _02301_ vssd1 vssd1 vccd1 vccd1 sky130_fd_sc_hd__diode_2
X_13033_ clknet_leaf_120_clk net1090 net595 vssd1 vssd1 vccd1 vccd1 cell0.LE_1B.config_data\[5\]
+ sky130_fd_sc_hd__dfrtp_1
X_10176_ net60 _05167_ _05168_ net59 cell2.CB_0.config_dataA\[3\] vssd1 vssd1 vccd1
+ vccd1 _05177_ sky130_fd_sc_hd__a221o_1
XANTENNA__10361__A3 net58 vssd1 vssd1 vccd1 vccd1 sky130_fd_sc_hd__diode_2
XFILLER_79_689 vssd1 vssd1 vccd1 vccd1 sky130_fd_sc_hd__fill_2
XANTENNA_output146_A net146 vssd1 vssd1 vccd1 vccd1 sky130_fd_sc_hd__diode_2
XANTENNA__07762__A1 net360 vssd1 vssd1 vccd1 vccd1 sky130_fd_sc_hd__diode_2
X_13935_ clknet_leaf_28_clk _00907_ net619 vssd1 vssd1 vccd1 vccd1 cell2.LE_0A.config_data\[14\]
+ sky130_fd_sc_hd__dfrtp_1
XFILLER_93_169 vssd1 vssd1 vccd1 vccd1 sky130_fd_sc_hd__fill_4
XANTENNA_clkload5_A clknet_4_5_0_clk vssd1 vssd1 vccd1 vccd1 sky130_fd_sc_hd__diode_2
X_13866_ clknet_leaf_43_clk _00838_ net627 vssd1 vssd1 vccd1 vccd1 cell2.CB_1.config_dataB\[15\]
+ sky130_fd_sc_hd__dfstp_1
XANTENNA__11310__A2 _05548_ vssd1 vssd1 vccd1 vccd1 sky130_fd_sc_hd__diode_2
X_12817_ cell2.SB0.route_sel\[59\] cell2.SB0.route_sel\[58\] net809 vssd1 vssd1 vccd1
+ vccd1 _01246_ sky130_fd_sc_hd__mux2_1
XFILLER_74_394 vssd1 vssd1 vccd1 vccd1 sky130_fd_sc_hd__fill_1
XANTENNA__10110__Y _05111_ vssd1 vssd1 vccd1 vccd1 sky130_fd_sc_hd__diode_2
X_13797_ clknet_leaf_105_clk _00769_ net661 vssd1 vssd1 vccd1 vccd1 cell1.SB0.route_sel\[74\]
+ sky130_fd_sc_hd__dfstp_1
X_12748_ cell3.CB_0.config_dataA\[15\] cell3.CB_0.config_dataA\[14\] net929 vssd1
+ vssd1 vccd1 vccd1 _01177_ sky130_fd_sc_hd__mux2_1
X_12679_ cell3.LE_1B.config_data\[16\] net1304 net953 vssd1 vssd1 vccd1 vccd1 _01108_
+ sky130_fd_sc_hd__mux2_1
XANTENNA__07700__X _02747_ vssd1 vssd1 vccd1 vccd1 sky130_fd_sc_hd__diode_2
X_14418_ clknet_leaf_55_clk _01390_ net717 vssd1 vssd1 vccd1 vccd1 cell3.LE_0A.config_data\[5\]
+ sky130_fd_sc_hd__dfrtp_1
XFILLER_8_53 vccd1 vssd1 vccd1 vssd1 sky130_ef_sc_hd__decap_40_12
XTAP_TAPCELL_ROW_96_1745 vssd1 vccd1 sky130_fd_sc_hd__tapvpwrvgnd_1
XFILLER_8_97 vccd1 vssd1 vccd1 vssd1 sky130_ef_sc_hd__decap_40_12
XANTENNA__10493__B _03537_ vssd1 vssd1 vccd1 vccd1 sky130_fd_sc_hd__diode_2
X_14349_ clknet_leaf_66_clk _01321_ net736 vssd1 vssd1 vccd1 vccd1 cell3.CB_1.config_dataB\[6\]
+ sky130_fd_sc_hd__dfstp_1
XFILLER_7_671 vssd1 vssd1 vccd1 vccd1 sky130_fd_sc_hd__fill_1
XANTENNA__10337__A0 net63 vssd1 vssd1 vccd1 vccd1 sky130_fd_sc_hd__diode_2
X_09890_ net437 _04894_ _04895_ vssd1 vssd1 vccd1 vccd1 _04896_ sky130_fd_sc_hd__a21oi_1
X_08910_ _03890_ _03940_ _03941_ _03894_ _01681_ vssd1 vssd1 vccd1 vccd1 _03942_ sky130_fd_sc_hd__a221o_1
XANTENNA__11809__S net902 vssd1 vssd1 vccd1 vccd1 sky130_fd_sc_hd__diode_2
X_08841_ bus3_1\[6\] bus3_1\[7\] net470 vssd1 vssd1 vccd1 vccd1 _03873_ sky130_fd_sc_hd__mux2_1
XANTENNA__07202__B1 _02260_ vssd1 vssd1 vccd1 vccd1 sky130_fd_sc_hd__diode_2
XANTENNA__10352__A3 _05139_ vssd1 vssd1 vccd1 vccd1 sky130_fd_sc_hd__diode_2
XTAP_TAPCELL_ROW_127_2211 vssd1 vccd1 sky130_fd_sc_hd__tapvpwrvgnd_1
XFILLER_84_103 vssd1 vssd1 vccd1 vccd1 sky130_fd_sc_hd__fill_1
XANTENNA__08950__A0 bus3_1\[0\] vssd1 vssd1 vccd1 vccd1 sky130_fd_sc_hd__diode_2
XFILLER_111_285 vssd1 vssd1 vccd1 vccd1 sky130_fd_sc_hd__fill_1
X_08772_ cell1.LE_1B.config_data\[15\] cell1.LE_1B.config_data\[14\] _03735_ vssd1
+ vssd1 vccd1 vccd1 _03806_ sky130_fd_sc_hd__mux2_1
XTAP_TAPCELL_ROW_0_302 vssd1 vccd1 sky130_fd_sc_hd__tapvpwrvgnd_1
X_07723_ _02769_ net334 _02768_ vssd1 vssd1 vccd1 vccd1 _02770_ sky130_fd_sc_hd__mux2_1
XTAP_TAPCELL_ROW_140_2411 vssd1 vccd1 sky130_fd_sc_hd__tapvpwrvgnd_1
XTAP_TAPCELL_ROW_0_313 vssd1 vccd1 sky130_fd_sc_hd__tapvpwrvgnd_1
X_07654_ _01847_ _02606_ net348 vssd1 vssd1 vccd1 vccd1 _02702_ sky130_fd_sc_hd__and3b_1
X_06605_ cell3.SB0.route_sel\[2\] vssd1 vssd1 vccd1 vccd1 _01675_ sky130_fd_sc_hd__inv_2
XFILLER_25_225 vssd1 vssd1 vccd1 vccd1 sky130_fd_sc_hd__fill_1
XFILLER_43_17 vccd1 vssd1 vccd1 vssd1 sky130_ef_sc_hd__decap_40_12
X_07585_ cell1.SB0.route_sel\[5\] cell1.SB0.route_sel\[4\] vssd1 vssd1 vccd1 vccd1
+ _02635_ sky130_fd_sc_hd__nand2_1
XANTENNA__11065__A1 _05916_ vssd1 vssd1 vccd1 vccd1 sky130_fd_sc_hd__diode_2
XTAP_TAPCELL_ROW_105_1885 vssd1 vccd1 sky130_fd_sc_hd__tapvpwrvgnd_1
X_06536_ cell2.SB0.route_sel\[40\] vssd1 vssd1 vccd1 vccd1 _01606_ sky130_fd_sc_hd__inv_2
X_09324_ _04328_ _04347_ _04345_ vssd1 vssd1 vccd1 vccd1 _04349_ sky130_fd_sc_hd__nor3b_1
XANTENNA__10812__A1 net14 vssd1 vssd1 vccd1 vccd1 sky130_fd_sc_hd__diode_2
XANTENNA__10812__B2 net13 vssd1 vssd1 vccd1 vccd1 sky130_fd_sc_hd__diode_2
X_09255_ net301 _04280_ vssd1 vssd1 vccd1 vccd1 _04281_ sky130_fd_sc_hd__nor2_1
X_06467_ cell1.SB0.route_sel\[92\] vssd1 vssd1 vccd1 vccd1 _01537_ sky130_fd_sc_hd__inv_2
XTAP_TAPCELL_ROW_138_2384 vssd1 vccd1 sky130_fd_sc_hd__tapvpwrvgnd_1
XTAP_TAPCELL_ROW_138_2373 vssd1 vccd1 sky130_fd_sc_hd__tapvpwrvgnd_1
XANTENNA_fanout609_A net623 vssd1 vssd1 vccd1 vccd1 sky130_fd_sc_hd__diode_2
XANTENNA__07469__S _02518_ vssd1 vssd1 vccd1 vccd1 sky130_fd_sc_hd__diode_2
X_08206_ bus1_0\[6\] bus1_0\[7\] net540 vssd1 vssd1 vccd1 vccd1 _03246_ sky130_fd_sc_hd__mux2_1
X_09186_ _04204_ _04213_ _04206_ vssd1 vssd1 vccd1 vccd1 _04214_ sky130_fd_sc_hd__a21o_1
X_06398_ cell0.SB0.route_sel\[67\] vssd1 vssd1 vccd1 vccd1 _01468_ sky130_fd_sc_hd__inv_2
XFILLER_107_514 vssd1 vssd1 vccd1 vccd1 sky130_fd_sc_hd__fill_1
XANTENNA__10576__A0 net17 vssd1 vssd1 vccd1 vccd1 sky130_fd_sc_hd__diode_2
X_08137_ net546 net544 _02350_ _03176_ cell0.CB_1.config_dataA\[2\] vssd1 vssd1 vccd1
+ vccd1 _03177_ sky130_fd_sc_hd__o311a_1
XFILLER_122_506 vssd1 vssd1 vccd1 vccd1 sky130_fd_sc_hd__fill_1
XFILLER_108_21 vssd1 vssd1 vccd1 vccd1 sky130_fd_sc_hd__fill_4
XANTENNA__10040__A2 bus3_2\[13\] vssd1 vssd1 vccd1 vccd1 sky130_fd_sc_hd__diode_2
XANTENNA_fanout880_A net884 vssd1 vssd1 vccd1 vccd1 sky130_fd_sc_hd__diode_2
X_08068_ bus2_0\[6\] bus2_0\[7\] net528 vssd1 vssd1 vccd1 vccd1 _03110_ sky130_fd_sc_hd__mux2_1
XANTENNA__08441__X _03477_ vssd1 vssd1 vccd1 vccd1 sky130_fd_sc_hd__diode_2
X_07019_ cell2.CB_1.config_dataB\[22\] cell2.CB_1.config_dataB\[23\] vssd1 vssd1 vccd1
+ vccd1 _02084_ sky130_fd_sc_hd__nand2b_2
XANTENNA__07992__B2 _02172_ vssd1 vssd1 vccd1 vccd1 sky130_fd_sc_hd__diode_2
XANTENNA__07992__A1 _02074_ vssd1 vssd1 vccd1 vccd1 sky130_fd_sc_hd__diode_2
XTAP_TAPCELL_ROW_8_435 vssd1 vccd1 sky130_fd_sc_hd__tapvpwrvgnd_1
XTAP_TAPCELL_ROW_8_424 vssd1 vccd1 sky130_fd_sc_hd__tapvpwrvgnd_1
X_10030_ net399 net400 vssd1 vssd1 vccd1 vccd1 _05034_ sky130_fd_sc_hd__or2_1
XFILLER_88_475 vssd1 vssd1 vccd1 vccd1 sky130_fd_sc_hd__fill_1
XFILLER_124_53 vccd1 vssd1 vccd1 vssd1 sky130_ef_sc_hd__decap_40_12
XANTENNA_fanout933_X net933 vssd1 vssd1 vccd1 vccd1 sky130_fd_sc_hd__diode_2
XFILLER_91_607 vssd1 vssd1 vccd1 vccd1 sky130_fd_sc_hd__fill_8
XANTENNA__07356__B1_N net69 vssd1 vssd1 vccd1 vccd1 sky130_fd_sc_hd__diode_2
X_11981_ cell0.SB0.route_sel\[87\] cell0.SB0.route_sel\[86\] net785 vssd1 vssd1 vccd1
+ vccd1 _00418_ sky130_fd_sc_hd__mux2_1
X_13720_ clknet_leaf_34_clk _00692_ net636 vssd1 vssd1 vccd1 vccd1 cell2.CB_0.config_dataA\[22\]
+ sky130_fd_sc_hd__dfstp_1
X_10932_ _05875_ _05876_ _05880_ _05885_ vssd1 vssd1 vccd1 vccd1 _05886_ sky130_fd_sc_hd__o211ai_1
XANTENNA__09432__B _04454_ vssd1 vssd1 vccd1 vccd1 sky130_fd_sc_hd__diode_2
XTAP_TAPCELL_ROW_67_1313 vssd1 vccd1 sky130_fd_sc_hd__tapvpwrvgnd_1
XTAP_TAPCELL_ROW_27_710 vssd1 vccd1 sky130_fd_sc_hd__tapvpwrvgnd_1
XFILLER_140_41 vccd1 vssd1 vccd1 vssd1 sky130_ef_sc_hd__decap_40_12
XFILLER_90_139 vssd1 vssd1 vccd1 vccd1 sky130_fd_sc_hd__fill_1
XFILLER_17_51 vssd1 vssd1 vccd1 vccd1 sky130_fd_sc_hd__fill_4
XFILLER_140_85 vccd1 vssd1 vccd1 vssd1 sky130_ef_sc_hd__decap_40_12
X_13651_ clknet_leaf_41_clk _00623_ net641 vssd1 vssd1 vccd1 vccd1 cell2.CB_1.config_dataA\[3\]
+ sky130_fd_sc_hd__dfstp_1
X_10863_ _05813_ _05816_ _05818_ cell3.CB_1.config_dataB\[17\] vssd1 vssd1 vccd1 vccd1
+ _05819_ sky130_fd_sc_hd__o22a_1
XTAP_TAPCELL_ROW_80_1502 vssd1 vccd1 sky130_fd_sc_hd__tapvpwrvgnd_1
XANTENNA__11056__A1 _05890_ vssd1 vssd1 vccd1 vccd1 sky130_fd_sc_hd__diode_2
X_10794_ _05510_ _05726_ _05748_ _05749_ vssd1 vssd1 vccd1 vccd1 _05750_ sky130_fd_sc_hd__a211oi_1
XTAP_TAPCELL_ROW_80_1513 vssd1 vccd1 sky130_fd_sc_hd__tapvpwrvgnd_1
X_12602_ cell3.SB0.route_sel\[67\] cell3.SB0.route_sel\[66\] net910 vssd1 vssd1 vccd1
+ vccd1 _01031_ sky130_fd_sc_hd__mux2_1
X_13582_ clknet_leaf_89_clk _00554_ net697 vssd1 vssd1 vccd1 vccd1 cell1.LEI0.config_data\[3\]
+ sky130_fd_sc_hd__dfrtp_1
X_12533_ cell2.CB_0.config_data_inA net1421 net838 vssd1 vssd1 vccd1 vccd1 _00962_
+ sky130_fd_sc_hd__mux2_1
XFILLER_12_442 vssd1 vssd1 vccd1 vccd1 sky130_fd_sc_hd__fill_1
XFILLER_12_464 vssd1 vssd1 vccd1 vccd1 sky130_fd_sc_hd__fill_1
X_14203_ clknet_leaf_54_clk _01175_ net717 vssd1 vssd1 vccd1 vccd1 cell3.CB_0.config_dataA\[13\]
+ sky130_fd_sc_hd__dfstp_1
X_12464_ net1034 cell2.LE_0A.config_data\[0\] net812 vssd1 vssd1 vccd1 vccd1 _00894_
+ sky130_fd_sc_hd__mux2_1
X_12395_ net407 cell2.CB_1.config_dataB\[4\] net848 vssd1 vssd1 vccd1 vccd1 _00828_
+ sky130_fd_sc_hd__mux2_1
X_11415_ cell0.SB0.route_sel\[96\] _01476_ vssd1 vssd1 vccd1 vccd1 _06277_ sky130_fd_sc_hd__nand2_1
XANTENNA_input62_X net62 vssd1 vssd1 vccd1 vccd1 sky130_fd_sc_hd__diode_2
X_11346_ _06238_ net284 _04571_ vssd1 vssd1 vccd1 vccd1 net183 sky130_fd_sc_hd__mux2_1
X_14134_ clknet_leaf_66_clk net1352 net743 vssd1 vssd1 vccd1 vccd1 cell3.LE_1B.config_data\[14\]
+ sky130_fd_sc_hd__dfrtp_1
XTAP_TAPCELL_ROW_78_1475 vssd1 vccd1 sky130_fd_sc_hd__tapvpwrvgnd_1
XANTENNA__09447__X _04469_ vssd1 vssd1 vccd1 vccd1 sky130_fd_sc_hd__diode_2
XFILLER_4_641 vssd1 vssd1 vccd1 vccd1 sky130_fd_sc_hd__fill_2
XFILLER_141_837 vssd1 vssd1 vccd1 vccd1 sky130_fd_sc_hd__fill_2
XFILLER_140_303 vssd1 vssd1 vccd1 vccd1 sky130_fd_sc_hd__fill_1
X_14065_ clknet_leaf_118_clk _01037_ net668 vssd1 vssd1 vccd1 vccd1 cell3.SB0.route_sel\[73\]
+ sky130_fd_sc_hd__dfstp_1
X_13016_ net1477 cell3.LEI0.config_data\[36\] net949 vssd1 vssd1 vccd1 vccd1 _01444_
+ sky130_fd_sc_hd__mux2_1
X_11277_ _02402_ _05113_ _02395_ vssd1 vssd1 vccd1 vccd1 _06207_ sky130_fd_sc_hd__a21o_1
XTAP_TAPCELL_ROW_91_1675 vssd1 vccd1 sky130_fd_sc_hd__tapvpwrvgnd_1
XANTENNA__08511__B _03509_ vssd1 vssd1 vccd1 vccd1 sky130_fd_sc_hd__diode_2
X_10228_ cell2.LEI0.config_data\[26\] _05228_ vssd1 vssd1 vccd1 vccd1 _05229_ sky130_fd_sc_hd__nor2_1
XFILLER_79_453 vssd1 vssd1 vccd1 vccd1 sky130_fd_sc_hd__fill_2
XFILLER_67_615 vssd1 vssd1 vccd1 vccd1 sky130_fd_sc_hd__fill_1
X_10159_ _05122_ _05125_ _05141_ _05159_ vssd1 vssd1 vccd1 vccd1 _05160_ sky130_fd_sc_hd__o22a_1
XFILLER_67_659 vssd1 vssd1 vccd1 vccd1 sky130_fd_sc_hd__fill_1
XANTENNA__14076__SET_B net672 vssd1 vssd1 vccd1 vccd1 sky130_fd_sc_hd__diode_2
Xhold2 cell0.LE_0A.dff0_out vssd1 vssd1 vccd1 vccd1 net961 sky130_fd_sc_hd__dlygate4sd3_1
XANTENNA__11540__A_N _02630_ vssd1 vssd1 vccd1 vccd1 sky130_fd_sc_hd__diode_2
XANTENNA__11295__A1 _05510_ vssd1 vssd1 vccd1 vccd1 sky130_fd_sc_hd__diode_2
XFILLER_35_501 vssd1 vssd1 vccd1 vccd1 sky130_fd_sc_hd__fill_2
X_13918_ clknet_leaf_36_clk _00890_ net646 vssd1 vssd1 vccd1 vccd1 cell2.LE_0B.reset_mode
+ sky130_fd_sc_hd__dfrtp_1
XTAP_TAPCELL_ROW_122_2141 vssd1 vccd1 sky130_fd_sc_hd__tapvpwrvgnd_1
XFILLER_90_640 vssd1 vssd1 vccd1 vccd1 sky130_fd_sc_hd__fill_2
XFILLER_63_843 vssd1 vssd1 vccd1 vccd1 sky130_fd_sc_hd__fill_1
X_13849_ clknet_leaf_115_clk _00821_ net596 vssd1 vssd1 vccd1 vccd1 cell1.SB0.route_sel\[126\]
+ sky130_fd_sc_hd__dfstp_1
XFILLER_35_567 vssd1 vssd1 vccd1 vccd1 sky130_fd_sc_hd__fill_1
XANTENNA__11047__A1 net54 vssd1 vssd1 vccd1 vccd1 sky130_fd_sc_hd__diode_2
X_07370_ _02406_ _02422_ _02424_ vssd1 vssd1 vccd1 vccd1 _02426_ sky130_fd_sc_hd__or3_1
X_09040_ bus3_1\[8\] bus3_1\[9\] bus3_1\[10\] bus3_1\[11\] net486 cell1.CB_0.config_dataB\[1\]
+ vssd1 vssd1 vccd1 vccd1 _04070_ sky130_fd_sc_hd__mux4_1
Xhold402 cell0.LEI0.config_data\[31\] vssd1 vssd1 vccd1 vccd1 net1361 sky130_fd_sc_hd__dlygate4sd3_1
Xhold413 cell3.LEI0.config_data\[29\] vssd1 vssd1 vccd1 vccd1 net1372 sky130_fd_sc_hd__dlygate4sd3_1
Xhold435 cell3.LEI0.config_data\[1\] vssd1 vssd1 vccd1 vccd1 net1394 sky130_fd_sc_hd__dlygate4sd3_1
Xhold424 cell0.LE_0B.config_data\[10\] vssd1 vssd1 vccd1 vccd1 net1383 sky130_fd_sc_hd__dlygate4sd3_1
XANTENNA__07423__B1 bus1_0\[14\] vssd1 vssd1 vccd1 vccd1 sky130_fd_sc_hd__diode_2
Xhold457 cell3.LE_1A.config_data\[5\] vssd1 vssd1 vccd1 vccd1 net1416 sky130_fd_sc_hd__dlygate4sd3_1
Xhold468 cell2.LEI0.config_data\[1\] vssd1 vssd1 vccd1 vccd1 net1427 sky130_fd_sc_hd__dlygate4sd3_1
X_09942_ cell2.CB_1.config_dataB\[2\] _04945_ vssd1 vssd1 vccd1 vccd1 _04946_ sky130_fd_sc_hd__nand2_1
Xhold446 cell0.LEI0.config_data\[41\] vssd1 vssd1 vccd1 vccd1 net1405 sky130_fd_sc_hd__dlygate4sd3_1
Xhold479 cell2.LEI0.config_data\[45\] vssd1 vssd1 vccd1 vccd1 net1438 sky130_fd_sc_hd__dlygate4sd3_1
Xfanout915 net916 vssd1 vssd1 vccd1 vccd1 net915 sky130_fd_sc_hd__clkbuf_2
XANTENNA__14364__SET_B net727 vssd1 vssd1 vccd1 vccd1 sky130_fd_sc_hd__diode_2
Xfanout904 net907 vssd1 vssd1 vccd1 vccd1 net904 sky130_fd_sc_hd__clkbuf_2
Xfanout948 net952 vssd1 vssd1 vccd1 vccd1 net948 sky130_fd_sc_hd__buf_2
Xfanout926 net934 vssd1 vssd1 vccd1 vccd1 net926 sky130_fd_sc_hd__clkbuf_2
Xfanout937 net944 vssd1 vssd1 vccd1 vccd1 net937 sky130_fd_sc_hd__clkbuf_4
X_09873_ bus3_2\[12\] bus3_2\[14\] bus3_2\[13\] bus3_2\[15\] net437 net438 vssd1 vssd1
+ vccd1 vccd1 _04879_ sky130_fd_sc_hd__mux4_1
Xfanout959 net130 vssd1 vssd1 vccd1 vccd1 net959 sky130_fd_sc_hd__clkbuf_4
XANTENNA__10325__A3 net58 vssd1 vssd1 vccd1 vccd1 sky130_fd_sc_hd__diode_2
XFILLER_98_795 vssd1 vssd1 vccd1 vccd1 sky130_fd_sc_hd__fill_1
XFILLER_97_283 vssd1 vssd1 vccd1 vccd1 sky130_fd_sc_hd__fill_1
X_08824_ _01508_ cell1.SB0.route_sel\[23\] vssd1 vssd1 vccd1 vccd1 _03856_ sky130_fd_sc_hd__nand2_1
XFILLER_85_467 vssd1 vssd1 vccd1 vccd1 sky130_fd_sc_hd__fill_1
X_08755_ net27 _03772_ _03773_ net28 cell1.CB_1.config_dataB\[18\] vssd1 vssd1 vccd1
+ vccd1 _03789_ sky130_fd_sc_hd__a221o_1
XTAP_TAPCELL_ROW_107_1914 vssd1 vccd1 sky130_fd_sc_hd__tapvpwrvgnd_1
XFILLER_85_489 vssd1 vssd1 vccd1 vccd1 sky130_fd_sc_hd__fill_4
X_07706_ net343 _01943_ _02620_ vssd1 vssd1 vccd1 vccd1 _02753_ sky130_fd_sc_hd__nor3_1
XANTENNA_fanout461_A cell1.CB_1.config_dataB\[0\] vssd1 vssd1 vccd1 vccd1 sky130_fd_sc_hd__diode_2
XTAP_TAPCELL_ROW_49_1043 vssd1 vccd1 sky130_fd_sc_hd__tapvpwrvgnd_1
X_08686_ _03537_ _03703_ _03705_ _03540_ _01654_ vssd1 vssd1 vccd1 vccd1 _03720_ sky130_fd_sc_hd__a221o_1
XANTENNA_fanout726_A net727 vssd1 vssd1 vccd1 vccd1 sky130_fd_sc_hd__diode_2
XFILLER_81_673 vssd1 vssd1 vccd1 vccd1 sky130_fd_sc_hd__fill_1
XANTENNA_fanout347_X net347 vssd1 vssd1 vccd1 vccd1 sky130_fd_sc_hd__diode_2
X_07637_ _02146_ _02640_ vssd1 vssd1 vccd1 vccd1 _02686_ sky130_fd_sc_hd__nor2_1
XFILLER_81_695 vssd1 vssd1 vccd1 vccd1 sky130_fd_sc_hd__fill_4
X_07568_ cell0.SB0.route_sel\[4\] cell0.SB0.route_sel\[5\] net97 _02616_ _02615_ vssd1
+ vssd1 vccd1 vccd1 _02618_ sky130_fd_sc_hd__a41o_1
XFILLER_110_66 vssd1 vssd1 vccd1 vccd1 sky130_fd_sc_hd__fill_2
XTAP_TAPCELL_ROW_62_1243 vssd1 vccd1 sky130_fd_sc_hd__tapvpwrvgnd_1
XTAP_TAPCELL_ROW_62_1232 vssd1 vccd1 sky130_fd_sc_hd__tapvpwrvgnd_1
X_09307_ _01947_ _02624_ net268 _02896_ vssd1 vssd1 vccd1 vccd1 _04332_ sky130_fd_sc_hd__o211ai_1
X_06519_ net106 vssd1 vssd1 vccd1 vccd1 _01589_ sky130_fd_sc_hd__inv_2
XFILLER_139_458 vssd1 vssd1 vccd1 vccd1 sky130_fd_sc_hd__fill_1
XFILLER_139_447 vssd1 vssd1 vccd1 vccd1 sky130_fd_sc_hd__fill_1
XANTENNA__10797__A0 net286 vssd1 vssd1 vccd1 vccd1 sky130_fd_sc_hd__diode_2
X_07499_ cell0.CB_0.le_outA _01943_ _02336_ vssd1 vssd1 vccd1 vccd1 _02551_ sky130_fd_sc_hd__or3_1
XFILLER_21_261 vssd1 vssd1 vccd1 vccd1 sky130_fd_sc_hd__fill_1
XANTENNA__10261__A2 net315 vssd1 vssd1 vccd1 vccd1 sky130_fd_sc_hd__diode_2
X_09238_ cell3.CB_0.config_dataB\[24\] cell3.CB_0.config_dataB\[21\] cell3.CB_0.config_dataB\[20\]
+ vssd1 vssd1 vccd1 vccd1 _04265_ sky130_fd_sc_hd__or3b_2
XTAP_TAPCELL_ROW_32_790 vssd1 vccd1 sky130_fd_sc_hd__tapvpwrvgnd_1
XFILLER_135_631 vssd1 vssd1 vccd1 vccd1 sky130_fd_sc_hd__fill_1
X_09169_ net269 _04196_ vssd1 vssd1 vccd1 vccd1 _04197_ sky130_fd_sc_hd__nand2_4
X_12180_ cell2.LE_1B.config_data\[13\] net1111 net853 vssd1 vssd1 vccd1 vccd1 _00613_
+ sky130_fd_sc_hd__mux2_1
X_11200_ cell3.CB_0.config_dataB\[17\] _06151_ vssd1 vssd1 vccd1 vccd1 _06152_ sky130_fd_sc_hd__nand2_1
XANTENNA__09267__X _04293_ vssd1 vssd1 vccd1 vccd1 sky130_fd_sc_hd__diode_2
XFILLER_107_333 vssd1 vssd1 vccd1 vccd1 sky130_fd_sc_hd__fill_1
X_11131_ net53 net54 net56 net57 net387 cell3.CB_0.config_dataB\[6\] vssd1 vssd1 vccd1
+ vccd1 _06083_ sky130_fd_sc_hd__mux4_1
XANTENNA_fanout883_X net883 vssd1 vssd1 vccd1 vccd1 sky130_fd_sc_hd__diode_2
XFILLER_0_110 vssd1 vssd1 vccd1 vccd1 sky130_fd_sc_hd__fill_2
X_11062_ net45 _05997_ _05999_ net46 cell3.CB_0.config_dataA\[18\] vssd1 vssd1 vccd1
+ vccd1 _06016_ sky130_fd_sc_hd__a221o_1
XFILLER_103_550 vssd1 vssd1 vccd1 vccd1 sky130_fd_sc_hd__fill_1
XANTENNA__08914__A0 bus3_1\[6\] vssd1 vssd1 vccd1 vccd1 sky130_fd_sc_hd__diode_2
XANTENNA__10316__A3 _05139_ vssd1 vssd1 vccd1 vccd1 sky130_fd_sc_hd__diode_2
X_10013_ _05016_ vssd1 vssd1 vccd1 vccd1 _05017_ sky130_fd_sc_hd__inv_2
XANTENNA_input22_A CBeast_in[29] vssd1 vssd1 vccd1 vccd1 sky130_fd_sc_hd__diode_2
XFILLER_91_426 vssd1 vssd1 vccd1 vccd1 sky130_fd_sc_hd__fill_1
XFILLER_17_501 vssd1 vssd1 vccd1 vccd1 sky130_fd_sc_hd__fill_2
XANTENNA__08142__A1 _02846_ vssd1 vssd1 vccd1 vccd1 sky130_fd_sc_hd__diode_2
X_11964_ cell0.SB0.route_sel\[70\] cell0.SB0.route_sel\[69\] net764 vssd1 vssd1 vccd1
+ vccd1 _00401_ sky130_fd_sc_hd__mux2_1
X_13703_ clknet_leaf_27_clk _00675_ net621 vssd1 vssd1 vccd1 vccd1 cell2.CB_0.config_dataA\[5\]
+ sky130_fd_sc_hd__dfstp_1
X_10915_ cell3.SB0.route_sel\[92\] _01735_ vssd1 vssd1 vccd1 vccd1 _05869_ sky130_fd_sc_hd__nand2_1
XANTENNA__08142__B2 _02807_ vssd1 vssd1 vccd1 vccd1 sky130_fd_sc_hd__diode_2
XFILLER_17_567 vssd1 vssd1 vccd1 vccd1 sky130_fd_sc_hd__fill_2
X_11895_ cell0.SB0.route_sel\[1\] cell0.SB0.route_sel\[0\] net782 vssd1 vssd1 vccd1
+ vccd1 _00332_ sky130_fd_sc_hd__mux2_1
XANTENNA__07496__A3 net103 vssd1 vssd1 vccd1 vccd1 sky130_fd_sc_hd__diode_2
XANTENNA__11029__A1 net45 vssd1 vssd1 vccd1 vccd1 sky130_fd_sc_hd__diode_2
XANTENNA__11029__B2 net46 vssd1 vssd1 vccd1 vccd1 sky130_fd_sc_hd__diode_2
X_13634_ clknet_leaf_39_clk net1173 net647 vssd1 vssd1 vccd1 vccd1 cell2.LE_1B.config_data\[6\]
+ sky130_fd_sc_hd__dfrtp_1
X_10846_ _05528_ _05531_ _05519_ _05523_ cell3.CB_1.config_dataB\[15\] net364 vssd1
+ vssd1 vccd1 vccd1 _05802_ sky130_fd_sc_hd__mux4_1
X_10777_ _05732_ vssd1 vssd1 vccd1 vccd1 _05733_ sky130_fd_sc_hd__inv_2
XFILLER_81_8 vccd1 vssd1 vccd1 vssd1 sky130_ef_sc_hd__decap_40_12
X_13565_ clknet_leaf_118_clk _00537_ net668 vssd1 vssd1 vccd1 vccd1 cell1.LE_0A.config_data\[8\]
+ sky130_fd_sc_hd__dfrtp_1
XPHY_EDGE_ROW_4_Left_147 vssd1 vssd1 vccd1 vccd1 sky130_fd_sc_hd__decap_3
XANTENNA__08445__A2 net6 vssd1 vssd1 vccd1 vccd1 sky130_fd_sc_hd__diode_2
X_12516_ cell2.LEI0.config_data\[30\] cell2.LEI0.config_data\[29\] net847 vssd1 vssd1
+ vccd1 vccd1 _00945_ sky130_fd_sc_hd__mux2_1
X_13496_ clknet_leaf_93_clk _00468_ net693 vssd1 vssd1 vccd1 vccd1 cell1.CB_1.config_dataB\[9\]
+ sky130_fd_sc_hd__dfstp_1
X_12447_ cell2.LE_0B.config_data\[7\] net1053 net841 vssd1 vssd1 vccd1 vccd1 _00878_
+ sky130_fd_sc_hd__mux2_1
XFILLER_8_265 vssd1 vssd1 vccd1 vccd1 sky130_fd_sc_hd__fill_2
XTAP_TAPCELL_ROW_10_451 vssd1 vccd1 sky130_fd_sc_hd__tapvpwrvgnd_1
XANTENNA__09945__A2 _04583_ vssd1 vssd1 vccd1 vccd1 sky130_fd_sc_hd__diode_2
XTAP_TAPCELL_ROW_93_1704 vssd1 vccd1 sky130_fd_sc_hd__tapvpwrvgnd_1
XTAP_TAPCELL_ROW_10_462 vssd1 vccd1 sky130_fd_sc_hd__tapvpwrvgnd_1
XFILLER_114_815 vssd1 vssd1 vccd1 vccd1 sky130_fd_sc_hd__fill_1
X_14117_ clknet_leaf_47_clk _01089_ net704 vssd1 vssd1 vccd1 vccd1 cell3.SB0.route_sel\[125\]
+ sky130_fd_sc_hd__dfstp_1
X_12378_ cell1.SB0.route_sel\[116\] cell1.SB0.route_sel\[115\] net882 vssd1 vssd1
+ vccd1 vccd1 _00811_ sky130_fd_sc_hd__mux2_1
X_11329_ _04266_ _05921_ _04269_ vssd1 vssd1 vccd1 vccd1 _06230_ sky130_fd_sc_hd__a21oi_1
XFILLER_4_493 vssd1 vssd1 vccd1 vccd1 sky130_fd_sc_hd__fill_1
X_14048_ clknet_leaf_47_clk _01020_ net703 vssd1 vssd1 vccd1 vccd1 cell3.SB0.route_sel\[56\]
+ sky130_fd_sc_hd__dfstp_1
X_06870_ cell0.SB0.route_sel\[59\] cell0.SB0.route_sel\[58\] vssd1 vssd1 vccd1 vccd1
+ _01938_ sky130_fd_sc_hd__nand2_1
XFILLER_121_391 vssd1 vssd1 vccd1 vccd1 sky130_fd_sc_hd__fill_1
XFILLER_82_415 vssd1 vssd1 vccd1 vccd1 sky130_fd_sc_hd__fill_4
XANTENNA__08133__A1 bus1_0\[9\] vssd1 vssd1 vccd1 vccd1 sky130_fd_sc_hd__diode_2
X_08540_ _03565_ _03567_ _03575_ vssd1 vssd1 vccd1 vccd1 _03576_ sky130_fd_sc_hd__a21oi_1
X_08471_ cell1.SB0.route_sel\[24\] cell1.SB0.route_sel\[25\] vssd1 vssd1 vccd1 vccd1
+ _03507_ sky130_fd_sc_hd__nand2b_1
XFILLER_90_481 vssd1 vssd1 vccd1 vccd1 sky130_fd_sc_hd__fill_2
XTAP_TAPCELL_ROW_18_573 vssd1 vccd1 sky130_fd_sc_hd__tapvpwrvgnd_1
XTAP_TAPCELL_ROW_18_584 vssd1 vccd1 sky130_fd_sc_hd__tapvpwrvgnd_1
X_07422_ net340 net361 _02326_ _02324_ _01847_ vssd1 vssd1 vccd1 vccd1 _02476_ sky130_fd_sc_hd__o32a_1
XTAP_TAPCELL_ROW_102_1844 vssd1 vccd1 sky130_fd_sc_hd__tapvpwrvgnd_1
XTAP_TAPCELL_ROW_102_1833 vssd1 vccd1 sky130_fd_sc_hd__tapvpwrvgnd_1
XFILLER_23_559 vssd1 vssd1 vccd1 vccd1 sky130_fd_sc_hd__fill_1
XFILLER_50_378 vssd1 vssd1 vccd1 vccd1 sky130_fd_sc_hd__fill_1
X_07353_ cell0.CB_1.le_outA _02405_ _02407_ _02408_ vssd1 vssd1 vccd1 vccd1 _02409_
+ sky130_fd_sc_hd__a2bb2o_1
XTAP_TAPCELL_ROW_135_2332 vssd1 vccd1 sky130_fd_sc_hd__tapvpwrvgnd_1
X_07284_ _02031_ _02340_ bus2_0\[12\] vssd1 vssd1 vccd1 vccd1 _02342_ sky130_fd_sc_hd__o21a_1
X_09023_ net485 _03885_ _04052_ net484 vssd1 vssd1 vccd1 vccd1 _04053_ sky130_fd_sc_hd__o211a_1
XFILLER_40_29 vccd1 vssd1 vccd1 vssd1 sky130_ef_sc_hd__decap_40_12
XANTENNA_fanout307_A net308 vssd1 vssd1 vccd1 vccd1 sky130_fd_sc_hd__diode_2
Xhold210 cell0.LE_0B.config_data\[2\] vssd1 vssd1 vccd1 vccd1 net1169 sky130_fd_sc_hd__dlygate4sd3_1
Xhold243 cell3.LE_1B.config_data\[5\] vssd1 vssd1 vccd1 vccd1 net1202 sky130_fd_sc_hd__dlygate4sd3_1
Xhold232 _01392_ vssd1 vssd1 vccd1 vccd1 net1191 sky130_fd_sc_hd__dlygate4sd3_1
Xhold221 _00900_ vssd1 vssd1 vccd1 vccd1 net1180 sky130_fd_sc_hd__dlygate4sd3_1
XANTENNA__09936__A2 _04696_ vssd1 vssd1 vccd1 vccd1 sky130_fd_sc_hd__diode_2
XANTENNA__07947__A1 bus2_0\[1\] vssd1 vssd1 vccd1 vccd1 sky130_fd_sc_hd__diode_2
XFILLER_2_419 vssd1 vssd1 vccd1 vccd1 sky130_fd_sc_hd__fill_1
Xhold265 cell3.LE_0B.config_data\[12\] vssd1 vssd1 vccd1 vccd1 net1224 sky130_fd_sc_hd__dlygate4sd3_1
Xhold254 _01393_ vssd1 vssd1 vccd1 vccd1 net1213 sky130_fd_sc_hd__dlygate4sd3_1
Xhold287 _00885_ vssd1 vssd1 vccd1 vccd1 net1246 sky130_fd_sc_hd__dlygate4sd3_1
Xhold276 cell3.LE_1B.config_data\[7\] vssd1 vssd1 vccd1 vccd1 net1235 sky130_fd_sc_hd__dlygate4sd3_1
XANTENNA__10951__A0 net47 vssd1 vssd1 vccd1 vccd1 sky130_fd_sc_hd__diode_2
Xfanout723 net724 vssd1 vssd1 vccd1 vccd1 net723 sky130_fd_sc_hd__buf_2
Xfanout712 net713 vssd1 vssd1 vccd1 vccd1 net712 sky130_fd_sc_hd__clkbuf_4
X_09925_ _04927_ _04928_ _04925_ vssd1 vssd1 vccd1 vccd1 _04929_ sky130_fd_sc_hd__o21ba_1
Xfanout701 net703 vssd1 vssd1 vccd1 vccd1 net701 sky130_fd_sc_hd__clkbuf_4
Xhold298 _00008_ vssd1 vssd1 vccd1 vccd1 net1257 sky130_fd_sc_hd__dlygate4sd3_1
Xfanout734 net742 vssd1 vssd1 vccd1 vccd1 net734 sky130_fd_sc_hd__clkbuf_4
Xfanout745 net746 vssd1 vssd1 vccd1 vccd1 net745 sky130_fd_sc_hd__clkbuf_2
X_09856_ _04856_ _04860_ _04861_ vssd1 vssd1 vccd1 vccd1 _04862_ sky130_fd_sc_hd__and3_1
Xfanout756 net131 vssd1 vssd1 vccd1 vccd1 net756 sky130_fd_sc_hd__clkbuf_8
XANTENNA__07990__B _02301_ vssd1 vssd1 vccd1 vccd1 sky130_fd_sc_hd__diode_2
Xfanout767 net768 vssd1 vssd1 vccd1 vccd1 net767 sky130_fd_sc_hd__clkbuf_2
XANTENNA_fanout676_A net684 vssd1 vssd1 vccd1 vccd1 sky130_fd_sc_hd__diode_2
XFILLER_105_55 vssd1 vssd1 vccd1 vccd1 sky130_fd_sc_hd__fill_1
Xfanout778 net779 vssd1 vssd1 vccd1 vccd1 net778 sky130_fd_sc_hd__clkbuf_2
XANTENNA__07175__A2 _02208_ vssd1 vssd1 vccd1 vccd1 sky130_fd_sc_hd__diode_2
X_08807_ cell1.SB0.route_sel\[82\] cell1.SB0.route_sel\[83\] vssd1 vssd1 vccd1 vccd1
+ _03839_ sky130_fd_sc_hd__or2_1
Xfanout789 net790 vssd1 vssd1 vccd1 vccd1 net789 sky130_fd_sc_hd__clkbuf_4
XANTENNA_fanout843_A net845 vssd1 vssd1 vccd1 vccd1 sky130_fd_sc_hd__diode_2
X_09787_ net447 net446 vssd1 vssd1 vccd1 vccd1 _04793_ sky130_fd_sc_hd__nor2_1
X_06999_ _02062_ _02063_ bus3_1\[8\] vssd1 vssd1 vccd1 vccd1 _02065_ sky130_fd_sc_hd__o21ai_1
XFILLER_39_692 vssd1 vssd1 vccd1 vccd1 sky130_fd_sc_hd__fill_1
X_08738_ net453 net451 vssd1 vssd1 vccd1 vccd1 _03772_ sky130_fd_sc_hd__nor2_1
XTAP_TAPCELL_ROW_37_860 vssd1 vccd1 sky130_fd_sc_hd__tapvpwrvgnd_1
X_08669_ net460 net462 vssd1 vssd1 vccd1 vccd1 _03703_ sky130_fd_sc_hd__and2b_1
XANTENNA__07478__A3 _02529_ vssd1 vssd1 vccd1 vccd1 sky130_fd_sc_hd__diode_2
X_10700_ cell3.CB_1.config_dataA\[18\] cell3.CB_1.config_dataA\[17\] vssd1 vssd1 vccd1
+ vccd1 _05658_ sky130_fd_sc_hd__nor2_1
XANTENNA__09872__A1 _04555_ vssd1 vssd1 vccd1 vccd1 sky130_fd_sc_hd__diode_2
X_11680_ net975 net548 _06373_ vssd1 vssd1 vccd1 vccd1 _00120_ sky130_fd_sc_hd__a21bo_1
X_10631_ net8 net9 net10 net11 net398 net397 vssd1 vssd1 vccd1 vccd1 _05589_ sky130_fd_sc_hd__mux4_1
XFILLER_41_389 vssd1 vssd1 vccd1 vccd1 sky130_fd_sc_hd__fill_1
XFILLER_14_41 vccd1 vssd1 vccd1 vssd1 sky130_ef_sc_hd__decap_40_12
XANTENNA__11033__A _05924_ vssd1 vssd1 vccd1 vccd1 sky130_fd_sc_hd__diode_2
X_10562_ net262 cell3.SB0.route_sel\[126\] vssd1 vssd1 vccd1 vccd1 _05520_ sky130_fd_sc_hd__nand2b_1
X_13350_ clknet_leaf_114_clk _00322_ net673 vssd1 vssd1 vccd1 vccd1 cell1.CB_0.config_dataA\[16\]
+ sky130_fd_sc_hd__dfstp_1
XFILLER_14_85 vssd1 vssd1 vccd1 vccd1 sky130_fd_sc_hd__fill_2
XFILLER_22_581 vssd1 vssd1 vccd1 vccd1 sky130_fd_sc_hd__fill_4
XANTENNA__10785__A3 net11 vssd1 vssd1 vccd1 vccd1 sky130_fd_sc_hd__diode_2
X_13281_ clknet_leaf_91_clk _00253_ net698 vssd1 vssd1 vccd1 vccd1 cell1.LE_1B.edge_mode
+ sky130_fd_sc_hd__dfstp_1
XFILLER_6_725 vccd1 vssd1 vccd1 vssd1 sky130_ef_sc_hd__decap_40_12
X_12301_ cell1.SB0.route_sel\[39\] cell1.SB0.route_sel\[38\] net860 vssd1 vssd1 vccd1
+ vccd1 _00734_ sky130_fd_sc_hd__mux2_1
X_12232_ cell2.CB_0.config_dataB\[20\] cell2.CB_0.config_dataB\[19\] net826 vssd1
+ vssd1 vccd1 vccd1 _00665_ sky130_fd_sc_hd__mux2_1
XANTENNA__11320__X net154 vssd1 vssd1 vccd1 vccd1 sky130_fd_sc_hd__diode_2
X_10493_ _02853_ _03537_ vssd1 vssd1 vccd1 vccd1 _05462_ sky130_fd_sc_hd__nand2b_1
XANTENNA__10591__B _05548_ vssd1 vssd1 vccd1 vccd1 sky130_fd_sc_hd__diode_2
XTAP_TAPCELL_ROW_75_1434 vssd1 vccd1 sky130_fd_sc_hd__tapvpwrvgnd_1
X_12163_ net1303 net1276 net894 vssd1 vssd1 vccd1 vccd1 _00596_ sky130_fd_sc_hd__mux2_1
XANTENNA__08061__B _02894_ vssd1 vssd1 vccd1 vccd1 sky130_fd_sc_hd__diode_2
X_11114_ net388 _06064_ _06065_ vssd1 vssd1 vccd1 vccd1 _06066_ sky130_fd_sc_hd__a21oi_1
X_12094_ net983 net550 _06379_ vssd1 vssd1 vccd1 vccd1 _00528_ sky130_fd_sc_hd__a21bo_1
XFILLER_1_441 vssd1 vssd1 vccd1 vccd1 sky130_fd_sc_hd__fill_4
X_11045_ cell3.CB_0.config_dataA\[16\] net373 vssd1 vssd1 vccd1 vccd1 _05999_ sky130_fd_sc_hd__and2b_1
XFILLER_1_485 vssd1 vssd1 vccd1 vccd1 sky130_fd_sc_hd__fill_2
XANTENNA__06797__A cell0.CB_0.config_dataB\[24\] vssd1 vssd1 vccd1 vccd1 sky130_fd_sc_hd__diode_2
XANTENNA__08363__A1 bus1_0\[1\] vssd1 vssd1 vccd1 vccd1 sky130_fd_sc_hd__diode_2
XANTENNA_input25_X net25 vssd1 vssd1 vccd1 vccd1 sky130_fd_sc_hd__diode_2
XFILLER_76_253 vssd1 vssd1 vccd1 vccd1 sky130_fd_sc_hd__fill_1
X_12996_ cell3.LEI0.config_data\[17\] net1472 net949 vssd1 vssd1 vccd1 vccd1 _01424_
+ sky130_fd_sc_hd__mux2_1
XFILLER_91_223 vssd1 vssd1 vccd1 vccd1 sky130_fd_sc_hd__fill_1
XANTENNA__09312__B1 bus3_2\[3\] vssd1 vssd1 vccd1 vccd1 sky130_fd_sc_hd__diode_2
XFILLER_44_150 vssd1 vssd1 vccd1 vccd1 sky130_fd_sc_hd__fill_1
X_11947_ cell0.SB0.route_sel\[53\] cell0.SB0.route_sel\[52\] net759 vssd1 vssd1 vccd1
+ vccd1 _00384_ sky130_fd_sc_hd__mux2_1
XTAP_TAPCELL_ROW_86_1596 vssd1 vccd1 sky130_fd_sc_hd__tapvpwrvgnd_1
XANTENNA__13170__RESET_B net751 vssd1 vssd1 vccd1 vccd1 sky130_fd_sc_hd__diode_2
X_11878_ cell1.CB_0.config_dataA\[9\] cell1.CB_0.config_dataA\[8\] net879 vssd1 vssd1
+ vccd1 vccd1 _00315_ sky130_fd_sc_hd__mux2_1
XTAP_TAPCELL_ROW_15_532 vssd1 vccd1 sky130_fd_sc_hd__tapvpwrvgnd_1
XANTENNA__07421__A net338 vssd1 vssd1 vccd1 vccd1 sky130_fd_sc_hd__diode_2
X_10829_ _05554_ _05761_ _05784_ vssd1 vssd1 vccd1 vccd1 _05785_ sky130_fd_sc_hd__a21o_1
X_13617_ clknet_leaf_87_clk net1239 net689 vssd1 vssd1 vccd1 vccd1 cell1.LEI0.config_data\[38\]
+ sky130_fd_sc_hd__dfrtp_1
X_13548_ clknet_leaf_90_clk _00520_ net699 vssd1 vssd1 vccd1 vccd1 cell1.LE_0B.config_data\[13\]
+ sky130_fd_sc_hd__dfrtp_1
XFILLER_13_581 vssd1 vssd1 vccd1 vccd1 sky130_fd_sc_hd__fill_2
XTAP_TAPCELL_ROW_117_2062 vssd1 vccd1 sky130_fd_sc_hd__tapvpwrvgnd_1
X_13479_ clknet_leaf_2_clk _00451_ net571 vssd1 vssd1 vccd1 vccd1 cell0.SB0.route_sel\[120\]
+ sky130_fd_sc_hd__dfstp_1
XANTENNA__11186__A0 net298 vssd1 vssd1 vccd1 vccd1 sky130_fd_sc_hd__diode_2
XANTENNA__11089__S cell3.LE_0A.reset_val vssd1 vssd1 vccd1 vccd1 sky130_fd_sc_hd__diode_2
XANTENNA__07929__A1 bus2_0\[13\] vssd1 vssd1 vccd1 vccd1 sky130_fd_sc_hd__diode_2
XTAP_TAPCELL_ROW_130_2262 vssd1 vccd1 sky130_fd_sc_hd__tapvpwrvgnd_1
XTAP_TAPCELL_ROW_130_2251 vssd1 vccd1 sky130_fd_sc_hd__tapvpwrvgnd_1
XFILLER_113_111 vssd1 vssd1 vccd1 vccd1 sky130_fd_sc_hd__fill_1
XANTENNA__09067__B _03820_ vssd1 vssd1 vccd1 vccd1 sky130_fd_sc_hd__diode_2
X_07971_ _03013_ _03014_ _02917_ vssd1 vssd1 vccd1 vccd1 _03015_ sky130_fd_sc_hd__mux2_1
X_09710_ _04722_ vssd1 vssd1 vccd1 vccd1 _04723_ sky130_fd_sc_hd__inv_2
X_06922_ cell2.SB0.route_sel\[59\] cell2.SB0.route_sel\[58\] vssd1 vssd1 vccd1 vccd1
+ _01989_ sky130_fd_sc_hd__nand2_1
XANTENNA__11817__S net905 vssd1 vssd1 vccd1 vccd1 sky130_fd_sc_hd__diode_2
X_06853_ cell2.CB_0.config_dataA\[24\] cell2.CB_0.config_dataA\[20\] cell2.CB_0.config_dataA\[21\]
+ vssd1 vssd1 vccd1 vccd1 _01922_ sky130_fd_sc_hd__or3b_1
X_09641_ _04218_ _04656_ vssd1 vssd1 vccd1 vccd1 _04657_ sky130_fd_sc_hd__or2_1
XFILLER_82_201 vssd1 vssd1 vccd1 vccd1 sky130_fd_sc_hd__fill_1
X_09572_ cell3.SB0.route_sel\[80\] cell3.SB0.route_sel\[81\] vssd1 vssd1 vccd1 vccd1
+ _04590_ sky130_fd_sc_hd__nand2_1
X_06784_ _01847_ _01848_ net348 vssd1 vssd1 vccd1 vccd1 _01854_ sky130_fd_sc_hd__and3b_1
XFILLER_82_267 vssd1 vssd1 vccd1 vccd1 sky130_fd_sc_hd__fill_1
X_08523_ net494 _03529_ vssd1 vssd1 vccd1 vccd1 _03559_ sky130_fd_sc_hd__nand2_1
XANTENNA__11110__B1 _05901_ vssd1 vssd1 vccd1 vccd1 sky130_fd_sc_hd__diode_2
XANTENNA__07865__A0 bus2_0\[6\] vssd1 vssd1 vccd1 vccd1 sky130_fd_sc_hd__diode_2
XTAP_TAPCELL_ROW_46_1002 vssd1 vccd1 sky130_fd_sc_hd__tapvpwrvgnd_1
XFILLER_23_312 vssd1 vssd1 vccd1 vccd1 sky130_fd_sc_hd__fill_1
XANTENNA__11405__X net199 vssd1 vssd1 vccd1 vccd1 sky130_fd_sc_hd__diode_2
X_08454_ net497 _03489_ vssd1 vssd1 vccd1 vccd1 _03490_ sky130_fd_sc_hd__nand2_1
X_07405_ net118 cell2.SB0.route_sel\[109\] cell2.SB0.route_sel\[108\] vssd1 vssd1
+ vccd1 vccd1 _02460_ sky130_fd_sc_hd__and3_1
XANTENNA__07331__A _02346_ vssd1 vssd1 vccd1 vccd1 sky130_fd_sc_hd__diode_2
X_08385_ _02422_ _02424_ _03422_ vssd1 vssd1 vccd1 vccd1 _03423_ sky130_fd_sc_hd__o21ai_1
XANTENNA__08409__A2 cell0.CB_1.le_outA vssd1 vssd1 vccd1 vccd1 sky130_fd_sc_hd__diode_2
XFILLER_136_9 vccd1 vssd1 vccd1 vssd1 sky130_ef_sc_hd__decap_40_12
X_07336_ cell2.SB0.route_sel\[99\] cell2.SB0.route_sel\[98\] _02391_ _02392_ _02384_
+ vssd1 vssd1 vccd1 vccd1 _02393_ sky130_fd_sc_hd__a41o_1
XFILLER_50_197 vssd1 vssd1 vccd1 vccd1 sky130_fd_sc_hd__fill_1
XFILLER_137_759 vccd1 vssd1 vccd1 vssd1 sky130_ef_sc_hd__decap_40_12
X_09006_ net483 _03820_ vssd1 vssd1 vccd1 vccd1 _04036_ sky130_fd_sc_hd__nand2_1
XANTENNA__07985__B _02585_ vssd1 vssd1 vccd1 vccd1 sky130_fd_sc_hd__diode_2
X_07267_ cell0.CB_1.config_dataB\[22\] cell0.CB_1.config_dataB\[23\] vssd1 vssd1 vccd1
+ vccd1 _02325_ sky130_fd_sc_hd__and2_1
XANTENNA__11177__A0 net40 vssd1 vssd1 vccd1 vccd1 sky130_fd_sc_hd__diode_2
XPHY_EDGE_ROW_76_Left_219 vssd1 vssd1 vccd1 vccd1 sky130_fd_sc_hd__decap_3
X_07198_ _01933_ net357 vssd1 vssd1 vccd1 vccd1 _02258_ sky130_fd_sc_hd__nor2_1
XFILLER_117_494 vssd1 vssd1 vccd1 vccd1 sky130_fd_sc_hd__fill_1
XTAP_TAPCELL_ROW_57_1164 vssd1 vccd1 sky130_fd_sc_hd__tapvpwrvgnd_1
XFILLER_116_21 vssd1 vssd1 vccd1 vccd1 sky130_fd_sc_hd__fill_4
XANTENNA__07396__A2 _02447_ vssd1 vssd1 vccd1 vccd1 sky130_fd_sc_hd__diode_2
XANTENNA__08593__A1 net30 vssd1 vssd1 vccd1 vccd1 sky130_fd_sc_hd__diode_2
XFILLER_2_249 vssd1 vssd1 vccd1 vccd1 sky130_fd_sc_hd__fill_2
Xfanout531 cell0.CB_0.config_dataB\[5\] vssd1 vssd1 vccd1 vccd1 net531 sky130_fd_sc_hd__clkbuf_2
Xfanout520 cell0.CB_0.config_dataA\[1\] vssd1 vssd1 vccd1 vccd1 net520 sky130_fd_sc_hd__buf_2
Xfanout542 cell0.CB_1.config_dataA\[5\] vssd1 vssd1 vccd1 vccd1 net542 sky130_fd_sc_hd__clkbuf_2
XANTENNA_fanout581_X net581 vssd1 vssd1 vccd1 vccd1 sky130_fd_sc_hd__diode_2
X_09908_ cell2.LE_1A.config_data\[15\] cell2.LE_1A.config_data\[14\] _04831_ vssd1
+ vssd1 vccd1 vccd1 _04914_ sky130_fd_sc_hd__mux2_1
Xfanout575 net602 vssd1 vssd1 vccd1 vccd1 net575 sky130_fd_sc_hd__clkbuf_2
XTAP_TAPCELL_ROW_70_1364 vssd1 vccd1 sky130_fd_sc_hd__tapvpwrvgnd_1
XTAP_TAPCELL_ROW_70_1353 vssd1 vccd1 sky130_fd_sc_hd__tapvpwrvgnd_1
Xfanout564 net575 vssd1 vssd1 vccd1 vccd1 net564 sky130_fd_sc_hd__clkbuf_4
Xfanout553 net555 vssd1 vssd1 vccd1 vccd1 net553 sky130_fd_sc_hd__clkbuf_4
XANTENNA__14483__SET_B net752 vssd1 vssd1 vccd1 vccd1 sky130_fd_sc_hd__diode_2
XANTENNA__10152__A1 net44 vssd1 vssd1 vccd1 vccd1 sky130_fd_sc_hd__diode_2
X_09839_ net441 _04583_ _04844_ net440 vssd1 vssd1 vccd1 vccd1 _04845_ sky130_fd_sc_hd__o211a_1
Xfanout597 net600 vssd1 vssd1 vccd1 vccd1 net597 sky130_fd_sc_hd__buf_4
Xfanout586 net587 vssd1 vssd1 vccd1 vccd1 net586 sky130_fd_sc_hd__clkbuf_4
XFILLER_132_53 vccd1 vssd1 vccd1 vssd1 sky130_ef_sc_hd__decap_40_12
X_12850_ cell2.SB0.route_sel\[92\] cell2.SB0.route_sel\[91\] net831 vssd1 vssd1 vccd1
+ vccd1 _01279_ sky130_fd_sc_hd__mux2_1
XANTENNA_input124_A SBwest_in[5] vssd1 vssd1 vccd1 vccd1 sky130_fd_sc_hd__diode_2
XPHY_EDGE_ROW_85_Left_228 vssd1 vssd1 vccd1 vccd1 sky130_fd_sc_hd__decap_3
X_11801_ net1154 net1290 net902 vssd1 vssd1 vccd1 vccd1 _00238_ sky130_fd_sc_hd__mux2_1
XFILLER_33_109 vssd1 vssd1 vccd1 vccd1 sky130_fd_sc_hd__fill_2
XANTENNA__09845__A1 bus3_2\[2\] vssd1 vssd1 vccd1 vccd1 sky130_fd_sc_hd__diode_2
X_12781_ cell2.SB0.route_sel\[23\] cell2.SB0.route_sel\[22\] net816 vssd1 vssd1 vccd1
+ vccd1 _01210_ sky130_fd_sc_hd__mux2_1
XFILLER_26_150 vssd1 vssd1 vccd1 vccd1 sky130_fd_sc_hd__fill_4
X_11732_ net993 cell0.LE_0A.config_data\[4\] net772 vssd1 vssd1 vccd1 vccd1 _00170_
+ sky130_fd_sc_hd__mux2_1
XFILLER_42_643 vssd1 vssd1 vccd1 vccd1 sky130_fd_sc_hd__fill_1
XFILLER_25_51 vssd1 vssd1 vccd1 vccd1 sky130_fd_sc_hd__fill_4
X_14451_ clknet_leaf_60_clk net1193 net738 vssd1 vssd1 vccd1 vccd1 cell3.LEI0.config_data\[16\]
+ sky130_fd_sc_hd__dfrtp_1
X_11663_ cell0.CB_1.config_dataB\[9\] cell0.CB_1.config_dataB\[8\] net783 vssd1 vssd1
+ vccd1 vccd1 _00104_ sky130_fd_sc_hd__mux2_1
XANTENNA__10207__A2 net34 vssd1 vssd1 vccd1 vccd1 sky130_fd_sc_hd__diode_2
X_14382_ clknet_leaf_69_clk _01354_ net743 vssd1 vssd1 vccd1 vccd1 cell3.LE_1A.config_data\[13\]
+ sky130_fd_sc_hd__dfrtp_1
X_10614_ net17 net18 net19 net20 net398 net397 vssd1 vssd1 vccd1 vccd1 _05572_ sky130_fd_sc_hd__mux4_1
X_13402_ clknet_leaf_134_clk _00374_ net553 vssd1 vssd1 vccd1 vccd1 cell0.SB0.route_sel\[43\]
+ sky130_fd_sc_hd__dfstp_1
XANTENNA__09073__A2 _03858_ vssd1 vssd1 vccd1 vccd1 sky130_fd_sc_hd__diode_2
X_13333_ clknet_leaf_114_clk _00305_ net673 vssd1 vssd1 vccd1 vccd1 cell1.CB_0.config_dataB\[24\]
+ sky130_fd_sc_hd__dfstp_2
XANTENNA__08281__A0 bus1_0\[8\] vssd1 vssd1 vccd1 vccd1 sky130_fd_sc_hd__diode_2
X_11594_ net536 cell0.CB_1.config_dataA\[14\] net789 vssd1 vssd1 vccd1 vccd1 _00035_
+ sky130_fd_sc_hd__mux2_1
XPHY_EDGE_ROW_94_Left_237 vssd1 vssd1 vccd1 vccd1 sky130_fd_sc_hd__decap_3
X_10545_ cell3.SB0.route_sel\[24\] _01694_ cell3.SB0.route_sel\[29\] cell3.SB0.route_sel\[28\]
+ _05502_ vssd1 vssd1 vccd1 vccd1 _05503_ sky130_fd_sc_hd__o221a_2
Xclkbuf_leaf_130_clk clknet_4_0_0_clk vssd1 vssd1 vccd1 vccd1 clknet_leaf_130_clk
+ sky130_fd_sc_hd__clkbuf_8
X_10476_ net597 cell0.LE_1B.reset_mode vssd1 vssd1 vccd1 vccd1 _10476_/X sky130_fd_sc_hd__xor2_2
X_13264_ clknet_leaf_91_clk _00236_ net698 vssd1 vssd1 vccd1 vccd1 cell1.LE_1B.config_data\[0\]
+ sky130_fd_sc_hd__dfrtp_1
XANTENNA_output176_A net176 vssd1 vssd1 vccd1 vccd1 sky130_fd_sc_hd__diode_2
X_12215_ cell2.CB_0.config_dataB\[3\] cell2.CB_0.config_dataB\[2\] net825 vssd1 vssd1
+ vccd1 vccd1 _00648_ sky130_fd_sc_hd__mux2_1
XFILLER_136_781 vccd1 vssd1 vccd1 vssd1 sky130_ef_sc_hd__decap_40_12
X_13195_ clknet_leaf_23_clk _00167_ net603 vssd1 vssd1 vccd1 vccd1 cell0.LE_0A.config_data\[2\]
+ sky130_fd_sc_hd__dfrtp_1
XANTENNA__13685__SET_B net619 vssd1 vssd1 vccd1 vccd1 sky130_fd_sc_hd__diode_2
XFILLER_111_604 vssd1 vssd1 vccd1 vccd1 sky130_fd_sc_hd__fill_4
X_12146_ net1364 cell1.LEI0.config_data\[27\] net893 vssd1 vssd1 vccd1 vccd1 _00579_
+ sky130_fd_sc_hd__mux2_1
XFILLER_111_615 vssd1 vssd1 vccd1 vccd1 sky130_fd_sc_hd__fill_1
XFILLER_96_348 vssd1 vssd1 vccd1 vccd1 sky130_fd_sc_hd__fill_1
X_12077_ net1010 net1012 net940 vssd1 vssd1 vccd1 vccd1 _00512_ sky130_fd_sc_hd__mux2_1
XANTENNA__09128__A3 net323 vssd1 vssd1 vccd1 vccd1 sky130_fd_sc_hd__diode_2
XFILLER_1_293 vccd1 vssd1 vccd1 vssd1 sky130_ef_sc_hd__decap_40_12
X_11028_ net47 net48 net375 vssd1 vssd1 vccd1 vccd1 _05982_ sky130_fd_sc_hd__mux2_1
XTAP_TAPCELL_ROW_88_1625 vssd1 vccd1 sky130_fd_sc_hd__tapvpwrvgnd_1
XFILLER_2_77 vssd1 vssd1 vccd1 vccd1 sky130_fd_sc_hd__fill_4
XANTENNA__08887__A2 _03858_ vssd1 vssd1 vccd1 vccd1 sky130_fd_sc_hd__diode_2
XANTENNA__06898__A1 net30 vssd1 vssd1 vccd1 vccd1 sky130_fd_sc_hd__diode_2
XANTENNA__10139__A2_N _05136_ vssd1 vssd1 vccd1 vccd1 sky130_fd_sc_hd__diode_2
XFILLER_80_705 vssd1 vssd1 vccd1 vccd1 sky130_fd_sc_hd__fill_4
X_12979_ net1403 cell3.LE_1A.reset_mode net948 vssd1 vssd1 vccd1 vccd1 _01407_ sky130_fd_sc_hd__mux2_1
XANTENNA__08639__A2 net23 vssd1 vssd1 vccd1 vccd1 sky130_fd_sc_hd__diode_2
XANTENNA__06974__B _02039_ vssd1 vssd1 vccd1 vccd1 sky130_fd_sc_hd__diode_2
XANTENNA__07847__B1 _02890_ vssd1 vssd1 vccd1 vccd1 sky130_fd_sc_hd__diode_2
XANTENNA_27 net195 vssd1 vssd1 vccd1 vccd1 sky130_fd_sc_hd__diode_2
XANTENNA_16 cell3.CB_1.le_outB vssd1 vssd1 vccd1 vccd1 sky130_fd_sc_hd__diode_2
XPHY_EDGE_ROW_120_Right_120 vssd1 vssd1 vccd1 vccd1 sky130_fd_sc_hd__decap_3
XANTENNA_38 cell1.LE_1A.config_data\[16\] vssd1 vssd1 vccd1 vccd1 sky130_fd_sc_hd__diode_2
X_08170_ net541 _03208_ _03209_ vssd1 vssd1 vccd1 vccd1 _03210_ sky130_fd_sc_hd__a21oi_1
XANTENNA_49 net41 vssd1 vssd1 vccd1 vccd1 sky130_fd_sc_hd__diode_2
X_07121_ _02183_ net310 _02181_ vssd1 vssd1 vccd1 vccd1 _02184_ sky130_fd_sc_hd__mux2_1
XFILLER_119_715 vssd1 vssd1 vccd1 vccd1 sky130_fd_sc_hd__fill_1
XANTENNA__09064__A2 bus3_1\[10\] vssd1 vssd1 vccd1 vccd1 sky130_fd_sc_hd__diode_2
XFILLER_20_359 vssd1 vssd1 vccd1 vccd1 sky130_fd_sc_hd__fill_1
XTAP_TAPCELL_ROW_99_1787 vssd1 vccd1 sky130_fd_sc_hd__tapvpwrvgnd_1
Xclkbuf_leaf_121_clk clknet_4_3_0_clk vssd1 vssd1 vccd1 vccd1 clknet_leaf_121_clk
+ sky130_fd_sc_hd__clkbuf_8
XANTENNA__11159__A0 net49 vssd1 vssd1 vccd1 vccd1 sky130_fd_sc_hd__diode_2
XTAP_TAPCELL_ROW_99_1798 vssd1 vccd1 sky130_fd_sc_hd__tapvpwrvgnd_1
X_07052_ cell0.SB0.route_sel\[74\] cell0.SB0.route_sel\[75\] vssd1 vssd1 vccd1 vccd1
+ _02116_ sky130_fd_sc_hd__nand2_1
Xoutput134 net134 vssd1 vssd1 vccd1 vccd1 CBeast_out[0] sky130_fd_sc_hd__buf_2
Xoutput167 net167 vssd1 vssd1 vccd1 vccd1 CBnorth_out[10] sky130_fd_sc_hd__buf_2
Xoutput145 net145 vssd1 vssd1 vccd1 vccd1 CBeast_out[1] sky130_fd_sc_hd__buf_2
Xoutput156 net156 vssd1 vssd1 vccd1 vccd1 CBeast_out[2] sky130_fd_sc_hd__buf_2
Xoutput189 net189 vssd1 vssd1 vccd1 vccd1 CBnorth_out[30] sky130_fd_sc_hd__buf_2
Xoutput178 net178 vssd1 vssd1 vccd1 vccd1 CBnorth_out[20] sky130_fd_sc_hd__buf_2
XFILLER_114_486 vssd1 vssd1 vccd1 vccd1 sky130_fd_sc_hd__fill_1
XFILLER_114_475 vssd1 vssd1 vccd1 vccd1 sky130_fd_sc_hd__fill_1
XFILLER_99_186 vssd1 vssd1 vccd1 vccd1 sky130_fd_sc_hd__fill_1
XTAP_TAPCELL_ROW_110_1965 vssd1 vccd1 sky130_fd_sc_hd__tapvpwrvgnd_1
XTAP_TAPCELL_ROW_110_1954 vssd1 vccd1 sky130_fd_sc_hd__tapvpwrvgnd_1
XANTENNA__09119__A3 bus3_1\[15\] vssd1 vssd1 vccd1 vccd1 sky130_fd_sc_hd__diode_2
X_07954_ _02074_ _02983_ _02984_ _02172_ cell0.CB_0.config_dataA\[17\] vssd1 vssd1
+ vccd1 vccd1 _02998_ sky130_fd_sc_hd__a221o_1
X_07885_ bus2_0\[5\] _02920_ _02921_ bus2_0\[4\] cell0.CB_0.config_dataA\[3\] vssd1
+ vssd1 vccd1 vccd1 _02929_ sky130_fd_sc_hd__a221o_1
XTAP_TAPCELL_ROW_52_1094 vssd1 vccd1 sky130_fd_sc_hd__tapvpwrvgnd_1
XTAP_TAPCELL_ROW_52_1083 vssd1 vccd1 sky130_fd_sc_hd__tapvpwrvgnd_1
X_06905_ cell1.CB_0.config_dataB\[24\] cell1.CB_0.config_dataB\[21\] cell1.CB_0.config_dataB\[20\]
+ vssd1 vssd1 vccd1 vccd1 _01973_ sky130_fd_sc_hd__nand3b_1
XTAP_TAPCELL_ROW_39_900 vssd1 vccd1 sky130_fd_sc_hd__tapvpwrvgnd_1
X_09624_ _01638_ cell2.SB0.route_sel\[103\] cell2.SB0.route_sel\[100\] cell2.SB0.route_sel\[101\]
+ _04639_ vssd1 vssd1 vccd1 vccd1 _04640_ sky130_fd_sc_hd__o221ai_2
X_06836_ cell2.CB_1.config_dataB\[23\] cell2.CB_1.config_dataB\[22\] vssd1 vssd1 vccd1
+ vccd1 _01905_ sky130_fd_sc_hd__and2b_1
XANTENNA__08878__A2 bus3_1\[14\] vssd1 vssd1 vccd1 vccd1 sky130_fd_sc_hd__diode_2
XFILLER_56_746 vssd1 vssd1 vccd1 vccd1 sky130_fd_sc_hd__fill_1
XFILLER_55_223 vssd1 vssd1 vccd1 vccd1 sky130_fd_sc_hd__fill_1
XANTENNA__06889__A1 net360 vssd1 vssd1 vccd1 vccd1 sky130_fd_sc_hd__diode_2
XANTENNA_fanout639_A net640 vssd1 vssd1 vccd1 vccd1 sky130_fd_sc_hd__diode_2
X_09555_ _04573_ _04564_ vssd1 vssd1 vccd1 vccd1 _04574_ sky130_fd_sc_hd__and2b_1
XFILLER_70_204 vssd1 vssd1 vccd1 vccd1 sky130_fd_sc_hd__fill_4
X_06767_ cell1.CB_1.config_dataB\[24\] cell1.CB_1.config_dataB\[20\] cell1.CB_1.config_dataB\[21\]
+ vssd1 vssd1 vccd1 vccd1 _01837_ sky130_fd_sc_hd__or3b_4
X_06698_ cell2.LEI0.config_data\[14\] vssd1 vssd1 vccd1 vccd1 _01768_ sky130_fd_sc_hd__inv_2
XFILLER_102_56 vssd1 vssd1 vccd1 vccd1 sky130_fd_sc_hd__fill_1
X_09486_ cell3.SB0.route_sel\[56\] cell3.SB0.route_sel\[57\] vssd1 vssd1 vccd1 vccd1
+ _04507_ sky130_fd_sc_hd__nand2_1
X_08506_ _03523_ _03526_ _03534_ _03541_ _03522_ vssd1 vssd1 vccd1 vccd1 _03542_ sky130_fd_sc_hd__o221a_1
XANTENNA__07061__A cell0.CB_0.config_dataB\[24\] vssd1 vssd1 vccd1 vccd1 sky130_fd_sc_hd__diode_2
X_08437_ _02159_ _03472_ vssd1 vssd1 vccd1 vccd1 _03473_ sky130_fd_sc_hd__nand2_4
XANTENNA_fanout806_A net807 vssd1 vssd1 vccd1 vccd1 sky130_fd_sc_hd__diode_2
X_08368_ cell0.CB_1.config_dataB\[11\] _03404_ _03405_ vssd1 vssd1 vccd1 vccd1 _03406_
+ sky130_fd_sc_hd__a21oi_1
X_07319_ cell2.CB_1.config_dataA\[23\] cell2.CB_1.config_dataA\[22\] vssd1 vssd1 vccd1
+ vccd1 _02376_ sky130_fd_sc_hd__nand2_1
X_08299_ net506 _01956_ vssd1 vssd1 vccd1 vccd1 _03337_ sky130_fd_sc_hd__nand2_1
Xclkbuf_leaf_112_clk clknet_4_8_0_clk vssd1 vssd1 vccd1 vccd1 clknet_leaf_112_clk
+ sky130_fd_sc_hd__clkbuf_8
X_10330_ _05111_ _05313_ vssd1 vssd1 vccd1 vccd1 _05329_ sky130_fd_sc_hd__nand2_1
XFILLER_3_503 vssd1 vssd1 vccd1 vccd1 sky130_fd_sc_hd__fill_1
X_10261_ _01822_ net305 net315 net302 cell2.LEI0.config_data\[36\] cell2.LEI0.config_data\[37\]
+ vssd1 vssd1 vccd1 vccd1 _05262_ sky130_fd_sc_hd__mux4_1
XANTENNA__08015__B1 _03056_ vssd1 vssd1 vccd1 vccd1 sky130_fd_sc_hd__diode_2
XANTENNA__11165__A3 net57 vssd1 vssd1 vccd1 vccd1 sky130_fd_sc_hd__diode_2
XFILLER_133_751 vssd1 vssd1 vccd1 vccd1 sky130_fd_sc_hd__fill_1
XFILLER_105_442 vssd1 vssd1 vccd1 vccd1 sky130_fd_sc_hd__fill_2
X_12000_ cell0.SB0.route_sel\[106\] cell0.SB0.route_sel\[105\] net770 vssd1 vssd1
+ vccd1 vccd1 _00437_ sky130_fd_sc_hd__mux2_1
XFILLER_3_558 vssd1 vssd1 vccd1 vccd1 sky130_fd_sc_hd__fill_2
XANTENNA__06899__X _01967_ vssd1 vssd1 vccd1 vccd1 sky130_fd_sc_hd__diode_2
XANTENNA__10373__A1 net37 vssd1 vssd1 vccd1 vccd1 sky130_fd_sc_hd__diode_2
X_10192_ _01765_ _05189_ _05192_ _01767_ _05181_ vssd1 vssd1 vccd1 vccd1 _05193_ sky130_fd_sc_hd__o311a_1
XFILLER_79_827 vssd1 vssd1 vccd1 vccd1 sky130_fd_sc_hd__fill_1
XANTENNA__10912__A3 net52 vssd1 vssd1 vccd1 vccd1 sky130_fd_sc_hd__diode_2
Xfanout350 _01829_ vssd1 vssd1 vccd1 vccd1 net350 sky130_fd_sc_hd__clkbuf_2
Xfanout372 cell3.CB_0.config_dataA\[16\] vssd1 vssd1 vccd1 vccd1 net372 sky130_fd_sc_hd__clkbuf_2
Xfanout383 cell3.CB_0.config_dataB\[15\] vssd1 vssd1 vccd1 vccd1 net383 sky130_fd_sc_hd__buf_2
X_13951_ clknet_leaf_42_clk net1146 net642 vssd1 vssd1 vccd1 vccd1 cell2.LEI0.config_data\[8\]
+ sky130_fd_sc_hd__dfrtp_1
XFILLER_93_329 vssd1 vssd1 vccd1 vccd1 sky130_fd_sc_hd__fill_4
Xfanout361 _01850_ vssd1 vssd1 vccd1 vccd1 net361 sky130_fd_sc_hd__clkbuf_4
Xfanout394 cell3.CB_1.config_dataA\[6\] vssd1 vssd1 vccd1 vccd1 net394 sky130_fd_sc_hd__clkbuf_2
XFILLER_86_392 vssd1 vssd1 vccd1 vccd1 sky130_fd_sc_hd__fill_4
XFILLER_86_370 vssd1 vssd1 vccd1 vccd1 sky130_fd_sc_hd__fill_1
X_12902_ net364 net365 net939 vssd1 vssd1 vccd1 vccd1 _01331_ sky130_fd_sc_hd__mux2_1
XTAP_TAPCELL_ROW_6_396 vssd1 vccd1 sky130_fd_sc_hd__tapvpwrvgnd_1
X_13882_ clknet_leaf_53_clk net1042 net715 vssd1 vssd1 vccd1 vccd1 cell2.LE_1A.config_data\[5\]
+ sky130_fd_sc_hd__dfrtp_1
X_12833_ cell2.SB0.route_sel\[75\] cell2.SB0.route_sel\[74\] net778 vssd1 vssd1 vccd1
+ vccd1 _01262_ sky130_fd_sc_hd__mux2_1
XFILLER_46_289 vssd1 vssd1 vccd1 vccd1 sky130_fd_sc_hd__fill_1
XFILLER_15_610 vssd1 vssd1 vccd1 vccd1 sky130_fd_sc_hd__fill_1
XFILLER_27_470 vssd1 vssd1 vccd1 vccd1 sky130_fd_sc_hd__fill_1
XTAP_TAPCELL_ROW_83_1555 vssd1 vccd1 sky130_fd_sc_hd__tapvpwrvgnd_1
X_12764_ cell2.SB0.route_sel\[6\] cell2.SB0.route_sel\[5\] net795 vssd1 vssd1 vccd1
+ vccd1 _01193_ sky130_fd_sc_hd__mux2_1
XFILLER_15_632 vssd1 vssd1 vccd1 vccd1 sky130_fd_sc_hd__fill_1
X_11715_ net1185 cell0.LE_0B.config_data\[10\] net803 vssd1 vssd1 vccd1 vccd1 _00154_
+ sky130_fd_sc_hd__mux2_1
X_12695_ cell3.CB_1.config_dataA\[12\] net392 net941 vssd1 vssd1 vccd1 vccd1 _01124_
+ sky130_fd_sc_hd__mux2_1
XANTENNA_input92_X net92 vssd1 vssd1 vccd1 vccd1 sky130_fd_sc_hd__diode_2
XTAP_TAPCELL_ROW_25_682 vssd1 vccd1 sky130_fd_sc_hd__tapvpwrvgnd_1
X_14434_ clknet_1_0__leaf_cell3.LE_0A.sel_clk _01406_ net752 vssd1 vssd1 vccd1 vccd1
+ cell3.LE_0A.dff0_out sky130_fd_sc_hd__dfrtp_1
X_11646_ cell0.CB_0.config_dataA\[17\] net511 net770 vssd1 vssd1 vccd1 vccd1 _00087_
+ sky130_fd_sc_hd__mux2_1
Xinput36 CBnorth_in[12] vssd1 vssd1 vccd1 vccd1 net36 sky130_fd_sc_hd__buf_2
Xinput25 CBeast_in[31] vssd1 vssd1 vccd1 vccd1 net25 sky130_fd_sc_hd__buf_2
Xinput14 CBeast_in[21] vssd1 vssd1 vccd1 vccd1 net14 sky130_fd_sc_hd__clkbuf_4
XANTENNA__09451__C1 _04471_ vssd1 vssd1 vccd1 vccd1 sky130_fd_sc_hd__diode_2
XANTENNA__09169__Y _04197_ vssd1 vssd1 vccd1 vccd1 sky130_fd_sc_hd__diode_2
X_14365_ clknet_leaf_74_clk _01337_ net729 vssd1 vssd1 vccd1 vccd1 cell3.CB_1.config_dataB\[22\]
+ sky130_fd_sc_hd__dfstp_1
X_11577_ net1512 cell0.LE_1B.edge_mode net803 vssd1 vssd1 vccd1 vccd1 _00018_ sky130_fd_sc_hd__mux2_1
Xclkbuf_leaf_103_clk clknet_4_10_0_clk vssd1 vssd1 vccd1 vccd1 clknet_leaf_103_clk
+ sky130_fd_sc_hd__clkbuf_8
Xinput47 CBnorth_in[22] vssd1 vssd1 vccd1 vccd1 net47 sky130_fd_sc_hd__clkbuf_4
Xinput58 CBnorth_in[3] vssd1 vssd1 vccd1 vccd1 net58 sky130_fd_sc_hd__buf_2
XTAP_TAPCELL_ROW_114_2021 vssd1 vccd1 sky130_fd_sc_hd__tapvpwrvgnd_1
X_10528_ _01788_ net394 vssd1 vssd1 vccd1 vccd1 _05486_ sky130_fd_sc_hd__or2_1
X_14296_ clknet_leaf_15_clk _01268_ net625 vssd1 vssd1 vccd1 vccd1 cell2.SB0.route_sel\[81\]
+ sky130_fd_sc_hd__dfstp_1
X_13316_ clknet_leaf_88_clk _00288_ net688 vssd1 vssd1 vccd1 vccd1 cell1.CB_0.config_dataB\[7\]
+ sky130_fd_sc_hd__dfstp_1
XFILLER_6_330 vssd1 vssd1 vccd1 vccd1 sky130_fd_sc_hd__fill_4
Xinput69 SBsouth_in[13] vssd1 vssd1 vccd1 vccd1 net69 sky130_fd_sc_hd__buf_2
XANTENNA__08006__A0 bus2_0\[6\] vssd1 vssd1 vccd1 vccd1 sky130_fd_sc_hd__diode_2
X_13247_ clknet_leaf_121_clk net1362 net594 vssd1 vssd1 vccd1 vccd1 cell0.LEI0.config_data\[32\]
+ sky130_fd_sc_hd__dfrtp_1
XANTENNA__12751__S net929 vssd1 vssd1 vccd1 vccd1 sky130_fd_sc_hd__diode_2
X_10459_ _05446_ _04602_ vssd1 vssd1 vccd1 vccd1 bus3_2\[10\] sky130_fd_sc_hd__and2b_2
X_13178_ clknet_leaf_14_clk net1211 net599 vssd1 vssd1 vccd1 vccd1 cell0.LE_0B.config_data\[7\]
+ sky130_fd_sc_hd__dfrtp_1
XFILLER_69_337 vssd1 vssd1 vccd1 vccd1 sky130_fd_sc_hd__fill_1
X_12129_ cell1.LEI0.config_data\[11\] net1446 net899 vssd1 vssd1 vccd1 vccd1 _00562_
+ sky130_fd_sc_hd__mux2_1
XFILLER_93_841 vssd1 vssd1 vccd1 vccd1 sky130_fd_sc_hd__fill_1
XFILLER_93_830 vssd1 vssd1 vccd1 vccd1 sky130_fd_sc_hd__fill_1
XANTENNA__10667__A2 _04362_ vssd1 vssd1 vccd1 vccd1 sky130_fd_sc_hd__diode_2
X_07670_ _01592_ cell0.SB0.route_sel\[22\] cell0.SB0.route_sel\[17\] _01817_ _02717_
+ vssd1 vssd1 vccd1 vccd1 _02718_ sky130_fd_sc_hd__a221o_2
XTAP_TAPCELL_ROW_125_2183 vssd1 vccd1 sky130_fd_sc_hd__tapvpwrvgnd_1
XANTENNA__09809__A1 bus3_2\[7\] vssd1 vssd1 vccd1 vccd1 sky130_fd_sc_hd__diode_2
X_06621_ cell3.SB0.route_sel\[19\] vssd1 vssd1 vccd1 vccd1 _01691_ sky130_fd_sc_hd__inv_2
X_09340_ _04216_ _04363_ net43 vssd1 vssd1 vccd1 vccd1 _04365_ sky130_fd_sc_hd__a21oi_1
X_06552_ cell2.SB0.route_sel\[71\] vssd1 vssd1 vccd1 vccd1 _01622_ sky130_fd_sc_hd__inv_2
X_09271_ _01586_ cell2.SB0.route_sel\[17\] _01588_ cell2.SB0.route_sel\[22\] _04296_
+ vssd1 vssd1 vccd1 vccd1 _04297_ sky130_fd_sc_hd__a221o_2
XANTENNA__07296__A1 _02327_ vssd1 vssd1 vccd1 vccd1 sky130_fd_sc_hd__diode_2
X_08222_ cell0.LEI0.config_data\[32\] _03261_ vssd1 vssd1 vccd1 vccd1 _03262_ sky130_fd_sc_hd__nor2_1
X_06483_ cell1.SB0.route_sel\[124\] vssd1 vssd1 vccd1 vccd1 _01553_ sky130_fd_sc_hd__inv_2
XFILLER_138_309 vssd1 vssd1 vccd1 vccd1 sky130_fd_sc_hd__fill_1
X_08153_ cell0.CB_1.config_dataA\[2\] _03189_ _03191_ _03192_ _03187_ vssd1 vssd1
+ vccd1 vccd1 _03193_ sky130_fd_sc_hd__o221a_1
XANTENNA__07048__A1 net339 vssd1 vssd1 vccd1 vccd1 sky130_fd_sc_hd__diode_2
X_07104_ net301 _02165_ _02163_ vssd1 vssd1 vccd1 vccd1 _02167_ sky130_fd_sc_hd__o21ba_1
X_08084_ net523 net524 vssd1 vssd1 vccd1 vccd1 _03126_ sky130_fd_sc_hd__and2b_1
X_07035_ cell2.CB_0.config_dataA\[22\] cell2.CB_0.config_dataA\[23\] vssd1 vssd1 vccd1
+ vccd1 _02100_ sky130_fd_sc_hd__nand2b_1
XANTENNA__10355__B2 _05156_ vssd1 vssd1 vccd1 vccd1 sky130_fd_sc_hd__diode_2
XANTENNA__10355__A1 _05152_ vssd1 vssd1 vccd1 vccd1 sky130_fd_sc_hd__diode_2
XTAP_TAPCELL_ROW_54_1123 vssd1 vccd1 sky130_fd_sc_hd__tapvpwrvgnd_1
XTAP_TAPCELL_ROW_54_1112 vssd1 vccd1 sky130_fd_sc_hd__tapvpwrvgnd_1
XANTENNA__07608__X bus1_0\[0\] vssd1 vssd1 vccd1 vccd1 sky130_fd_sc_hd__diode_2
X_08986_ _04017_ _04010_ _04006_ vssd1 vssd1 vccd1 vccd1 _04018_ sky130_fd_sc_hd__mux2_1
X_07937_ net513 _01986_ vssd1 vssd1 vccd1 vccd1 _02981_ sky130_fd_sc_hd__nand2_1
XFILLER_29_702 vssd1 vssd1 vccd1 vccd1 sky130_fd_sc_hd__fill_1
XANTENNA_fanout756_A net131 vssd1 vssd1 vccd1 vccd1 sky130_fd_sc_hd__diode_2
XFILLER_113_55 vssd1 vssd1 vccd1 vccd1 sky130_fd_sc_hd__fill_1
X_07868_ bus2_0\[0\] bus2_0\[1\] bus2_0\[2\] bus2_0\[3\] net518 net517 vssd1 vssd1
+ vccd1 vccd1 _02912_ sky130_fd_sc_hd__mux4_1
XTAP_TAPCELL_ROW_3_355 vssd1 vccd1 sky130_fd_sc_hd__tapvpwrvgnd_1
X_09607_ net381 net380 _04363_ vssd1 vssd1 vccd1 vccd1 _04624_ sky130_fd_sc_hd__nand3b_1
XANTENNA_fanout923_A net934 vssd1 vssd1 vccd1 vccd1 sky130_fd_sc_hd__diode_2
XFILLER_83_362 vssd1 vssd1 vccd1 vccd1 sky130_fd_sc_hd__fill_1
XFILLER_73_26 vssd1 vssd1 vccd1 vccd1 sky130_fd_sc_hd__fill_1
XFILLER_56_587 vssd1 vssd1 vccd1 vccd1 sky130_fd_sc_hd__fill_1
X_06819_ cell1.CB_0.config_dataB\[23\] cell1.CB_0.config_dataB\[22\] vssd1 vssd1 vccd1
+ vccd1 _01889_ sky130_fd_sc_hd__and2b_1
X_07799_ cell0.SB0.route_sel\[44\] cell0.SB0.route_sel\[45\] vssd1 vssd1 vccd1 vccd1
+ _02844_ sky130_fd_sc_hd__or2_1
X_09538_ cell3.SB0.route_sel\[77\] cell3.SB0.route_sel\[76\] vssd1 vssd1 vccd1 vccd1
+ _04557_ sky130_fd_sc_hd__nand2_2
X_11500_ _01599_ cell2.SB0.route_sel\[34\] _01602_ cell2.SB0.route_sel\[37\] _06333_
+ vssd1 vssd1 vccd1 vccd1 _06334_ sky130_fd_sc_hd__a221o_1
X_09469_ net552 _04490_ vssd1 vssd1 vccd1 vccd1 _04491_ sky130_fd_sc_hd__nand2_1
XTAP_TAPCELL_ROW_65_1285 vssd1 vccd1 sky130_fd_sc_hd__tapvpwrvgnd_1
XTAP_TAPCELL_ROW_42_939 vssd1 vccd1 sky130_fd_sc_hd__tapvpwrvgnd_1
X_12480_ cell2.LE_0A.edge_mode net1127 net833 vssd1 vssd1 vccd1 vccd1 _00910_ sky130_fd_sc_hd__mux2_1
XFILLER_7_105 vssd1 vssd1 vccd1 vccd1 sky130_fd_sc_hd__fill_4
XFILLER_12_657 vssd1 vssd1 vccd1 vccd1 sky130_fd_sc_hd__fill_4
XTAP_TAPCELL_ROW_22_641 vssd1 vccd1 sky130_fd_sc_hd__tapvpwrvgnd_1
X_11431_ cell0.SB0.route_sel\[112\] cell0.SB0.route_sel\[113\] _01483_ cell0.SB0.route_sel\[116\]
+ _06287_ vssd1 vssd1 vccd1 vccd1 _06288_ sky130_fd_sc_hd__o221a_1
XFILLER_22_41 vccd1 vssd1 vccd1 vssd1 sky130_ef_sc_hd__decap_40_12
XFILLER_138_41 vccd1 vssd1 vccd1 vssd1 sky130_ef_sc_hd__decap_40_12
X_11362_ net737 cell3.LE_1A.reset_mode vssd1 vssd1 vccd1 vccd1 _11362_/X sky130_fd_sc_hd__xor2_2
X_14150_ clknet_leaf_69_clk _01122_ net732 vssd1 vssd1 vccd1 vccd1 cell3.CB_1.config_dataA\[10\]
+ sky130_fd_sc_hd__dfstp_1
XFILLER_138_85 vccd1 vssd1 vccd1 vssd1 sky130_ef_sc_hd__decap_40_12
X_10313_ net435 net433 vssd1 vssd1 vccd1 vccd1 _05312_ sky130_fd_sc_hd__nor2_1
XANTENNA__08902__X _03934_ vssd1 vssd1 vccd1 vccd1 sky130_fd_sc_hd__diode_2
X_13101_ clknet_leaf_5_clk _00073_ net564 vssd1 vssd1 vccd1 vccd1 cell0.CB_0.config_dataA\[3\]
+ sky130_fd_sc_hd__dfstp_1
XFILLER_125_559 vssd1 vssd1 vccd1 vccd1 sky130_fd_sc_hd__fill_1
X_14081_ clknet_leaf_79_clk _01053_ net709 vssd1 vssd1 vccd1 vccd1 cell3.SB0.route_sel\[89\]
+ sky130_fd_sc_hd__dfstp_1
X_11293_ net287 _05513_ _04211_ vssd1 vssd1 vccd1 vccd1 _06211_ sky130_fd_sc_hd__mux2_1
XFILLER_3_333 vssd1 vssd1 vccd1 vccd1 sky130_fd_sc_hd__fill_2
XANTENNA_input52_A CBnorth_in[27] vssd1 vssd1 vccd1 vccd1 sky130_fd_sc_hd__diode_2
X_10244_ net60 _05235_ _05236_ net59 cell2.CB_0.config_dataA\[18\] vssd1 vssd1 vccd1
+ vccd1 _05245_ sky130_fd_sc_hd__a221o_1
X_13032_ clknet_leaf_119_clk _00004_ net595 vssd1 vssd1 vccd1 vccd1 cell0.LE_1B.config_data\[4\]
+ sky130_fd_sc_hd__dfrtp_1
XANTENNA__07518__X _02570_ vssd1 vssd1 vccd1 vccd1 sky130_fd_sc_hd__diode_2
X_10175_ net61 net62 net422 vssd1 vssd1 vccd1 vccd1 _05176_ sky130_fd_sc_hd__mux2_1
XANTENNA__09733__X bus2_0\[0\] vssd1 vssd1 vccd1 vccd1 sky130_fd_sc_hd__diode_2
XANTENNA__07762__A2 net358 vssd1 vssd1 vccd1 vccd1 sky130_fd_sc_hd__diode_2
XFILLER_75_841 vssd1 vssd1 vccd1 vccd1 sky130_fd_sc_hd__fill_1
XANTENNA__06970__B1 _02029_ vssd1 vssd1 vccd1 vccd1 sky130_fd_sc_hd__diode_2
X_13934_ clknet_leaf_25_clk net1040 net619 vssd1 vssd1 vccd1 vccd1 cell2.LE_0A.config_data\[13\]
+ sky130_fd_sc_hd__dfrtp_1
XANTENNA__10649__A2 _05540_ vssd1 vssd1 vccd1 vccd1 sky130_fd_sc_hd__diode_2
X_13865_ clknet_leaf_43_clk _00837_ net627 vssd1 vssd1 vccd1 vccd1 cell2.CB_1.config_dataB\[14\]
+ sky130_fd_sc_hd__dfstp_1
X_12816_ cell2.SB0.route_sel\[58\] cell2.SB0.route_sel\[57\] net810 vssd1 vssd1 vccd1
+ vccd1 _01245_ sky130_fd_sc_hd__mux2_1
X_13796_ clknet_leaf_112_clk _00768_ net661 vssd1 vssd1 vccd1 vccd1 cell1.SB0.route_sel\[73\]
+ sky130_fd_sc_hd__dfstp_2
X_12747_ cell3.CB_0.config_dataA\[14\] cell3.CB_0.config_dataA\[13\] net929 vssd1
+ vssd1 vccd1 vccd1 _01176_ sky130_fd_sc_hd__mux2_1
X_12678_ net1304 cell3.LE_1B.config_data\[14\] net953 vssd1 vssd1 vccd1 vccd1 _01107_
+ sky130_fd_sc_hd__mux2_1
X_14417_ clknet_leaf_55_clk net1135 net717 vssd1 vssd1 vccd1 vccd1 cell3.LE_0A.config_data\[4\]
+ sky130_fd_sc_hd__dfrtp_1
X_11629_ cell0.CB_0.config_dataA\[0\] cell0.CB_0.config_data_inA net769 vssd1 vssd1
+ vccd1 vccd1 _00070_ sky130_fd_sc_hd__mux2_1
XFILLER_8_65 vccd1 vssd1 vccd1 vssd1 sky130_ef_sc_hd__decap_40_12
XANTENNA__12047__A net756 vssd1 vssd1 vccd1 vccd1 sky130_fd_sc_hd__diode_2
X_14348_ clknet_leaf_67_clk _01320_ net736 vssd1 vssd1 vccd1 vccd1 cell3.CB_1.config_dataB\[5\]
+ sky130_fd_sc_hd__dfstp_1
XTAP_TAPCELL_ROW_96_1746 vssd1 vccd1 sky130_fd_sc_hd__tapvpwrvgnd_1
XFILLER_116_559 vssd1 vssd1 vccd1 vccd1 sky130_fd_sc_hd__fill_1
X_14279_ clknet_leaf_21_clk _01251_ net605 vssd1 vssd1 vccd1 vccd1 cell2.SB0.route_sel\[64\]
+ sky130_fd_sc_hd__dfstp_1
XANTENNA__07450__A1 net322 vssd1 vssd1 vccd1 vccd1 sky130_fd_sc_hd__diode_2
XANTENNA__10337__A1 net64 vssd1 vssd1 vccd1 vccd1 sky130_fd_sc_hd__diode_2
X_08840_ _03831_ _03868_ _03871_ _03827_ cell1.CB_0.config_dataA\[7\] vssd1 vssd1
+ vccd1 vccd1 _03872_ sky130_fd_sc_hd__a221o_1
XANTENNA__07202__A1 _02257_ vssd1 vssd1 vccd1 vccd1 sky130_fd_sc_hd__diode_2
XTAP_TAPCELL_ROW_127_2212 vssd1 vccd1 sky130_fd_sc_hd__tapvpwrvgnd_1
XFILLER_69_167 vssd1 vssd1 vccd1 vccd1 sky130_fd_sc_hd__fill_1
XFILLER_69_145 vssd1 vssd1 vccd1 vccd1 sky130_fd_sc_hd__fill_1
XFILLER_58_819 vssd1 vssd1 vccd1 vccd1 sky130_fd_sc_hd__fill_1
XANTENNA__08950__A1 bus3_1\[1\] vssd1 vssd1 vccd1 vccd1 sky130_fd_sc_hd__diode_2
XFILLER_69_178 vssd1 vssd1 vccd1 vccd1 sky130_fd_sc_hd__fill_1
XFILLER_38_510 vssd1 vssd1 vccd1 vccd1 sky130_fd_sc_hd__fill_1
X_08771_ cell1.LE_1B.config_data\[13\] cell1.LE_1B.config_data\[12\] _03735_ vssd1
+ vssd1 vccd1 vccd1 _03805_ sky130_fd_sc_hd__mux2_1
XANTENNA_clkbuf_4_7_0_clk_A clknet_0_clk vssd1 vssd1 vccd1 vccd1 sky130_fd_sc_hd__diode_2
XTAP_TAPCELL_ROW_0_303 vssd1 vccd1 sky130_fd_sc_hd__tapvpwrvgnd_1
X_07722_ net320 net26 _02767_ vssd1 vssd1 vccd1 vccd1 _02769_ sky130_fd_sc_hd__mux2_1
XTAP_TAPCELL_ROW_140_2412 vssd1 vccd1 sky130_fd_sc_hd__tapvpwrvgnd_1
XTAP_TAPCELL_ROW_140_2401 vssd1 vccd1 sky130_fd_sc_hd__tapvpwrvgnd_1
XANTENNA__09091__A _04120_ vssd1 vssd1 vccd1 vccd1 sky130_fd_sc_hd__diode_2
XFILLER_53_524 vssd1 vssd1 vccd1 vccd1 sky130_fd_sc_hd__fill_1
XTAP_TAPCELL_ROW_0_314 vssd1 vccd1 sky130_fd_sc_hd__tapvpwrvgnd_1
X_07653_ net339 _01850_ net353 _02607_ _01847_ vssd1 vssd1 vccd1 vccd1 _02701_ sky130_fd_sc_hd__o32a_1
XFILLER_92_181 vssd1 vssd1 vccd1 vccd1 sky130_fd_sc_hd__fill_4
X_06604_ cell3.SB0.route_sel\[3\] vssd1 vssd1 vccd1 vccd1 _01674_ sky130_fd_sc_hd__inv_2
X_09323_ _04347_ _04345_ vssd1 vssd1 vccd1 vccd1 _04348_ sky130_fd_sc_hd__and2b_2
XFILLER_43_29 vssd1 vssd1 vccd1 vccd1 sky130_fd_sc_hd__fill_4
X_07584_ _02610_ _02630_ _02632_ _02611_ vssd1 vssd1 vccd1 vccd1 _02634_ sky130_fd_sc_hd__o31a_1
XTAP_TAPCELL_ROW_105_1886 vssd1 vccd1 sky130_fd_sc_hd__tapvpwrvgnd_1
X_06535_ cell0.SB0.route_sel\[39\] vssd1 vssd1 vccd1 vccd1 _01605_ sky130_fd_sc_hd__inv_2
XANTENNA__07269__A1 net340 vssd1 vssd1 vccd1 vccd1 sky130_fd_sc_hd__diode_2
XFILLER_138_117 vssd1 vssd1 vccd1 vccd1 sky130_fd_sc_hd__fill_1
X_09254_ _01903_ _04175_ vssd1 vssd1 vccd1 vccd1 _04280_ sky130_fd_sc_hd__nand2_1
X_06466_ cell1.SB0.route_sel\[91\] vssd1 vssd1 vccd1 vccd1 _01536_ sky130_fd_sc_hd__inv_2
XTAP_TAPCELL_ROW_138_2374 vssd1 vccd1 sky130_fd_sc_hd__tapvpwrvgnd_1
X_09185_ net293 _04212_ _04209_ vssd1 vssd1 vccd1 vccd1 _04213_ sky130_fd_sc_hd__mux2_1
X_08205_ cell0.CB_1.config_dataA\[13\] cell0.CB_1.config_dataA\[12\] vssd1 vssd1 vccd1
+ vccd1 _03245_ sky130_fd_sc_hd__nor2_1
XTAP_TAPCELL_ROW_138_2385 vssd1 vccd1 sky130_fd_sc_hd__tapvpwrvgnd_1
X_08136_ net546 _02560_ _03175_ vssd1 vssd1 vccd1 vccd1 _03176_ sky130_fd_sc_hd__a21o_1
X_06397_ cell0.SB0.route_sel\[68\] vssd1 vssd1 vccd1 vccd1 _01467_ sky130_fd_sc_hd__inv_2
XFILLER_107_526 vssd1 vssd1 vccd1 vccd1 sky130_fd_sc_hd__fill_4
XANTENNA__10576__A1 net18 vssd1 vssd1 vccd1 vccd1 sky130_fd_sc_hd__diode_2
XANTENNA__10040__A3 bus3_2\[15\] vssd1 vssd1 vccd1 vccd1 sky130_fd_sc_hd__diode_2
X_08067_ cell0.CB_0.config_dataB\[11\] _03106_ _03107_ _03108_ vssd1 vssd1 vccd1 vccd1
+ _03109_ sky130_fd_sc_hd__a31o_1
X_07018_ cell2.CB_1.config_dataB\[22\] cell2.CB_1.config_dataB\[23\] vssd1 vssd1 vccd1
+ vccd1 _02083_ sky130_fd_sc_hd__and2b_1
XTAP_TAPCELL_ROW_8_425 vssd1 vccd1 sky130_fd_sc_hd__tapvpwrvgnd_1
XANTENNA__09194__A1 net286 vssd1 vssd1 vccd1 vccd1 sky130_fd_sc_hd__diode_2
XFILLER_1_837 vssd1 vssd1 vccd1 vccd1 sky130_fd_sc_hd__fill_1
XFILLER_0_369 vssd1 vssd1 vccd1 vccd1 sky130_fd_sc_hd__fill_1
XFILLER_124_65 vssd1 vssd1 vccd1 vccd1 sky130_fd_sc_hd__fill_4
X_08969_ cell1.LEI0.config_data\[37\] _04000_ vssd1 vssd1 vccd1 vccd1 _04001_ sky130_fd_sc_hd__nor2_1
XFILLER_84_25 vssd1 vssd1 vccd1 vccd1 sky130_fd_sc_hd__fill_2
XANTENNA__09272__Y _04298_ vssd1 vssd1 vccd1 vccd1 sky130_fd_sc_hd__diode_2
X_11980_ cell0.SB0.route_sel\[86\] cell0.SB0.route_sel\[85\] net784 vssd1 vssd1 vccd1
+ vccd1 _00417_ sky130_fd_sc_hd__mux2_1
X_10931_ _01806_ cell3.CB_0.config_dataA\[1\] _05883_ _01805_ vssd1 vssd1 vccd1 vccd1
+ _05885_ sky130_fd_sc_hd__o31a_1
XANTENNA__11307__Y net148 vssd1 vssd1 vccd1 vccd1 sky130_fd_sc_hd__diode_2
XFILLER_84_682 vssd1 vssd1 vccd1 vccd1 sky130_fd_sc_hd__fill_8
XTAP_TAPCELL_ROW_67_1314 vssd1 vccd1 sky130_fd_sc_hd__tapvpwrvgnd_1
XANTENNA__07514__A net89 vssd1 vssd1 vccd1 vccd1 sky130_fd_sc_hd__diode_2
XANTENNA__07073__X _02137_ vssd1 vssd1 vccd1 vccd1 sky130_fd_sc_hd__diode_2
XTAP_TAPCELL_ROW_27_711 vssd1 vccd1 sky130_fd_sc_hd__tapvpwrvgnd_1
XFILLER_140_53 vccd1 vssd1 vccd1 vssd1 sky130_ef_sc_hd__decap_40_12
X_13650_ clknet_leaf_41_clk _00622_ net641 vssd1 vssd1 vccd1 vccd1 cell2.CB_1.config_dataA\[2\]
+ sky130_fd_sc_hd__dfstp_2
X_10862_ _05817_ vssd1 vssd1 vccd1 vccd1 _05818_ sky130_fd_sc_hd__inv_2
XTAP_TAPCELL_ROW_80_1503 vssd1 vccd1 sky130_fd_sc_hd__tapvpwrvgnd_1
XANTENNA__07801__X _02846_ vssd1 vssd1 vccd1 vccd1 sky130_fd_sc_hd__diode_2
XFILLER_140_97 vccd1 vssd1 vccd1 vssd1 sky130_ef_sc_hd__decap_40_12
X_10793_ _05513_ _05725_ _01779_ vssd1 vssd1 vccd1 vccd1 _05749_ sky130_fd_sc_hd__o21ai_1
XTAP_TAPCELL_ROW_80_1514 vssd1 vccd1 sky130_fd_sc_hd__tapvpwrvgnd_1
X_12601_ cell3.SB0.route_sel\[66\] cell3.SB0.route_sel\[65\] net910 vssd1 vssd1 vccd1
+ vccd1 _01030_ sky130_fd_sc_hd__mux2_1
X_13581_ clknet_leaf_89_clk net1376 net697 vssd1 vssd1 vccd1 vccd1 cell1.LEI0.config_data\[2\]
+ sky130_fd_sc_hd__dfrtp_1
X_12532_ net1421 net1438 net838 vssd1 vssd1 vccd1 vccd1 _00961_ sky130_fd_sc_hd__mux2_1
XFILLER_33_51 vssd1 vssd1 vccd1 vccd1 sky130_fd_sc_hd__fill_4
X_12463_ cell2.LE_0A.config_data\[0\] cell1.SB0.config_data_out net834 vssd1 vssd1
+ vccd1 vccd1 _00893_ sky130_fd_sc_hd__mux2_1
XANTENNA__07680__A1 net23 vssd1 vssd1 vccd1 vccd1 sky130_fd_sc_hd__diode_2
X_14202_ clknet_leaf_55_clk _01174_ net717 vssd1 vssd1 vccd1 vccd1 cell3.CB_0.config_dataA\[12\]
+ sky130_fd_sc_hd__dfstp_2
X_11414_ _02274_ _06276_ vssd1 vssd1 vccd1 vccd1 net232 sky130_fd_sc_hd__nor2_2
X_12394_ cell2.CB_1.config_dataB\[4\] cell2.CB_1.config_dataB\[3\] net837 vssd1 vssd1
+ vccd1 vccd1 _00827_ sky130_fd_sc_hd__mux2_1
XANTENNA_clkbuf_leaf_73_clk_A clknet_4_14_0_clk vssd1 vssd1 vccd1 vccd1 sky130_fd_sc_hd__diode_2
XANTENNA__11764__A0 cell0.LEI0.config_data\[14\] vssd1 vssd1 vccd1 vccd1 sky130_fd_sc_hd__diode_2
X_11345_ _05883_ cell3.CB_0.le_outB _04570_ vssd1 vssd1 vccd1 vccd1 _06238_ sky130_fd_sc_hd__mux2_1
X_14133_ clknet_leaf_66_clk net1166 net745 vssd1 vssd1 vccd1 vccd1 cell3.LE_1B.config_data\[13\]
+ sky130_fd_sc_hd__dfrtp_1
XTAP_TAPCELL_ROW_78_1476 vssd1 vccd1 sky130_fd_sc_hd__tapvpwrvgnd_1
XANTENNA_input55_X net55 vssd1 vssd1 vccd1 vccd1 sky130_fd_sc_hd__diode_2
XANTENNA__10319__A1 _05156_ vssd1 vssd1 vccd1 vccd1 sky130_fd_sc_hd__diode_2
X_11276_ net312 _02316_ _02317_ _06206_ vssd1 vssd1 vccd1 vccd1 net168 sky130_fd_sc_hd__a22o_2
X_14064_ clknet_leaf_82_clk _01036_ net701 vssd1 vssd1 vccd1 vccd1 cell3.SB0.route_sel\[72\]
+ sky130_fd_sc_hd__dfstp_1
XANTENNA__10319__B2 _05152_ vssd1 vssd1 vccd1 vccd1 sky130_fd_sc_hd__diode_2
X_13015_ net1479 net1414 net951 vssd1 vssd1 vccd1 vccd1 _01443_ sky130_fd_sc_hd__mux2_1
X_10227_ _01822_ net305 net315 net302 cell2.LEI0.config_data\[24\] cell2.LEI0.config_data\[25\]
+ vssd1 vssd1 vccd1 vccd1 _05228_ sky130_fd_sc_hd__mux4_1
XANTENNA_output256_A net256 vssd1 vssd1 vccd1 vccd1 sky130_fd_sc_hd__diode_2
XFILLER_4_697 vssd1 vssd1 vccd1 vccd1 sky130_fd_sc_hd__fill_2
XTAP_TAPCELL_ROW_91_1676 vssd1 vccd1 sky130_fd_sc_hd__tapvpwrvgnd_1
XANTENNA_clkbuf_leaf_88_clk_A clknet_4_11_0_clk vssd1 vssd1 vccd1 vccd1 sky130_fd_sc_hd__diode_2
X_10158_ _05098_ _05156_ _05158_ _05149_ _05153_ vssd1 vssd1 vccd1 vccd1 _05159_ sky130_fd_sc_hd__a2111oi_1
XFILLER_66_104 vssd1 vssd1 vccd1 vccd1 sky130_fd_sc_hd__fill_1
Xhold3 cell1.LE_1B.dff0_out vssd1 vssd1 vccd1 vccd1 net962 sky130_fd_sc_hd__dlygate4sd3_1
XANTENNA_clkbuf_leaf_131_clk_A clknet_4_0_0_clk vssd1 vssd1 vccd1 vccd1 sky130_fd_sc_hd__diode_2
X_10089_ cell2.SB0.route_sel\[75\] cell2.SB0.route_sel\[74\] vssd1 vssd1 vccd1 vccd1
+ _05090_ sky130_fd_sc_hd__nor2_1
X_13917_ clknet_leaf_36_clk _00889_ net639 vssd1 vssd1 vccd1 vccd1 cell2.LE_0B.reset_val
+ sky130_fd_sc_hd__dfrtp_1
XFILLER_75_671 vssd1 vssd1 vccd1 vccd1 sky130_fd_sc_hd__fill_1
XANTENNA_clkbuf_leaf_11_clk_A clknet_4_3_0_clk vssd1 vssd1 vccd1 vccd1 sky130_fd_sc_hd__diode_2
XTAP_TAPCELL_ROW_122_2142 vssd1 vccd1 sky130_fd_sc_hd__tapvpwrvgnd_1
XTAP_TAPCELL_ROW_122_2131 vssd1 vccd1 sky130_fd_sc_hd__tapvpwrvgnd_1
X_13848_ clknet_leaf_120_clk _00820_ net665 vssd1 vssd1 vccd1 vccd1 cell1.SB0.route_sel\[125\]
+ sky130_fd_sc_hd__dfstp_1
XANTENNA__11047__A2 net56 vssd1 vssd1 vccd1 vccd1 sky130_fd_sc_hd__diode_2
XANTENNA__12476__S net824 vssd1 vssd1 vccd1 vccd1 sky130_fd_sc_hd__diode_2
XANTENNA_clkbuf_leaf_26_clk_A clknet_4_4_0_clk vssd1 vssd1 vccd1 vccd1 sky130_fd_sc_hd__diode_2
XFILLER_95_3 vccd1 vssd1 vccd1 vssd1 sky130_ef_sc_hd__decap_40_12
X_13779_ clknet_leaf_109_clk _00751_ net652 vssd1 vssd1 vccd1 vccd1 cell1.SB0.route_sel\[56\]
+ sky130_fd_sc_hd__dfstp_2
XANTENNA__07120__A0 net64 vssd1 vssd1 vccd1 vccd1 sky130_fd_sc_hd__diode_2
Xclkbuf_4_4_0_clk clknet_0_clk vssd1 vssd1 vccd1 vccd1 clknet_4_4_0_clk sky130_fd_sc_hd__clkbuf_8
XFILLER_129_673 vssd1 vssd1 vccd1 vccd1 sky130_fd_sc_hd__fill_1
Xhold414 _01436_ vssd1 vssd1 vccd1 vccd1 net1373 sky130_fd_sc_hd__dlygate4sd3_1
Xhold436 _01409_ vssd1 vssd1 vccd1 vccd1 net1395 sky130_fd_sc_hd__dlygate4sd3_1
Xhold403 _00219_ vssd1 vssd1 vccd1 vccd1 net1362 sky130_fd_sc_hd__dlygate4sd3_1
Xhold425 cell1.CB_0.config_data_inA vssd1 vssd1 vccd1 vccd1 net1384 sky130_fd_sc_hd__dlygate4sd3_1
XANTENNA__07423__A1 net361 vssd1 vssd1 vccd1 vccd1 sky130_fd_sc_hd__diode_2
Xhold469 cell2.LEI0.config_data\[4\] vssd1 vssd1 vccd1 vccd1 net1428 sky130_fd_sc_hd__dlygate4sd3_1
Xhold447 cell3.LE_1A.config_data\[2\] vssd1 vssd1 vccd1 vccd1 net1406 sky130_fd_sc_hd__dlygate4sd3_1
X_09941_ bus3_2\[12\] bus3_2\[14\] bus3_2\[13\] bus3_2\[15\] net408 net410 vssd1 vssd1
+ vccd1 vccd1 _04945_ sky130_fd_sc_hd__mux4_1
Xhold458 cell0.LEI0.config_data\[28\] vssd1 vssd1 vccd1 vccd1 net1417 sky130_fd_sc_hd__dlygate4sd3_1
Xfanout916 net934 vssd1 vssd1 vccd1 vccd1 net916 sky130_fd_sc_hd__clkbuf_2
Xfanout905 net907 vssd1 vssd1 vccd1 vccd1 net905 sky130_fd_sc_hd__clkbuf_4
Xfanout949 net952 vssd1 vssd1 vccd1 vccd1 net949 sky130_fd_sc_hd__clkbuf_4
Xfanout927 net929 vssd1 vssd1 vccd1 vccd1 net927 sky130_fd_sc_hd__clkbuf_4
X_09872_ _04555_ _04875_ _04877_ _04874_ cell2.CB_1.config_dataA\[17\] vssd1 vssd1
+ vccd1 vccd1 _04878_ sky130_fd_sc_hd__a2111o_1
Xfanout938 net940 vssd1 vssd1 vccd1 vccd1 net938 sky130_fd_sc_hd__clkbuf_4
X_08823_ _03822_ _03832_ _03846_ _03854_ vssd1 vssd1 vccd1 vccd1 _03855_ sky130_fd_sc_hd__o22a_1
XFILLER_58_649 vssd1 vssd1 vccd1 vccd1 sky130_fd_sc_hd__fill_1
XFILLER_38_29 vccd1 vssd1 vccd1 vssd1 sky130_ef_sc_hd__decap_40_12
XANTENNA__11408__X net231 vssd1 vssd1 vccd1 vccd1 sky130_fd_sc_hd__diode_2
X_08754_ net29 net30 net453 vssd1 vssd1 vccd1 vccd1 _03788_ sky130_fd_sc_hd__mux2_1
XANTENNA__10679__B _05635_ vssd1 vssd1 vccd1 vccd1 sky130_fd_sc_hd__diode_2
XTAP_TAPCELL_ROW_107_1915 vssd1 vccd1 sky130_fd_sc_hd__tapvpwrvgnd_1
XFILLER_73_619 vssd1 vssd1 vccd1 vccd1 sky130_fd_sc_hd__fill_1
XFILLER_54_811 vssd1 vssd1 vccd1 vccd1 sky130_fd_sc_hd__fill_1
XANTENNA__08687__A0 net1 vssd1 vssd1 vccd1 vccd1 sky130_fd_sc_hd__diode_2
X_07705_ _02750_ _02751_ _02747_ _02748_ vssd1 vssd1 vccd1 vccd1 _02752_ sky130_fd_sc_hd__a2bb2o_1
XFILLER_81_630 vccd1 vssd1 vccd1 vssd1 sky130_ef_sc_hd__decap_40_12
Xclkbuf_leaf_92_clk clknet_4_11_0_clk vssd1 vssd1 vccd1 vccd1 clknet_leaf_92_clk sky130_fd_sc_hd__clkbuf_8
XTAP_TAPCELL_ROW_49_1044 vssd1 vccd1 sky130_fd_sc_hd__tapvpwrvgnd_1
X_08685_ net461 _03533_ _03718_ net460 vssd1 vssd1 vccd1 vccd1 _03719_ sky130_fd_sc_hd__o211a_1
XFILLER_41_505 vssd1 vssd1 vccd1 vccd1 sky130_fd_sc_hd__fill_1
X_07636_ net449 net450 _02143_ vssd1 vssd1 vccd1 vccd1 _02685_ sky130_fd_sc_hd__or3_1
XANTENNA_fanout621_A net622 vssd1 vssd1 vccd1 vccd1 sky130_fd_sc_hd__diode_2
X_07567_ cell0.SB0.route_sel\[4\] cell0.SB0.route_sel\[5\] net65 vssd1 vssd1 vccd1
+ vccd1 _02617_ sky130_fd_sc_hd__a21boi_1
XANTENNA_fanout719_A net724 vssd1 vssd1 vccd1 vccd1 sky130_fd_sc_hd__diode_2
XFILLER_110_45 vssd1 vssd1 vccd1 vccd1 sky130_fd_sc_hd__fill_2
X_09306_ cell2.SB0.route_sel\[31\] cell2.SB0.route_sel\[30\] _04330_ vssd1 vssd1 vccd1
+ vccd1 _04331_ sky130_fd_sc_hd__a21bo_1
X_06518_ cell2.SB0.route_sel\[23\] vssd1 vssd1 vccd1 vccd1 _01588_ sky130_fd_sc_hd__inv_2
XTAP_TAPCELL_ROW_62_1244 vssd1 vccd1 sky130_fd_sc_hd__tapvpwrvgnd_1
XTAP_TAPCELL_ROW_62_1233 vssd1 vccd1 sky130_fd_sc_hd__tapvpwrvgnd_1
XANTENNA__10797__A1 net279 vssd1 vssd1 vccd1 vccd1 sky130_fd_sc_hd__diode_2
X_09237_ _04233_ _04240_ _04263_ _04236_ vssd1 vssd1 vccd1 vccd1 _04264_ sky130_fd_sc_hd__a31o_1
X_07498_ _01943_ _02336_ vssd1 vssd1 vccd1 vccd1 _02550_ sky130_fd_sc_hd__nor2_1
XANTENNA__10261__A3 net302 vssd1 vssd1 vccd1 vccd1 sky130_fd_sc_hd__diode_2
XANTENNA__09939__A0 bus3_2\[8\] vssd1 vssd1 vccd1 vccd1 sky130_fd_sc_hd__diode_2
XANTENNA__11303__B _05483_ vssd1 vssd1 vccd1 vccd1 sky130_fd_sc_hd__diode_2
X_06449_ cell1.SB0.route_sel\[52\] vssd1 vssd1 vccd1 vccd1 _01519_ sky130_fd_sc_hd__inv_2
XTAP_TAPCELL_ROW_32_791 vssd1 vccd1 sky130_fd_sc_hd__tapvpwrvgnd_1
X_09168_ _01564_ cell2.SB0.route_sel\[1\] _01566_ cell2.SB0.route_sel\[6\] _04195_
+ vssd1 vssd1 vccd1 vccd1 _04196_ sky130_fd_sc_hd__a221o_2
X_08119_ _03160_ _03159_ _03057_ vssd1 vssd1 vccd1 vccd1 _03161_ sky130_fd_sc_hd__mux2_1
X_09099_ net475 net476 vssd1 vssd1 vccd1 vccd1 _04129_ sky130_fd_sc_hd__and2b_1
XANTENNA__12415__A net755 vssd1 vssd1 vccd1 vccd1 sky130_fd_sc_hd__diode_2
X_11130_ net386 _06077_ _06081_ vssd1 vssd1 vccd1 vccd1 _06082_ sky130_fd_sc_hd__a21o_1
XANTENNA__07068__X _02132_ vssd1 vssd1 vccd1 vccd1 sky130_fd_sc_hd__diode_2
XFILLER_0_100 vssd1 vssd1 vccd1 vccd1 sky130_fd_sc_hd__fill_4
X_11061_ net47 net48 cell3.CB_0.config_dataA\[15\] vssd1 vssd1 vccd1 vccd1 _06015_
+ sky130_fd_sc_hd__mux2_1
XANTENNA__07178__B1 net115 vssd1 vssd1 vccd1 vccd1 sky130_fd_sc_hd__diode_2
XFILLER_0_122 vssd1 vssd1 vccd1 vccd1 sky130_fd_sc_hd__fill_8
X_10012_ bus3_2\[0\] bus3_2\[2\] bus3_2\[1\] bus3_2\[3\] cell2.CB_1.config_dataB\[11\]
+ net403 vssd1 vssd1 vccd1 vccd1 _05016_ sky130_fd_sc_hd__mux4_1
XFILLER_95_57 vccd1 vssd1 vccd1 vssd1 sky130_ef_sc_hd__decap_40_12
XFILLER_88_262 vssd1 vssd1 vccd1 vccd1 sky130_fd_sc_hd__fill_1
XANTENNA__08914__A1 bus3_1\[7\] vssd1 vssd1 vccd1 vccd1 sky130_fd_sc_hd__diode_2
XFILLER_0_177 vssd1 vssd1 vccd1 vccd1 sky130_fd_sc_hd__fill_1
XFILLER_0_166 vssd1 vssd1 vccd1 vccd1 sky130_fd_sc_hd__fill_2
XANTENNA__08390__A2 _02211_ vssd1 vssd1 vccd1 vccd1 sky130_fd_sc_hd__diode_2
XANTENNA_input15_A CBeast_in[22] vssd1 vssd1 vccd1 vccd1 sky130_fd_sc_hd__diode_2
XANTENNA__11277__A2 _05113_ vssd1 vssd1 vccd1 vccd1 sky130_fd_sc_hd__diode_2
Xclkbuf_leaf_83_clk clknet_4_9_0_clk vssd1 vssd1 vccd1 vccd1 clknet_leaf_83_clk sky130_fd_sc_hd__clkbuf_8
XFILLER_17_546 vssd1 vssd1 vccd1 vccd1 sky130_fd_sc_hd__fill_1
XFILLER_29_395 vssd1 vssd1 vccd1 vccd1 sky130_fd_sc_hd__fill_1
X_11963_ cell0.SB0.route_sel\[69\] cell0.SB0.route_sel\[68\] net764 vssd1 vssd1 vccd1
+ vccd1 _00400_ sky130_fd_sc_hd__mux2_1
X_10914_ cell3.CB_0.config_dataA\[2\] _05867_ _05865_ cell3.CB_0.config_dataA\[3\]
+ vssd1 vssd1 vccd1 vccd1 _05868_ sky130_fd_sc_hd__o211a_1
X_13702_ clknet_leaf_27_clk _00674_ net621 vssd1 vssd1 vccd1 vccd1 cell2.CB_0.config_dataA\[4\]
+ sky130_fd_sc_hd__dfstp_1
XANTENNA__09730__Y bus3_1\[15\] vssd1 vssd1 vccd1 vccd1 sky130_fd_sc_hd__diode_2
X_11894_ cell0.SB0.route_sel\[0\] cell0.CB_1.config_dataB\[24\] net782 vssd1 vssd1
+ vccd1 vccd1 _00331_ sky130_fd_sc_hd__mux2_1
X_13633_ clknet_leaf_39_clk _00605_ net647 vssd1 vssd1 vccd1 vccd1 cell2.LE_1B.config_data\[5\]
+ sky130_fd_sc_hd__dfrtp_1
X_10845_ cell3.CB_1.config_dataB\[17\] _05800_ vssd1 vssd1 vccd1 vccd1 _05801_ sky130_fd_sc_hd__nand2_1
XANTENNA__07250__Y _02309_ vssd1 vssd1 vccd1 vccd1 sky130_fd_sc_hd__diode_2
X_10776_ _05730_ _05731_ cell3.CB_1.config_dataB\[7\] vssd1 vssd1 vccd1 vccd1 _05732_
+ sky130_fd_sc_hd__mux2_1
XANTENNA__10788__A1 net13 vssd1 vssd1 vccd1 vccd1 sky130_fd_sc_hd__diode_2
XANTENNA__10788__B2 net14 vssd1 vssd1 vccd1 vccd1 sky130_fd_sc_hd__diode_2
X_13564_ clknet_leaf_118_clk net1292 net668 vssd1 vssd1 vccd1 vccd1 cell1.LE_0A.config_data\[7\]
+ sky130_fd_sc_hd__dfrtp_1
XFILLER_12_240 vssd1 vssd1 vccd1 vccd1 sky130_fd_sc_hd__fill_1
XANTENNA__08445__A3 net7 vssd1 vssd1 vccd1 vccd1 sky130_fd_sc_hd__diode_2
X_12515_ cell2.LEI0.config_data\[29\] net1470 net843 vssd1 vssd1 vccd1 vccd1 _00944_
+ sky130_fd_sc_hd__mux2_1
X_13495_ clknet_leaf_93_clk _00467_ net692 vssd1 vssd1 vccd1 vccd1 cell1.CB_1.config_dataB\[8\]
+ sky130_fd_sc_hd__dfstp_1
XANTENNA__07653__A1 net339 vssd1 vssd1 vccd1 vccd1 sky130_fd_sc_hd__diode_2
X_12446_ net1053 net1363 net827 vssd1 vssd1 vccd1 vccd1 _00877_ sky130_fd_sc_hd__mux2_1
XFILLER_60_60 vssd1 vssd1 vccd1 vccd1 sky130_fd_sc_hd__fill_1
XTAP_TAPCELL_ROW_10_452 vssd1 vccd1 sky130_fd_sc_hd__tapvpwrvgnd_1
XANTENNA__11201__A2 _05912_ vssd1 vssd1 vccd1 vccd1 sky130_fd_sc_hd__diode_2
XTAP_TAPCELL_ROW_93_1705 vssd1 vccd1 sky130_fd_sc_hd__tapvpwrvgnd_1
XTAP_TAPCELL_ROW_10_463 vssd1 vccd1 sky130_fd_sc_hd__tapvpwrvgnd_1
X_12377_ cell1.SB0.route_sel\[115\] cell1.SB0.route_sel\[114\] net908 vssd1 vssd1
+ vccd1 vccd1 _00810_ sky130_fd_sc_hd__mux2_1
X_11328_ _06229_ net285 _04220_ vssd1 vssd1 vccd1 vccd1 net173 sky130_fd_sc_hd__mux2_1
X_14116_ clknet_leaf_49_clk _01088_ net705 vssd1 vssd1 vccd1 vccd1 cell3.SB0.route_sel\[124\]
+ sky130_fd_sc_hd__dfstp_1
XFILLER_5_55 vssd1 vssd1 vccd1 vccd1 sky130_fd_sc_hd__fill_1
XFILLER_140_112 vssd1 vssd1 vccd1 vccd1 sky130_fd_sc_hd__fill_2
X_11259_ _04390_ _05139_ vssd1 vssd1 vccd1 vccd1 _06197_ sky130_fd_sc_hd__nand2b_1
X_14047_ clknet_leaf_46_clk _01019_ net701 vssd1 vssd1 vccd1 vccd1 cell3.SB0.route_sel\[55\]
+ sky130_fd_sc_hd__dfstp_1
XPHY_EDGE_ROW_105_Left_248 vssd1 vssd1 vccd1 vccd1 sky130_fd_sc_hd__decap_3
XFILLER_10_3 vccd1 vssd1 vccd1 vssd1 sky130_ef_sc_hd__decap_40_12
XANTENNA__08381__A2 _02560_ vssd1 vssd1 vccd1 vccd1 sky130_fd_sc_hd__diode_2
XANTENNA__10499__B _03477_ vssd1 vssd1 vccd1 vccd1 sky130_fd_sc_hd__diode_2
Xclkbuf_leaf_74_clk clknet_4_14_0_clk vssd1 vssd1 vccd1 vccd1 clknet_leaf_74_clk sky130_fd_sc_hd__clkbuf_8
XANTENNA__08133__A2 bus1_0\[10\] vssd1 vssd1 vccd1 vccd1 sky130_fd_sc_hd__diode_2
X_08470_ net497 _03504_ vssd1 vssd1 vccd1 vccd1 _03506_ sky130_fd_sc_hd__or2_1
XTAP_TAPCELL_ROW_18_574 vssd1 vccd1 sky130_fd_sc_hd__tapvpwrvgnd_1
XTAP_TAPCELL_ROW_18_585 vssd1 vccd1 sky130_fd_sc_hd__tapvpwrvgnd_1
X_07421_ net338 _02474_ vssd1 vssd1 vccd1 vccd1 _02475_ sky130_fd_sc_hd__nor2_1
XTAP_TAPCELL_ROW_102_1845 vssd1 vccd1 sky130_fd_sc_hd__tapvpwrvgnd_1
XTAP_TAPCELL_ROW_102_1834 vssd1 vccd1 sky130_fd_sc_hd__tapvpwrvgnd_1
X_07352_ net355 _02326_ bus1_0\[13\] vssd1 vssd1 vccd1 vccd1 _02408_ sky130_fd_sc_hd__o21ai_1
XPHY_EDGE_ROW_114_Left_257 vssd1 vssd1 vccd1 vccd1 sky130_fd_sc_hd__decap_3
XFILLER_50_368 vssd1 vssd1 vccd1 vccd1 sky130_fd_sc_hd__fill_1
XANTENNA__08841__A0 bus3_1\[6\] vssd1 vssd1 vccd1 vccd1 sky130_fd_sc_hd__diode_2
X_07283_ _02030_ _02339_ vssd1 vssd1 vccd1 vccd1 _02341_ sky130_fd_sc_hd__nand2_1
XFILLER_31_593 vssd1 vssd1 vccd1 vccd1 sky130_fd_sc_hd__fill_1
XTAP_TAPCELL_ROW_135_2333 vssd1 vccd1 sky130_fd_sc_hd__tapvpwrvgnd_1
X_09022_ net485 _03881_ vssd1 vssd1 vccd1 vccd1 _04052_ sky130_fd_sc_hd__nand2_1
Xhold200 cell3.LE_1B.config_data\[9\] vssd1 vssd1 vccd1 vccd1 net1159 sky130_fd_sc_hd__dlygate4sd3_1
Xhold211 _00145_ vssd1 vssd1 vccd1 vccd1 net1170 sky130_fd_sc_hd__dlygate4sd3_1
Xhold244 _01097_ vssd1 vssd1 vccd1 vccd1 net1203 sky130_fd_sc_hd__dlygate4sd3_1
Xhold222 cell3.LE_1B.config_data\[8\] vssd1 vssd1 vccd1 vccd1 net1181 sky130_fd_sc_hd__dlygate4sd3_1
Xhold233 cell3.LEI0.config_data\[15\] vssd1 vssd1 vccd1 vccd1 net1192 sky130_fd_sc_hd__dlygate4sd3_1
XANTENNA__07947__A2 bus2_0\[2\] vssd1 vssd1 vccd1 vccd1 sky130_fd_sc_hd__diode_2
Xhold266 _01376_ vssd1 vssd1 vccd1 vccd1 net1225 sky130_fd_sc_hd__dlygate4sd3_1
Xhold277 _01099_ vssd1 vssd1 vccd1 vccd1 net1236 sky130_fd_sc_hd__dlygate4sd3_1
Xhold255 cell2.LEI0.config_data\[9\] vssd1 vssd1 vccd1 vccd1 net1214 sky130_fd_sc_hd__dlygate4sd3_1
XANTENNA__10951__A1 net48 vssd1 vssd1 vccd1 vccd1 sky130_fd_sc_hd__diode_2
XANTENNA__10026__Y _05030_ vssd1 vssd1 vccd1 vccd1 sky130_fd_sc_hd__diode_2
Xfanout724 net750 vssd1 vssd1 vccd1 vccd1 net724 sky130_fd_sc_hd__buf_2
Xhold299 cell3.LE_1B.config_data\[6\] vssd1 vssd1 vccd1 vccd1 net1258 sky130_fd_sc_hd__dlygate4sd3_1
XFILLER_131_156 vssd1 vssd1 vccd1 vccd1 sky130_fd_sc_hd__fill_1
XPHY_EDGE_ROW_123_Left_266 vssd1 vssd1 vccd1 vccd1 sky130_fd_sc_hd__decap_3
Xfanout713 net724 vssd1 vssd1 vccd1 vccd1 net713 sky130_fd_sc_hd__clkbuf_2
X_09924_ _04197_ _04922_ _04924_ _04260_ vssd1 vssd1 vccd1 vccd1 _04928_ sky130_fd_sc_hd__a22o_1
Xfanout702 net703 vssd1 vssd1 vccd1 vccd1 net702 sky130_fd_sc_hd__clkbuf_4
Xhold288 cell0.LE_1A.config_data\[4\] vssd1 vssd1 vccd1 vccd1 net1247 sky130_fd_sc_hd__dlygate4sd3_1
XANTENNA_input7_A CBeast_in[15] vssd1 vssd1 vccd1 vccd1 sky130_fd_sc_hd__diode_2
Xfanout735 net742 vssd1 vssd1 vccd1 vccd1 net735 sky130_fd_sc_hd__clkbuf_2
Xfanout746 net749 vssd1 vssd1 vccd1 vccd1 net746 sky130_fd_sc_hd__clkbuf_2
XTAP_TAPCELL_ROW_113_1996 vssd1 vccd1 sky130_fd_sc_hd__tapvpwrvgnd_1
X_09855_ _04849_ _04850_ _04852_ cell2.CB_1.config_dataA\[12\] vssd1 vssd1 vccd1 vccd1
+ _04861_ sky130_fd_sc_hd__o22a_1
Xfanout757 net759 vssd1 vssd1 vccd1 vccd1 net757 sky130_fd_sc_hd__clkbuf_4
XFILLER_85_221 vssd1 vssd1 vccd1 vccd1 sky130_fd_sc_hd__fill_2
Xfanout779 net780 vssd1 vssd1 vccd1 vccd1 net779 sky130_fd_sc_hd__buf_2
XANTENNA_fanout669_A net672 vssd1 vssd1 vccd1 vccd1 sky130_fd_sc_hd__diode_2
XANTENNA__07175__A3 _02234_ vssd1 vssd1 vccd1 vccd1 sky130_fd_sc_hd__diode_2
Xfanout768 net807 vssd1 vssd1 vccd1 vccd1 net768 sky130_fd_sc_hd__clkbuf_2
XANTENNA_fanout571_A net575 vssd1 vssd1 vccd1 vccd1 sky130_fd_sc_hd__diode_2
X_08806_ _01535_ cell1.SB0.route_sel\[87\] vssd1 vssd1 vccd1 vccd1 _03838_ sky130_fd_sc_hd__nand2_1
X_09786_ net446 net448 vssd1 vssd1 vccd1 vccd1 _04792_ sky130_fd_sc_hd__and2b_1
X_06998_ _02062_ _02063_ vssd1 vssd1 vccd1 vccd1 _02064_ sky130_fd_sc_hd__nor2_1
XFILLER_39_671 vssd1 vssd1 vccd1 vccd1 sky130_fd_sc_hd__fill_1
XPHY_EDGE_ROW_134_Right_134 vssd1 vssd1 vccd1 vccd1 sky130_fd_sc_hd__decap_3
Xclkbuf_leaf_65_clk clknet_4_15_0_clk vssd1 vssd1 vccd1 vccd1 clknet_leaf_65_clk sky130_fd_sc_hd__clkbuf_8
XANTENNA_fanout836_A net837 vssd1 vssd1 vccd1 vccd1 sky130_fd_sc_hd__diode_2
X_08737_ net452 _03465_ _03770_ net451 vssd1 vssd1 vccd1 vccd1 _03771_ sky130_fd_sc_hd__o211a_1
X_08668_ cell1.CB_1.config_dataB\[9\] _03670_ _03675_ _03696_ _03701_ vssd1 vssd1
+ vccd1 vccd1 _03702_ sky130_fd_sc_hd__a311o_2
XTAP_TAPCELL_ROW_37_861 vssd1 vccd1 sky130_fd_sc_hd__tapvpwrvgnd_1
XFILLER_121_55 vssd1 vssd1 vccd1 vccd1 sky130_fd_sc_hd__fill_1
X_07619_ _02666_ _02667_ _02663_ _02664_ vssd1 vssd1 vccd1 vccd1 _02668_ sky130_fd_sc_hd__a2bb2o_1
XFILLER_14_527 vssd1 vssd1 vccd1 vccd1 sky130_fd_sc_hd__fill_4
XPHY_EDGE_ROW_132_Left_275 vssd1 vssd1 vccd1 vccd1 sky130_fd_sc_hd__decap_3
X_10630_ net396 _05586_ _05587_ vssd1 vssd1 vccd1 vccd1 _05588_ sky130_fd_sc_hd__a21o_1
X_08599_ _03628_ _03631_ _03633_ _03634_ vssd1 vssd1 vccd1 vccd1 _03635_ sky130_fd_sc_hd__o22a_1
XFILLER_41_379 vssd1 vssd1 vccd1 vccd1 sky130_fd_sc_hd__fill_1
XFILLER_14_53 vccd1 vssd1 vccd1 vssd1 sky130_ef_sc_hd__decap_40_12
X_10561_ _04714_ _05518_ vssd1 vssd1 vccd1 vccd1 _05519_ sky130_fd_sc_hd__or2_2
XFILLER_127_418 vssd1 vssd1 vccd1 vccd1 sky130_fd_sc_hd__fill_1
X_13280_ clknet_leaf_91_clk _00252_ net698 vssd1 vssd1 vccd1 vccd1 cell1.LE_1B.config_data\[16\]
+ sky130_fd_sc_hd__dfrtp_1
X_10492_ net333 _02785_ _02786_ _05461_ vssd1 vssd1 vccd1 vccd1 net160 sky130_fd_sc_hd__a22o_1
X_12300_ cell1.SB0.route_sel\[38\] cell1.SB0.route_sel\[37\] net859 vssd1 vssd1 vccd1
+ vccd1 _00733_ sky130_fd_sc_hd__mux2_1
X_12231_ cell2.CB_0.config_dataB\[19\] cell2.CB_0.config_dataB\[18\] net826 vssd1
+ vssd1 vccd1 vccd1 _00664_ sky130_fd_sc_hd__mux2_1
XFILLER_108_643 vssd1 vssd1 vccd1 vccd1 sky130_fd_sc_hd__fill_1
XFILLER_6_737 vccd1 vssd1 vccd1 vssd1 sky130_ef_sc_hd__decap_40_12
XFILLER_30_41 vccd1 vssd1 vccd1 vssd1 sky130_ef_sc_hd__decap_40_12
XTAP_TAPCELL_ROW_75_1435 vssd1 vccd1 sky130_fd_sc_hd__tapvpwrvgnd_1
XPHY_EDGE_ROW_141_Left_284 vssd1 vssd1 vccd1 vccd1 sky130_fd_sc_hd__decap_3
XFILLER_107_186 vssd1 vssd1 vccd1 vccd1 sky130_fd_sc_hd__fill_1
X_12162_ net1276 cell1.LEI0.config_data\[43\] net894 vssd1 vssd1 vccd1 vccd1 _00595_
+ sky130_fd_sc_hd__mux2_1
XFILLER_123_679 vssd1 vssd1 vccd1 vccd1 sky130_fd_sc_hd__fill_1
X_11113_ net45 _06046_ _06048_ net46 cell3.CB_0.config_dataB\[3\] vssd1 vssd1 vccd1
+ vccd1 _06065_ sky130_fd_sc_hd__a221o_1
X_12093_ net756 _04171_ vssd1 vssd1 vccd1 vccd1 _06379_ sky130_fd_sc_hd__nand2_1
X_11044_ net373 net372 vssd1 vssd1 vccd1 vccd1 _05998_ sky130_fd_sc_hd__or2_1
XANTENNA_clkbuf_4_15_0_clk_A clknet_0_clk vssd1 vssd1 vccd1 vccd1 sky130_fd_sc_hd__diode_2
XFILLER_110_307 vssd1 vssd1 vccd1 vccd1 sky130_fd_sc_hd__fill_1
XFILLER_89_571 vssd1 vssd1 vccd1 vccd1 sky130_fd_sc_hd__fill_4
XFILLER_77_711 vssd1 vssd1 vccd1 vccd1 sky130_fd_sc_hd__fill_1
XANTENNA__08363__A2 bus1_0\[2\] vssd1 vssd1 vccd1 vccd1 sky130_fd_sc_hd__diode_2
Xclkbuf_leaf_56_clk clknet_4_13_0_clk vssd1 vssd1 vccd1 vccd1 clknet_leaf_56_clk sky130_fd_sc_hd__clkbuf_8
XANTENNA_input18_X net18 vssd1 vssd1 vccd1 vccd1 sky130_fd_sc_hd__diode_2
X_12995_ cell3.LEI0.config_data\[16\] net1192 net949 vssd1 vssd1 vccd1 vccd1 _01423_
+ sky130_fd_sc_hd__mux2_1
XPHY_EDGE_ROW_101_Right_101 vssd1 vssd1 vccd1 vccd1 sky130_fd_sc_hd__decap_3
XFILLER_64_449 vssd1 vssd1 vccd1 vccd1 sky130_fd_sc_hd__fill_4
XANTENNA_output219_A net219 vssd1 vssd1 vccd1 vccd1 sky130_fd_sc_hd__diode_2
X_11946_ cell0.SB0.route_sel\[52\] cell0.SB0.route_sel\[51\] net759 vssd1 vssd1 vccd1
+ vccd1 _00383_ sky130_fd_sc_hd__mux2_1
XFILLER_17_343 vssd1 vssd1 vccd1 vccd1 sky130_fd_sc_hd__fill_1
XFILLER_33_814 vssd1 vssd1 vccd1 vccd1 sky130_fd_sc_hd__fill_1
XTAP_TAPCELL_ROW_86_1597 vssd1 vccd1 sky130_fd_sc_hd__tapvpwrvgnd_1
X_11877_ cell1.CB_0.config_dataA\[8\] cell1.CB_0.config_dataA\[7\] net879 vssd1 vssd1
+ vccd1 vccd1 _00314_ sky130_fd_sc_hd__mux2_1
XTAP_TAPCELL_ROW_15_533 vssd1 vccd1 sky130_fd_sc_hd__tapvpwrvgnd_1
X_10828_ _05549_ _05762_ _05783_ net366 cell3.CB_1.config_dataB\[12\] vssd1 vssd1
+ vccd1 vccd1 _05784_ sky130_fd_sc_hd__a221o_1
XFILLER_60_699 vssd1 vssd1 vccd1 vccd1 sky130_fd_sc_hd__fill_1
X_13616_ clknet_leaf_87_clk _00588_ net689 vssd1 vssd1 vccd1 vccd1 cell1.LEI0.config_data\[37\]
+ sky130_fd_sc_hd__dfrtp_1
X_10759_ net371 _05501_ _05714_ net370 vssd1 vssd1 vccd1 vccd1 _05715_ sky130_fd_sc_hd__o211a_1
X_13547_ clknet_leaf_90_clk net1098 net699 vssd1 vssd1 vccd1 vccd1 cell1.LE_0B.config_data\[12\]
+ sky130_fd_sc_hd__dfrtp_1
XANTENNA__14308__Q cell2.SB0.route_sel\[93\] vssd1 vssd1 vccd1 vccd1 sky130_fd_sc_hd__diode_2
XTAP_TAPCELL_ROW_117_2063 vssd1 vccd1 sky130_fd_sc_hd__tapvpwrvgnd_1
X_13478_ clknet_leaf_2_clk _00450_ net571 vssd1 vssd1 vccd1 vccd1 cell0.SB0.route_sel\[119\]
+ sky130_fd_sc_hd__dfstp_1
XANTENNA__11186__A1 net291 vssd1 vssd1 vccd1 vccd1 sky130_fd_sc_hd__diode_2
X_12429_ net1251 cell2.LE_1A.config_data\[11\] net848 vssd1 vssd1 vccd1 vccd1 _00861_
+ sky130_fd_sc_hd__mux2_1
XANTENNA__07929__A2 bus2_0\[14\] vssd1 vssd1 vccd1 vccd1 sky130_fd_sc_hd__diode_2
XTAP_TAPCELL_ROW_130_2252 vssd1 vccd1 sky130_fd_sc_hd__tapvpwrvgnd_1
XANTENNA__08051__A1 _02074_ vssd1 vssd1 vccd1 vccd1 sky130_fd_sc_hd__diode_2
XANTENNA__08051__B2 _02172_ vssd1 vssd1 vccd1 vccd1 sky130_fd_sc_hd__diode_2
XTAP_TAPCELL_ROW_130_2263 vssd1 vccd1 sky130_fd_sc_hd__tapvpwrvgnd_1
X_07970_ cell0.LE_0A.config_data\[1\] cell0.LE_0A.config_data\[0\] _02947_ vssd1 vssd1
+ vccd1 vccd1 _03014_ sky130_fd_sc_hd__mux2_1
X_06921_ _01944_ _01987_ _01982_ _01945_ vssd1 vssd1 vccd1 vccd1 _01988_ sky130_fd_sc_hd__o211a_1
XANTENNA__10697__A0 _05478_ vssd1 vssd1 vccd1 vccd1 sky130_fd_sc_hd__diode_2
XANTENNA__08354__A2 _02211_ vssd1 vssd1 vccd1 vccd1 sky130_fd_sc_hd__diode_2
X_06852_ _01919_ _01920_ vssd1 vssd1 vccd1 vccd1 _01921_ sky130_fd_sc_hd__nor2_1
X_09640_ cell3.CB_0.config_dataA\[22\] cell3.CB_0.config_dataA\[23\] vssd1 vssd1 vccd1
+ vccd1 _04656_ sky130_fd_sc_hd__nand2_1
XANTENNA__10161__A2 net318 vssd1 vssd1 vccd1 vccd1 sky130_fd_sc_hd__diode_2
X_09571_ _04580_ _04587_ _04588_ vssd1 vssd1 vccd1 vccd1 _04589_ sky130_fd_sc_hd__a21o_1
X_06783_ net339 net361 net360 _01847_ _01849_ vssd1 vssd1 vccd1 vccd1 _01853_ sky130_fd_sc_hd__o32a_1
XFILLER_27_129 vssd1 vssd1 vccd1 vccd1 sky130_fd_sc_hd__fill_2
Xclkbuf_leaf_47_clk clknet_4_12_0_clk vssd1 vssd1 vccd1 vccd1 clknet_leaf_47_clk sky130_fd_sc_hd__clkbuf_8
X_08522_ cell1.CB_1.config_dataA\[7\] _03553_ _03554_ _03557_ vssd1 vssd1 vccd1 vccd1
+ _03558_ sky130_fd_sc_hd__o22a_1
XTAP_TAPCELL_ROW_46_1003 vssd1 vccd1 sky130_fd_sc_hd__tapvpwrvgnd_1
X_08453_ _03487_ _03488_ _02579_ vssd1 vssd1 vccd1 vccd1 _03489_ sky130_fd_sc_hd__a21boi_4
XFILLER_24_847 vssd1 vssd1 vccd1 vccd1 sky130_fd_sc_hd__fill_1
X_07404_ _02415_ _02418_ _02457_ _02458_ vssd1 vssd1 vccd1 vccd1 _02459_ sky130_fd_sc_hd__o31ai_2
XANTENNA__07865__A1 bus2_0\[7\] vssd1 vssd1 vccd1 vccd1 sky130_fd_sc_hd__diode_2
XFILLER_23_324 vssd1 vssd1 vccd1 vccd1 sky130_fd_sc_hd__fill_1
XTAP_TAPCELL_ROW_34_820 vssd1 vccd1 sky130_fd_sc_hd__tapvpwrvgnd_1
X_08384_ net499 net500 vssd1 vssd1 vccd1 vccd1 _03422_ sky130_fd_sc_hd__and2b_1
XANTENNA__08409__A3 cell0.CB_1.le_outB vssd1 vssd1 vccd1 vccd1 sky130_fd_sc_hd__diode_2
X_07335_ cell2.SB0.route_sel\[102\] cell2.SB0.route_sel\[103\] _01639_ _02390_ vssd1
+ vssd1 vccd1 vccd1 _02392_ sky130_fd_sc_hd__a211o_1
X_07266_ cell0.CB_1.config_dataA\[22\] cell0.CB_1.config_dataA\[23\] vssd1 vssd1 vccd1
+ vccd1 _02324_ sky130_fd_sc_hd__nand2_2
X_09005_ cell1.CB_0.config_dataB\[7\] _04026_ _04030_ _04034_ vssd1 vssd1 vccd1 vccd1
+ _04035_ sky130_fd_sc_hd__o211a_1
XANTENNA__11177__A1 net41 vssd1 vssd1 vccd1 vccd1 sky130_fd_sc_hd__diode_2
X_07197_ _01931_ _02012_ vssd1 vssd1 vccd1 vccd1 _02257_ sky130_fd_sc_hd__nand2_1
XFILLER_132_421 vssd1 vssd1 vccd1 vccd1 sky130_fd_sc_hd__fill_4
XFILLER_105_646 vssd1 vssd1 vccd1 vccd1 sky130_fd_sc_hd__fill_1
XFILLER_3_729 vccd1 vssd1 vccd1 vssd1 sky130_ef_sc_hd__decap_40_12
XTAP_TAPCELL_ROW_57_1165 vssd1 vccd1 sky130_fd_sc_hd__tapvpwrvgnd_1
XANTENNA_fanout786_A net787 vssd1 vssd1 vccd1 vccd1 sky130_fd_sc_hd__diode_2
X_09907_ cell2.LE_1A.config_data\[13\] cell2.LE_1A.config_data\[12\] _04831_ vssd1
+ vssd1 vccd1 vccd1 _04913_ sky130_fd_sc_hd__mux2_1
Xfanout532 cell0.CB_0.config_dataB\[1\] vssd1 vssd1 vccd1 vccd1 net532 sky130_fd_sc_hd__buf_2
Xfanout521 cell0.CB_0.config_dataA\[0\] vssd1 vssd1 vccd1 vccd1 net521 sky130_fd_sc_hd__buf_2
Xfanout510 cell0.CB_1.config_dataB\[0\] vssd1 vssd1 vccd1 vccd1 net510 sky130_fd_sc_hd__clkbuf_2
XFILLER_120_649 vssd1 vssd1 vccd1 vccd1 sky130_fd_sc_hd__fill_1
XFILLER_101_841 vssd1 vssd1 vccd1 vccd1 sky130_fd_sc_hd__fill_1
XTAP_TAPCELL_ROW_70_1365 vssd1 vccd1 sky130_fd_sc_hd__tapvpwrvgnd_1
XTAP_TAPCELL_ROW_70_1354 vssd1 vccd1 sky130_fd_sc_hd__tapvpwrvgnd_1
Xfanout565 net575 vssd1 vssd1 vccd1 vccd1 net565 sky130_fd_sc_hd__clkbuf_2
XANTENNA__08345__A2 _02560_ vssd1 vssd1 vccd1 vccd1 sky130_fd_sc_hd__diode_2
Xfanout543 cell0.CB_1.config_dataA\[5\] vssd1 vssd1 vccd1 vccd1 net543 sky130_fd_sc_hd__clkbuf_2
Xfanout554 net555 vssd1 vssd1 vccd1 vccd1 net554 sky130_fd_sc_hd__clkbuf_2
XANTENNA__10152__A2 _05152_ vssd1 vssd1 vccd1 vccd1 sky130_fd_sc_hd__diode_2
X_09838_ net441 _04608_ vssd1 vssd1 vccd1 vccd1 _04844_ sky130_fd_sc_hd__nand2_1
Xfanout598 net600 vssd1 vssd1 vccd1 vccd1 net598 sky130_fd_sc_hd__clkbuf_4
Xfanout587 net592 vssd1 vssd1 vccd1 vccd1 net587 sky130_fd_sc_hd__clkbuf_4
Xfanout576 net577 vssd1 vssd1 vccd1 vccd1 net576 sky130_fd_sc_hd__clkbuf_4
XFILLER_19_619 vssd1 vssd1 vccd1 vccd1 sky130_fd_sc_hd__fill_1
X_09769_ bus3_2\[5\] _04757_ _04758_ bus3_2\[4\] cell2.CB_1.config_dataA\[8\] vssd1
+ vssd1 vccd1 vccd1 _04775_ sky130_fd_sc_hd__a221o_1
Xclkbuf_leaf_38_clk clknet_4_7_0_clk vssd1 vssd1 vccd1 vccd1 clknet_leaf_38_clk sky130_fd_sc_hd__clkbuf_8
XFILLER_132_65 vssd1 vssd1 vccd1 vccd1 sky130_fd_sc_hd__fill_8
XFILLER_92_25 vssd1 vssd1 vccd1 vccd1 sky130_fd_sc_hd__fill_2
X_11800_ net1290 net1347 net901 vssd1 vssd1 vccd1 vccd1 _00237_ sky130_fd_sc_hd__mux2_1
XANTENNA__09845__A2 bus3_2\[1\] vssd1 vssd1 vccd1 vccd1 sky130_fd_sc_hd__diode_2
XANTENNA_input117_A SBwest_in[28] vssd1 vssd1 vccd1 vccd1 sky130_fd_sc_hd__diode_2
X_12780_ cell2.SB0.route_sel\[22\] cell2.SB0.route_sel\[21\] net816 vssd1 vssd1 vccd1
+ vccd1 _01209_ sky130_fd_sc_hd__mux2_1
XANTENNA__07305__B1 net335 vssd1 vssd1 vccd1 vccd1 sky130_fd_sc_hd__diode_2
X_11731_ net1086 net1084 net808 vssd1 vssd1 vccd1 vccd1 _00169_ sky130_fd_sc_hd__mux2_1
X_14450_ clknet_leaf_58_clk _01422_ net735 vssd1 vssd1 vccd1 vccd1 cell3.LEI0.config_data\[15\]
+ sky130_fd_sc_hd__dfrtp_1
X_11662_ cell0.CB_1.config_dataB\[8\] cell0.CB_1.config_dataB\[7\] net783 vssd1 vssd1
+ vccd1 vccd1 _00103_ sky130_fd_sc_hd__mux2_1
XFILLER_25_85 vssd1 vssd1 vccd1 vccd1 sky130_fd_sc_hd__fill_2
XFILLER_25_96 vssd1 vssd1 vccd1 vccd1 sky130_fd_sc_hd__fill_8
XANTENNA__10207__A3 net35 vssd1 vssd1 vccd1 vccd1 sky130_fd_sc_hd__diode_2
X_14381_ clknet_leaf_70_clk net1080 net731 vssd1 vssd1 vccd1 vccd1 cell3.LE_1A.config_data\[12\]
+ sky130_fd_sc_hd__dfrtp_1
X_10613_ _05563_ _05564_ _05567_ _05570_ vssd1 vssd1 vccd1 vccd1 _05571_ sky130_fd_sc_hd__a211o_1
X_11593_ cell0.CB_1.config_dataA\[14\] cell0.CB_1.config_dataA\[13\] net859 vssd1
+ vssd1 vccd1 vccd1 _00034_ sky130_fd_sc_hd__mux2_1
X_13401_ clknet_leaf_134_clk _00373_ net553 vssd1 vssd1 vccd1 vccd1 cell0.SB0.route_sel\[42\]
+ sky130_fd_sc_hd__dfstp_1
X_10544_ _01696_ cell3.SB0.route_sel\[30\] vssd1 vssd1 vccd1 vccd1 _05502_ sky130_fd_sc_hd__nand2_1
X_13332_ clknet_leaf_114_clk _00304_ net666 vssd1 vssd1 vccd1 vccd1 cell1.CB_0.config_dataB\[23\]
+ sky130_fd_sc_hd__dfstp_1
XANTENNA_input82_A SBsouth_in[25] vssd1 vssd1 vccd1 vccd1 sky130_fd_sc_hd__diode_2
XFILLER_41_51 vssd1 vssd1 vccd1 vccd1 sky130_fd_sc_hd__fill_2
XANTENNA__08281__A1 bus1_0\[9\] vssd1 vssd1 vccd1 vccd1 sky130_fd_sc_hd__diode_2
X_13263_ clknet_1_1__leaf_cell0.LE_0A.sel_clk _00235_ net751 vssd1 vssd1 vccd1 vccd1
+ cell0.LE_0A.dff1_out sky130_fd_sc_hd__dfstp_1
X_10475_ cell0.LE_1B.edge_mode clknet_leaf_119_clk vssd1 vssd1 vccd1 vccd1 cell0.LE_1B.sel_clk
+ sky130_fd_sc_hd__xnor2_2
X_12214_ cell2.CB_0.config_dataB\[2\] net433 net825 vssd1 vssd1 vccd1 vccd1 _00647_
+ sky130_fd_sc_hd__mux2_1
XFILLER_136_793 vccd1 vssd1 vccd1 vssd1 sky130_ef_sc_hd__decap_40_12
XANTENNA__09736__X bus2_0\[1\] vssd1 vssd1 vccd1 vccd1 sky130_fd_sc_hd__diode_2
X_13194_ clknet_leaf_23_clk net998 net603 vssd1 vssd1 vccd1 vccd1 cell0.LE_0A.config_data\[1\]
+ sky130_fd_sc_hd__dfrtp_1
XANTENNA_output169_A net169 vssd1 vssd1 vccd1 vccd1 sky130_fd_sc_hd__diode_2
X_12145_ net1483 cell1.LEI0.config_data\[26\] net893 vssd1 vssd1 vccd1 vccd1 _00578_
+ sky130_fd_sc_hd__mux2_1
XANTENNA__10391__A2 _05088_ vssd1 vssd1 vccd1 vccd1 sky130_fd_sc_hd__diode_2
XFILLER_97_828 vssd1 vssd1 vccd1 vccd1 sky130_fd_sc_hd__fill_8
XANTENNA__07792__B1 bus2_0\[5\] vssd1 vssd1 vccd1 vccd1 sky130_fd_sc_hd__diode_2
XFILLER_1_261 vccd1 vssd1 vccd1 vssd1 sky130_ef_sc_hd__decap_40_12
X_12076_ net1012 net1050 net940 vssd1 vssd1 vccd1 vccd1 _00511_ sky130_fd_sc_hd__mux2_1
XANTENNA__08336__A2 _02211_ vssd1 vssd1 vccd1 vccd1 sky130_fd_sc_hd__diode_2
X_11027_ cell3.CB_0.config_dataA\[13\] cell3.CB_0.config_dataA\[12\] vssd1 vssd1 vccd1
+ vccd1 _05981_ sky130_fd_sc_hd__nor2_1
XANTENNA__12749__S net929 vssd1 vssd1 vccd1 vccd1 sky130_fd_sc_hd__diode_2
Xclkbuf_1_1__f_cell2.LE_1A.sel_clk clknet_0_cell2.LE_1A.sel_clk vssd1 vssd1 vccd1
+ vccd1 clknet_1_1__leaf_cell2.LE_1A.sel_clk sky130_fd_sc_hd__clkbuf_16
XFILLER_92_533 vssd1 vssd1 vccd1 vccd1 sky130_fd_sc_hd__fill_1
XTAP_TAPCELL_ROW_88_1626 vssd1 vccd1 sky130_fd_sc_hd__tapvpwrvgnd_1
Xclkbuf_leaf_29_clk clknet_4_5_0_clk vssd1 vssd1 vccd1 vccd1 clknet_leaf_29_clk sky130_fd_sc_hd__clkbuf_8
X_12978_ net970 _06042_ net755 vssd1 vssd1 vccd1 vccd1 _01406_ sky130_fd_sc_hd__mux2_1
Xclkbuf_1_0__f_cell0.LE_1B.sel_clk clknet_0_cell0.LE_1B.sel_clk vssd1 vssd1 vccd1
+ vccd1 clknet_1_0__leaf_cell0.LE_1B.sel_clk sky130_fd_sc_hd__clkbuf_16
XANTENNA__08639__A3 net26 vssd1 vssd1 vccd1 vccd1 sky130_fd_sc_hd__diode_2
X_11929_ cell0.SB0.route_sel\[35\] cell0.SB0.route_sel\[34\] net758 vssd1 vssd1 vccd1
+ vccd1 _00366_ sky130_fd_sc_hd__mux2_1
XFILLER_32_165 vssd1 vssd1 vccd1 vccd1 sky130_fd_sc_hd__fill_4
XANTENNA_17 net2 vssd1 vssd1 vccd1 vccd1 sky130_fd_sc_hd__diode_2
XANTENNA_28 net807 vssd1 vssd1 vccd1 vccd1 sky130_fd_sc_hd__diode_2
XANTENNA_39 net1 vssd1 vssd1 vccd1 vccd1 sky130_fd_sc_hd__diode_2
X_07120_ net64 net307 _02179_ vssd1 vssd1 vccd1 vccd1 _02183_ sky130_fd_sc_hd__mux2_1
XANTENNA__09064__A3 bus3_1\[11\] vssd1 vssd1 vccd1 vccd1 sky130_fd_sc_hd__diode_2
XTAP_TAPCELL_ROW_99_1788 vssd1 vccd1 sky130_fd_sc_hd__tapvpwrvgnd_1
XANTENNA__11159__A1 net50 vssd1 vssd1 vccd1 vccd1 sky130_fd_sc_hd__diode_2
XTAP_TAPCELL_ROW_99_1799 vssd1 vccd1 sky130_fd_sc_hd__tapvpwrvgnd_1
X_07051_ _02112_ _02114_ _02113_ vssd1 vssd1 vccd1 vccd1 _02115_ sky130_fd_sc_hd__a21o_1
XFILLER_99_110 vssd1 vssd1 vccd1 vccd1 sky130_fd_sc_hd__fill_2
XANTENNA__09221__B1 bus3_2\[1\] vssd1 vssd1 vccd1 vccd1 sky130_fd_sc_hd__diode_2
XFILLER_142_763 vssd1 vssd1 vccd1 vccd1 sky130_fd_sc_hd__fill_1
XFILLER_142_752 vssd1 vssd1 vccd1 vccd1 sky130_fd_sc_hd__fill_4
Xoutput168 net168 vssd1 vssd1 vccd1 vccd1 CBnorth_out[11] sky130_fd_sc_hd__buf_2
Xoutput157 net157 vssd1 vssd1 vccd1 vccd1 CBeast_out[30] sky130_fd_sc_hd__buf_2
Xoutput146 net146 vssd1 vssd1 vccd1 vccd1 CBeast_out[20] sky130_fd_sc_hd__buf_2
Xoutput135 net135 vssd1 vssd1 vccd1 vccd1 CBeast_out[10] sky130_fd_sc_hd__buf_2
XFILLER_142_785 vssd1 vssd1 vccd1 vccd1 sky130_fd_sc_hd__fill_2
XFILLER_142_774 vssd1 vssd1 vccd1 vccd1 sky130_fd_sc_hd__fill_2
Xoutput179 net179 vssd1 vssd1 vccd1 vccd1 CBnorth_out[21] sky130_fd_sc_hd__buf_2
XANTENNA__09509__D1 _02092_ vssd1 vssd1 vccd1 vccd1 sky130_fd_sc_hd__diode_2
XTAP_TAPCELL_ROW_110_1955 vssd1 vccd1 sky130_fd_sc_hd__tapvpwrvgnd_1
XFILLER_101_137 vssd1 vssd1 vccd1 vccd1 sky130_fd_sc_hd__fill_1
X_07953_ net512 _02235_ _02996_ net511 vssd1 vssd1 vccd1 vccd1 _02997_ sky130_fd_sc_hd__o211a_1
XFILLER_83_500 vssd1 vssd1 vccd1 vccd1 sky130_fd_sc_hd__fill_1
X_07884_ bus2_0\[6\] bus2_0\[7\] net521 vssd1 vssd1 vccd1 vccd1 _02928_ sky130_fd_sc_hd__mux2_1
XTAP_TAPCELL_ROW_52_1084 vssd1 vccd1 sky130_fd_sc_hd__tapvpwrvgnd_1
X_06904_ cell1.CB_0.config_dataB\[24\] cell1.CB_0.config_dataB\[21\] cell1.CB_0.config_dataB\[20\]
+ vssd1 vssd1 vccd1 vccd1 _01972_ sky130_fd_sc_hd__and3b_1
XANTENNA__08327__A2 _02494_ vssd1 vssd1 vccd1 vccd1 sky130_fd_sc_hd__diode_2
XFILLER_28_405 vssd1 vssd1 vccd1 vccd1 sky130_fd_sc_hd__fill_1
X_09623_ cell2.SB0.route_sel\[96\] cell2.SB0.route_sel\[97\] vssd1 vssd1 vccd1 vccd1
+ _04639_ sky130_fd_sc_hd__nand2b_1
X_06835_ cell2.CB_1.config_dataB\[24\] cell2.CB_1.config_dataB\[20\] cell2.CB_1.config_dataB\[21\]
+ vssd1 vssd1 vccd1 vccd1 _01904_ sky130_fd_sc_hd__or3b_2
XANTENNA__08878__A3 bus3_1\[15\] vssd1 vssd1 vccd1 vccd1 sky130_fd_sc_hd__diode_2
XTAP_TAPCELL_ROW_52_1095 vssd1 vccd1 sky130_fd_sc_hd__tapvpwrvgnd_1
XANTENNA__06889__A2 _01933_ vssd1 vssd1 vccd1 vccd1 sky130_fd_sc_hd__diode_2
X_09554_ _04572_ net282 _04571_ vssd1 vssd1 vccd1 vccd1 _04573_ sky130_fd_sc_hd__mux2_1
XFILLER_70_227 vssd1 vssd1 vccd1 vccd1 sky130_fd_sc_hd__fill_2
X_06766_ bus3_1\[4\] vssd1 vssd1 vccd1 vccd1 _01836_ sky130_fd_sc_hd__inv_2
X_06697_ cell2.CB_0.config_dataA\[4\] vssd1 vssd1 vccd1 vccd1 _01767_ sky130_fd_sc_hd__inv_2
X_09485_ _04502_ _04504_ _04505_ vssd1 vssd1 vccd1 vccd1 _04506_ sky130_fd_sc_hd__a21o_1
XFILLER_64_791 vssd1 vssd1 vccd1 vccd1 sky130_fd_sc_hd__fill_1
XFILLER_36_493 vssd1 vssd1 vccd1 vccd1 sky130_fd_sc_hd__fill_1
X_08505_ _03474_ _03537_ _03540_ _03478_ _01664_ vssd1 vssd1 vccd1 vccd1 _03541_ sky130_fd_sc_hd__a221o_1
X_08436_ _01528_ cell1.SB0.route_sel\[73\] cell1.SB0.route_sel\[78\] _01532_ _03471_
+ vssd1 vssd1 vccd1 vccd1 _03472_ sky130_fd_sc_hd__a221o_2
XANTENNA__12394__S net837 vssd1 vssd1 vccd1 vccd1 sky130_fd_sc_hd__diode_2
X_08367_ bus1_0\[5\] _03384_ _03386_ bus1_0\[4\] cell0.CB_1.config_dataB\[13\] vssd1
+ vssd1 vccd1 vccd1 _03405_ sky130_fd_sc_hd__a221o_1
XFILLER_24_699 vssd1 vssd1 vccd1 vccd1 sky130_fd_sc_hd__fill_1
XANTENNA_fanout322_X net322 vssd1 vssd1 vccd1 vccd1 sky130_fd_sc_hd__diode_2
X_07318_ _02373_ _02375_ vssd1 vssd1 vccd1 vccd1 bus1_0\[12\] sky130_fd_sc_hd__and2_2
X_08298_ _01491_ _03331_ _03332_ _03335_ vssd1 vssd1 vccd1 vccd1 _03336_ sky130_fd_sc_hd__o2bb2a_1
X_07249_ _02304_ _02306_ _02307_ vssd1 vssd1 vccd1 vccd1 _02308_ sky130_fd_sc_hd__a21oi_1
XANTENNA__06813__A2 _01846_ vssd1 vssd1 vccd1 vccd1 sky130_fd_sc_hd__diode_2
X_10260_ _01772_ _05257_ _05260_ _01774_ _05249_ vssd1 vssd1 vccd1 vccd1 _05261_ sky130_fd_sc_hd__o311a_1
XFILLER_105_421 vssd1 vssd1 vccd1 vccd1 sky130_fd_sc_hd__fill_1
XANTENNA_fanout691_X net691 vssd1 vssd1 vccd1 vccd1 sky130_fd_sc_hd__diode_2
XFILLER_11_87 vssd1 vssd1 vccd1 vccd1 sky130_fd_sc_hd__fill_1
XANTENNA__08566__A2 _03486_ vssd1 vssd1 vccd1 vccd1 sky130_fd_sc_hd__diode_2
XANTENNA__10373__A2 net38 vssd1 vssd1 vccd1 vccd1 sky130_fd_sc_hd__diode_2
X_10191_ _05190_ _05191_ _01766_ vssd1 vssd1 vccd1 vccd1 _05192_ sky130_fd_sc_hd__mux2_1
XFILLER_79_839 vssd1 vssd1 vccd1 vccd1 sky130_fd_sc_hd__fill_1
XANTENNA__08112__S _03057_ vssd1 vssd1 vccd1 vccd1 sky130_fd_sc_hd__diode_2
Xfanout340 _01830_ vssd1 vssd1 vccd1 vccd1 net340 sky130_fd_sc_hd__buf_2
Xfanout384 cell3.CB_0.config_dataB\[11\] vssd1 vssd1 vccd1 vccd1 net384 sky130_fd_sc_hd__clkbuf_2
Xfanout373 cell3.CB_0.config_dataA\[15\] vssd1 vssd1 vccd1 vccd1 net373 sky130_fd_sc_hd__buf_2
X_13950_ clknet_leaf_42_clk _00922_ net633 vssd1 vssd1 vccd1 vccd1 cell2.LEI0.config_data\[7\]
+ sky130_fd_sc_hd__dfrtp_1
Xfanout362 cell3.CB_1.config_dataB\[23\] vssd1 vssd1 vccd1 vccd1 net362 sky130_fd_sc_hd__clkbuf_2
Xfanout351 _03025_ vssd1 vssd1 vccd1 vccd1 net351 sky130_fd_sc_hd__buf_4
XFILLER_19_405 vssd1 vssd1 vccd1 vccd1 sky130_fd_sc_hd__fill_2
Xfanout395 cell3.CB_1.config_dataA\[5\] vssd1 vssd1 vccd1 vccd1 net395 sky130_fd_sc_hd__buf_2
X_12901_ cell3.CB_1.config_dataB\[15\] cell3.CB_1.config_dataB\[14\] net941 vssd1
+ vssd1 vccd1 vccd1 _01330_ sky130_fd_sc_hd__mux2_1
XFILLER_74_522 vssd1 vssd1 vccd1 vccd1 sky130_fd_sc_hd__fill_1
XTAP_TAPCELL_ROW_6_397 vssd1 vccd1 sky130_fd_sc_hd__tapvpwrvgnd_1
X_13881_ clknet_leaf_40_clk net1175 net715 vssd1 vssd1 vccd1 vccd1 cell2.LE_1A.config_data\[4\]
+ sky130_fd_sc_hd__dfrtp_1
XFILLER_46_246 vssd1 vssd1 vccd1 vccd1 sky130_fd_sc_hd__fill_1
X_12832_ cell2.SB0.route_sel\[74\] cell2.SB0.route_sel\[73\] net778 vssd1 vssd1 vccd1
+ vccd1 _01261_ sky130_fd_sc_hd__mux2_1
XFILLER_36_73 vssd1 vssd1 vccd1 vccd1 sky130_fd_sc_hd__fill_2
X_12763_ cell2.SB0.route_sel\[5\] cell2.SB0.route_sel\[4\] net795 vssd1 vssd1 vccd1
+ vccd1 _01192_ sky130_fd_sc_hd__mux2_1
XTAP_TAPCELL_ROW_83_1556 vssd1 vccd1 sky130_fd_sc_hd__tapvpwrvgnd_1
X_11714_ net1383 net1369 net803 vssd1 vssd1 vccd1 vccd1 _00153_ sky130_fd_sc_hd__mux2_1
XFILLER_14_143 vssd1 vssd1 vccd1 vccd1 sky130_fd_sc_hd__fill_1
X_14433_ clknet_1_0__leaf_cell3.LE_0B.sel_clk _01405_ net754 vssd1 vssd1 vccd1 vccd1
+ cell3.LE_0B.dff1_out sky130_fd_sc_hd__dfstp_1
X_12694_ net392 cell3.CB_1.config_dataA\[10\] net941 vssd1 vssd1 vccd1 vccd1 _01123_
+ sky130_fd_sc_hd__mux2_1
XTAP_TAPCELL_ROW_25_683 vssd1 vccd1 sky130_fd_sc_hd__tapvpwrvgnd_1
X_11645_ net511 net512 net770 vssd1 vssd1 vccd1 vccd1 _00086_ sky130_fd_sc_hd__mux2_1
Xinput37 CBnorth_in[13] vssd1 vssd1 vccd1 vccd1 net37 sky130_fd_sc_hd__buf_2
Xinput15 CBeast_in[22] vssd1 vssd1 vccd1 vccd1 net15 sky130_fd_sc_hd__buf_2
XANTENNA__09451__B1 net300 vssd1 vssd1 vccd1 vccd1 sky130_fd_sc_hd__diode_2
Xinput26 CBeast_in[3] vssd1 vssd1 vccd1 vccd1 net26 sky130_fd_sc_hd__clkbuf_4
X_14364_ clknet_leaf_88_clk _01336_ net727 vssd1 vssd1 vccd1 vccd1 cell3.CB_1.config_dataB\[21\]
+ sky130_fd_sc_hd__dfstp_1
X_11576_ cell0.LE_1B.edge_mode cell0.LE_1B.config_data\[16\] net803 vssd1 vssd1 vccd1
+ vccd1 _00017_ sky130_fd_sc_hd__mux2_1
XANTENNA_input85_X net85 vssd1 vssd1 vccd1 vccd1 sky130_fd_sc_hd__diode_2
Xinput48 CBnorth_in[23] vssd1 vssd1 vccd1 vccd1 net48 sky130_fd_sc_hd__clkbuf_4
Xinput59 CBnorth_in[4] vssd1 vssd1 vccd1 vccd1 net59 sky130_fd_sc_hd__clkbuf_4
XTAP_TAPCELL_ROW_114_2022 vssd1 vccd1 sky130_fd_sc_hd__tapvpwrvgnd_1
XTAP_TAPCELL_ROW_114_2011 vssd1 vccd1 sky130_fd_sc_hd__tapvpwrvgnd_1
X_10527_ _01788_ net394 vssd1 vssd1 vccd1 vccd1 _05485_ sky130_fd_sc_hd__nor2_1
X_14295_ clknet_leaf_16_clk _01267_ net591 vssd1 vssd1 vccd1 vccd1 cell2.SB0.route_sel\[80\]
+ sky130_fd_sc_hd__dfstp_1
X_13315_ clknet_leaf_88_clk _00287_ net690 vssd1 vssd1 vccd1 vccd1 cell1.CB_0.config_dataB\[6\]
+ sky130_fd_sc_hd__dfstp_1
XFILLER_10_393 vssd1 vssd1 vccd1 vccd1 sky130_fd_sc_hd__fill_1
X_10458_ cell3.SB0.route_sel\[80\] cell3.SB0.route_sel\[81\] _01731_ cell3.SB0.route_sel\[84\]
+ _05445_ vssd1 vssd1 vccd1 vccd1 _05446_ sky130_fd_sc_hd__o221a_1
XANTENNA__08006__A1 bus2_0\[7\] vssd1 vssd1 vccd1 vccd1 sky130_fd_sc_hd__diode_2
X_13246_ clknet_leaf_122_clk _00218_ net594 vssd1 vssd1 vccd1 vccd1 cell0.LEI0.config_data\[31\]
+ sky130_fd_sc_hd__dfrtp_1
XANTENNA__09754__A1 _04555_ vssd1 vssd1 vccd1 vccd1 sky130_fd_sc_hd__diode_2
XANTENNA__10364__A2 _05107_ vssd1 vssd1 vccd1 vccd1 sky130_fd_sc_hd__diode_2
X_10389_ _05111_ _05385_ _05387_ _05384_ vssd1 vssd1 vccd1 vccd1 _05388_ sky130_fd_sc_hd__a211o_1
XFILLER_111_402 vssd1 vssd1 vccd1 vccd1 sky130_fd_sc_hd__fill_4
X_13177_ clknet_leaf_118_clk _00149_ net599 vssd1 vssd1 vccd1 vccd1 cell0.LE_0B.config_data\[6\]
+ sky130_fd_sc_hd__dfrtp_1
X_12128_ net1446 cell1.LEI0.config_data\[9\] net899 vssd1 vssd1 vccd1 vccd1 _00561_
+ sky130_fd_sc_hd__mux2_1
XFILLER_2_581 vssd1 vssd1 vccd1 vccd1 sky130_fd_sc_hd__fill_4
X_12059_ net1148 net1008 net888 vssd1 vssd1 vccd1 vccd1 _00495_ sky130_fd_sc_hd__mux2_1
XANTENNA__07517__A0 net7 vssd1 vssd1 vccd1 vccd1 sky130_fd_sc_hd__diode_2
XFILLER_77_393 vssd1 vssd1 vccd1 vccd1 sky130_fd_sc_hd__fill_8
X_06620_ cell3.SB0.route_sel\[17\] vssd1 vssd1 vccd1 vccd1 _01690_ sky130_fd_sc_hd__inv_2
XTAP_TAPCELL_ROW_125_2184 vssd1 vccd1 sky130_fd_sc_hd__tapvpwrvgnd_1
XFILLER_18_460 vssd1 vssd1 vccd1 vccd1 sky130_fd_sc_hd__fill_1
XFILLER_18_471 vssd1 vssd1 vccd1 vccd1 sky130_fd_sc_hd__fill_4
XANTENNA__10300__B _05084_ vssd1 vssd1 vccd1 vccd1 sky130_fd_sc_hd__diode_2
XFILLER_93_90 vssd1 vssd1 vccd1 vccd1 sky130_fd_sc_hd__fill_1
X_06551_ cell2.SB0.route_sel\[70\] vssd1 vssd1 vccd1 vccd1 _01621_ sky130_fd_sc_hd__inv_2
XANTENNA__10824__A0 net17 vssd1 vssd1 vccd1 vccd1 sky130_fd_sc_hd__diode_2
X_09270_ cell2.SB0.route_sel\[21\] cell2.SB0.route_sel\[20\] vssd1 vssd1 vccd1 vccd1
+ _04296_ sky130_fd_sc_hd__nor2_1
X_06482_ cell1.SB0.route_sel\[123\] vssd1 vssd1 vccd1 vccd1 _01552_ sky130_fd_sc_hd__inv_2
XANTENNA__07296__A2 _02351_ vssd1 vssd1 vccd1 vccd1 sky130_fd_sc_hd__diode_2
X_08221_ net342 net346 net349 net339 cell0.LEI0.config_data\[30\] cell0.LEI0.config_data\[31\]
+ vssd1 vssd1 vccd1 vccd1 _03261_ sky130_fd_sc_hd__mux4_1
XANTENNA__08545__X _03581_ vssd1 vssd1 vccd1 vccd1 sky130_fd_sc_hd__diode_2
XTAP_TAPCELL_ROW_44_970 vssd1 vccd1 sky130_fd_sc_hd__tapvpwrvgnd_1
XANTENNA__06506__A cell0.LE_0A.config_data\[16\] vssd1 vssd1 vccd1 vccd1 sky130_fd_sc_hd__diode_2
X_08152_ _02678_ _03167_ _03169_ _02633_ cell0.CB_1.config_dataA\[2\] vssd1 vssd1
+ vccd1 vccd1 _03192_ sky130_fd_sc_hd__a221o_1
XANTENNA__07048__A2 net357 vssd1 vssd1 vccd1 vccd1 sky130_fd_sc_hd__diode_2
XANTENNA__12942__S net932 vssd1 vssd1 vccd1 vccd1 sky130_fd_sc_hd__diode_2
X_07103_ bus3_2\[9\] _02165_ vssd1 vssd1 vccd1 vccd1 _02166_ sky130_fd_sc_hd__nand2_1
Xclkbuf_leaf_9_clk clknet_4_1_0_clk vssd1 vssd1 vccd1 vccd1 clknet_leaf_9_clk sky130_fd_sc_hd__clkbuf_8
XANTENNA_clkbuf_4_3_0_clk_A clknet_0_clk vssd1 vssd1 vccd1 vccd1 sky130_fd_sc_hd__diode_2
X_08083_ net523 net524 vssd1 vssd1 vccd1 vccd1 _03125_ sky130_fd_sc_hd__nor2_1
XFILLER_134_538 vssd1 vssd1 vccd1 vccd1 sky130_fd_sc_hd__fill_1
X_07034_ cell2.CB_0.config_dataA\[24\] cell2.CB_0.config_dataA\[20\] cell2.CB_0.config_dataA\[21\]
+ vssd1 vssd1 vccd1 vccd1 _02099_ sky130_fd_sc_hd__or3_1
XANTENNA__11001__A0 _05912_ vssd1 vssd1 vccd1 vccd1 sky130_fd_sc_hd__diode_2
XFILLER_114_240 vssd1 vssd1 vccd1 vccd1 sky130_fd_sc_hd__fill_1
XTAP_TAPCELL_ROW_54_1124 vssd1 vccd1 sky130_fd_sc_hd__tapvpwrvgnd_1
XTAP_TAPCELL_ROW_54_1113 vssd1 vccd1 sky130_fd_sc_hd__tapvpwrvgnd_1
X_08985_ _04016_ _04013_ _03968_ vssd1 vssd1 vccd1 vccd1 _04017_ sky130_fd_sc_hd__mux2_1
XFILLER_75_319 vssd1 vssd1 vccd1 vccd1 sky130_fd_sc_hd__fill_1
X_07936_ _02979_ _02948_ _02917_ vssd1 vssd1 vccd1 vccd1 _02980_ sky130_fd_sc_hd__mux2_1
XANTENNA__10107__A2 _05107_ vssd1 vssd1 vccd1 vccd1 sky130_fd_sc_hd__diode_2
XANTENNA_fanout749_A net750 vssd1 vssd1 vccd1 vccd1 sky130_fd_sc_hd__diode_2
XANTENNA_fanout272_X net272 vssd1 vssd1 vccd1 vccd1 sky130_fd_sc_hd__diode_2
X_07867_ cell0.CB_0.config_dataA\[6\] _02909_ _02910_ vssd1 vssd1 vccd1 vccd1 _02911_
+ sky130_fd_sc_hd__a21o_1
XTAP_TAPCELL_ROW_3_356 vssd1 vccd1 sky130_fd_sc_hd__tapvpwrvgnd_1
XANTENNA__08181__A0 bus1_0\[12\] vssd1 vssd1 vccd1 vccd1 sky130_fd_sc_hd__diode_2
X_09606_ _04616_ _04622_ _04618_ vssd1 vssd1 vccd1 vccd1 _04623_ sky130_fd_sc_hd__a21oi_1
X_06818_ cell1.CB_0.config_dataB\[24\] cell1.CB_0.config_dataB\[20\] cell1.CB_0.config_dataB\[21\]
+ vssd1 vssd1 vccd1 vccd1 _01888_ sky130_fd_sc_hd__or3b_4
X_07798_ cell0.SB0.route_sel\[47\] cell0.SB0.route_sel\[46\] vssd1 vssd1 vccd1 vccd1
+ _02843_ sky130_fd_sc_hd__nand2b_1
X_09537_ _02165_ net264 _04554_ vssd1 vssd1 vccd1 vccd1 _04556_ sky130_fd_sc_hd__nand3_1
X_06749_ net124 vssd1 vssd1 vccd1 vccd1 _01819_ sky130_fd_sc_hd__inv_2
XANTENNA__10210__B _05144_ vssd1 vssd1 vccd1 vccd1 sky130_fd_sc_hd__diode_2
XANTENNA_fanout916_A net934 vssd1 vssd1 vccd1 vccd1 sky130_fd_sc_hd__diode_2
XFILLER_24_463 vssd1 vssd1 vccd1 vccd1 sky130_fd_sc_hd__fill_4
X_09468_ _04486_ _04488_ _04489_ vssd1 vssd1 vccd1 vccd1 _04490_ sky130_fd_sc_hd__a21o_1
XTAP_TAPCELL_ROW_65_1286 vssd1 vccd1 sky130_fd_sc_hd__tapvpwrvgnd_1
XFILLER_11_113 vssd1 vssd1 vccd1 vccd1 sky130_fd_sc_hd__fill_4
XFILLER_138_811 vssd1 vssd1 vccd1 vccd1 sky130_fd_sc_hd__fill_1
X_08419_ cell0.LE_1B.config_data\[13\] cell0.LE_1B.config_data\[12\] _03380_ vssd1
+ vssd1 vccd1 vccd1 _03457_ sky130_fd_sc_hd__mux2_1
XFILLER_8_629 vccd1 vssd1 vccd1 vssd1 sky130_ef_sc_hd__decap_40_12
XTAP_TAPCELL_ROW_22_631 vssd1 vccd1 sky130_fd_sc_hd__tapvpwrvgnd_1
XTAP_TAPCELL_ROW_22_642 vssd1 vccd1 sky130_fd_sc_hd__tapvpwrvgnd_1
X_09399_ _03887_ _03888_ _03889_ _02866_ _02861_ vssd1 vssd1 vccd1 vccd1 _04422_ sky130_fd_sc_hd__a311o_1
X_11430_ _01486_ cell0.SB0.route_sel\[114\] vssd1 vssd1 vccd1 vccd1 _06287_ sky130_fd_sc_hd__nand2_1
XFILLER_125_3 vccd1 vssd1 vccd1 vssd1 sky130_ef_sc_hd__decap_40_12
X_11361_ clknet_leaf_66_clk cell3.LE_1A.edge_mode vssd1 vssd1 vccd1 vccd1 cell3.LE_1A.sel_clk
+ sky130_fd_sc_hd__xnor2_2
XFILLER_4_802 vssd1 vssd1 vccd1 vccd1 sky130_fd_sc_hd__fill_8
XFILLER_22_53 vssd1 vssd1 vccd1 vccd1 sky130_fd_sc_hd__fill_2
XFILLER_138_53 vccd1 vssd1 vccd1 vssd1 sky130_ef_sc_hd__decap_40_12
X_10312_ net435 _05128_ _05310_ vssd1 vssd1 vccd1 vccd1 _05311_ sky130_fd_sc_hd__a21o_1
XANTENNA__07995__A0 bus2_0\[8\] vssd1 vssd1 vccd1 vccd1 sky130_fd_sc_hd__diode_2
X_13100_ clknet_leaf_5_clk _00072_ net564 vssd1 vssd1 vccd1 vccd1 cell0.CB_0.config_dataA\[2\]
+ sky130_fd_sc_hd__dfstp_1
XFILLER_4_813 vssd1 vssd1 vccd1 vccd1 sky130_fd_sc_hd__fill_4
XFILLER_138_97 vccd1 vssd1 vccd1 vssd1 sky130_ef_sc_hd__decap_40_12
X_11292_ net645 cell2.LE_0A.reset_mode vssd1 vssd1 vccd1 vccd1 _11292_/X sky130_fd_sc_hd__xor2_2
X_14080_ clknet_leaf_80_clk _01052_ net707 vssd1 vssd1 vccd1 vccd1 cell3.SB0.route_sel\[88\]
+ sky130_fd_sc_hd__dfstp_1
X_10243_ net61 net62 net412 vssd1 vssd1 vccd1 vccd1 _05244_ sky130_fd_sc_hd__mux2_1
X_13031_ clknet_leaf_119_clk net1137 net595 vssd1 vssd1 vccd1 vccd1 cell0.LE_1B.config_data\[3\]
+ sky130_fd_sc_hd__dfrtp_1
XANTENNA_input45_A CBnorth_in[20] vssd1 vssd1 vccd1 vccd1 sky130_fd_sc_hd__diode_2
X_10174_ cell2.CB_0.config_dataA\[3\] cell2.CB_0.config_dataA\[2\] vssd1 vssd1 vccd1
+ vccd1 _05175_ sky130_fd_sc_hd__nor2_1
XANTENNA__07534__X _02585_ vssd1 vssd1 vccd1 vccd1 sky130_fd_sc_hd__diode_2
XFILLER_19_213 vssd1 vssd1 vccd1 vccd1 sky130_fd_sc_hd__fill_4
X_13933_ clknet_leaf_25_clk _00905_ net609 vssd1 vssd1 vccd1 vccd1 cell2.LE_0A.config_data\[12\]
+ sky130_fd_sc_hd__dfrtp_1
X_13864_ clknet_leaf_43_clk _00836_ net628 vssd1 vssd1 vccd1 vccd1 cell2.CB_1.config_dataB\[13\]
+ sky130_fd_sc_hd__dfstp_1
XFILLER_19_279 vssd1 vssd1 vccd1 vccd1 sky130_fd_sc_hd__fill_1
XANTENNA__11059__A0 net40 vssd1 vssd1 vccd1 vccd1 sky130_fd_sc_hd__diode_2
X_12815_ cell2.SB0.route_sel\[57\] cell2.SB0.route_sel\[56\] net810 vssd1 vssd1 vccd1
+ vccd1 _01244_ sky130_fd_sc_hd__mux2_1
XANTENNA_output201_A net201 vssd1 vssd1 vccd1 vccd1 sky130_fd_sc_hd__diode_2
X_13795_ clknet_leaf_105_clk _00767_ net661 vssd1 vssd1 vccd1 vccd1 cell1.SB0.route_sel\[72\]
+ sky130_fd_sc_hd__dfstp_2
X_12746_ cell3.CB_0.config_dataA\[13\] cell3.CB_0.config_dataA\[12\] net927 vssd1
+ vssd1 vccd1 vccd1 _01175_ sky130_fd_sc_hd__mux2_1
X_12677_ cell3.LE_1B.config_data\[14\] net1351 net953 vssd1 vssd1 vccd1 vccd1 _01106_
+ sky130_fd_sc_hd__mux2_1
X_14416_ clknet_leaf_38_clk _01388_ net717 vssd1 vssd1 vccd1 vccd1 cell3.LE_0A.config_data\[3\]
+ sky130_fd_sc_hd__dfrtp_1
X_11628_ cell0.CB_0.config_dataB\[24\] cell0.CB_0.config_dataB\[23\] net777 vssd1
+ vssd1 vccd1 vccd1 _00069_ sky130_fd_sc_hd__mux2_1
XANTENNA__13837__SET_B net674 vssd1 vssd1 vccd1 vccd1 sky130_fd_sc_hd__diode_2
XFILLER_30_466 vssd1 vssd1 vccd1 vccd1 sky130_fd_sc_hd__fill_4
XFILLER_128_343 vssd1 vssd1 vccd1 vccd1 sky130_fd_sc_hd__fill_1
X_14347_ clknet_leaf_67_clk _01319_ net736 vssd1 vssd1 vccd1 vccd1 cell3.CB_1.config_dataB\[4\]
+ sky130_fd_sc_hd__dfstp_1
XFILLER_8_77 vssd1 vssd1 vccd1 vccd1 sky130_fd_sc_hd__fill_4
XTAP_TAPCELL_ROW_96_1747 vssd1 vccd1 sky130_fd_sc_hd__tapvpwrvgnd_1
X_11559_ net1466 cell0.LE_0A.reset_mode net799 vssd1 vssd1 vccd1 vccd1 _00000_ sky130_fd_sc_hd__mux2_1
XFILLER_7_673 vccd1 vssd1 vccd1 vssd1 sky130_ef_sc_hd__decap_40_12
X_14278_ clknet_leaf_22_clk _01250_ net604 vssd1 vssd1 vccd1 vccd1 cell2.SB0.route_sel\[63\]
+ sky130_fd_sc_hd__dfstp_1
XANTENNA__10337__A2 net34 vssd1 vssd1 vccd1 vccd1 sky130_fd_sc_hd__diode_2
XANTENNA__10135__X _05136_ vssd1 vssd1 vccd1 vccd1 sky130_fd_sc_hd__diode_2
X_13229_ clknet_leaf_2_clk _00201_ net571 vssd1 vssd1 vccd1 vccd1 cell0.LEI0.config_data\[14\]
+ sky130_fd_sc_hd__dfrtp_1
XTAP_TAPCELL_ROW_127_2213 vssd1 vccd1 sky130_fd_sc_hd__tapvpwrvgnd_1
XANTENNA__08950__A2 bus3_1\[2\] vssd1 vssd1 vccd1 vccd1 sky130_fd_sc_hd__diode_2
X_08770_ _03769_ _03803_ _03767_ vssd1 vssd1 vccd1 vccd1 _03804_ sky130_fd_sc_hd__mux2_1
XFILLER_38_533 vssd1 vssd1 vccd1 vccd1 sky130_fd_sc_hd__fill_2
X_07721_ _01964_ _02640_ vssd1 vssd1 vccd1 vccd1 _02768_ sky130_fd_sc_hd__nor2_1
XTAP_TAPCELL_ROW_140_2413 vssd1 vccd1 sky130_fd_sc_hd__tapvpwrvgnd_1
XTAP_TAPCELL_ROW_140_2402 vssd1 vccd1 sky130_fd_sc_hd__tapvpwrvgnd_1
XFILLER_53_503 vssd1 vssd1 vccd1 vccd1 sky130_fd_sc_hd__fill_1
XTAP_TAPCELL_ROW_0_315 vssd1 vccd1 sky130_fd_sc_hd__tapvpwrvgnd_1
XTAP_TAPCELL_ROW_0_304 vssd1 vccd1 sky130_fd_sc_hd__tapvpwrvgnd_1
X_07652_ _02700_ _02698_ vssd1 vssd1 vccd1 vccd1 bus1_0\[1\] sky130_fd_sc_hd__and2b_2
X_06603_ cell3.SB0.route_sel\[1\] vssd1 vssd1 vccd1 vccd1 _01673_ sky130_fd_sc_hd__inv_2
X_07583_ _02630_ _02632_ vssd1 vssd1 vccd1 vccd1 _02633_ sky130_fd_sc_hd__or2_4
X_09322_ cell2.SB0.route_sel\[31\] _01595_ cell2.SB0.route_sel\[29\] cell2.SB0.route_sel\[28\]
+ _04346_ vssd1 vssd1 vccd1 vccd1 _04347_ sky130_fd_sc_hd__o221a_1
X_06534_ cell0.SB0.route_sel\[36\] vssd1 vssd1 vccd1 vccd1 _01604_ sky130_fd_sc_hd__inv_2
XTAP_TAPCELL_ROW_105_1887 vssd1 vccd1 sky130_fd_sc_hd__tapvpwrvgnd_1
XTAP_TAPCELL_ROW_105_1876 vssd1 vccd1 sky130_fd_sc_hd__tapvpwrvgnd_1
XANTENNA__07269__A2 net358 vssd1 vssd1 vccd1 vccd1 sky130_fd_sc_hd__diode_2
X_09253_ _01900_ _04173_ vssd1 vssd1 vccd1 vccd1 _04279_ sky130_fd_sc_hd__nor2_2
X_06465_ cell1.SB0.route_sel\[86\] vssd1 vssd1 vccd1 vccd1 _01535_ sky130_fd_sc_hd__inv_2
XTAP_TAPCELL_ROW_138_2375 vssd1 vccd1 sky130_fd_sc_hd__tapvpwrvgnd_1
X_09184_ net287 net8 _04211_ vssd1 vssd1 vccd1 vccd1 _04212_ sky130_fd_sc_hd__mux2_1
X_08204_ cell0.CB_1.config_dataA\[13\] _03237_ _03241_ _03243_ vssd1 vssd1 vccd1 vccd1
+ _03244_ sky130_fd_sc_hd__and4_1
X_06396_ cell0.SB0.route_sel\[65\] vssd1 vssd1 vccd1 vccd1 _01466_ sky130_fd_sc_hd__inv_2
X_08135_ net546 _02494_ net544 vssd1 vssd1 vccd1 vccd1 _03175_ sky130_fd_sc_hd__o21ai_1
XFILLER_135_836 vssd1 vssd1 vccd1 vccd1 sky130_fd_sc_hd__fill_1
XFILLER_135_825 vssd1 vssd1 vccd1 vccd1 sky130_fd_sc_hd__fill_1
XANTENNA__10576__A2 net19 vssd1 vssd1 vccd1 vccd1 sky130_fd_sc_hd__diode_2
XFILLER_4_109 vccd1 vssd1 vccd1 vssd1 sky130_ef_sc_hd__decap_40_12
Xclkbuf_0_cell3.LE_1A.sel_clk cell3.LE_1A.sel_clk vssd1 vssd1 vccd1 vccd1 clknet_0_cell3.LE_1A.sel_clk
+ sky130_fd_sc_hd__clkbuf_16
X_08066_ _02887_ _03091_ _03092_ _02890_ _01559_ vssd1 vssd1 vccd1 vccd1 _03108_ sky130_fd_sc_hd__a221o_1
X_07017_ cell2.CB_1.config_dataB\[24\] cell2.CB_1.config_dataB\[21\] cell2.CB_1.config_dataB\[20\]
+ vssd1 vssd1 vccd1 vccd1 _02082_ sky130_fd_sc_hd__or3_1
XANTENNA_fanout699_A net700 vssd1 vssd1 vccd1 vccd1 sky130_fd_sc_hd__diode_2
XTAP_TAPCELL_ROW_8_426 vssd1 vccd1 sky130_fd_sc_hd__tapvpwrvgnd_1
XANTENNA__10328__A2 _05107_ vssd1 vssd1 vccd1 vccd1 sky130_fd_sc_hd__diode_2
XFILLER_88_433 vssd1 vssd1 vccd1 vccd1 sky130_fd_sc_hd__fill_1
XFILLER_0_304 vssd1 vssd1 vccd1 vccd1 sky130_fd_sc_hd__fill_4
X_08968_ net331 net327 cell1.LEI0.config_data\[36\] vssd1 vssd1 vccd1 vccd1 _04000_
+ sky130_fd_sc_hd__mux2_1
X_08899_ net472 _03928_ _03929_ _03930_ vssd1 vssd1 vccd1 vccd1 _03931_ sky130_fd_sc_hd__a31o_1
X_07919_ bus2_0\[0\] bus2_0\[1\] bus2_0\[2\] bus2_0\[3\] net516 net514 vssd1 vssd1
+ vccd1 vccd1 _02963_ sky130_fd_sc_hd__mux4_1
XANTENNA__13008__S net952 vssd1 vssd1 vccd1 vccd1 sky130_fd_sc_hd__diode_2
X_10930_ _05883_ vssd1 vssd1 vccd1 vccd1 _05884_ sky130_fd_sc_hd__inv_2
XTAP_TAPCELL_ROW_67_1315 vssd1 vccd1 sky130_fd_sc_hd__tapvpwrvgnd_1
XFILLER_17_706 vssd1 vssd1 vccd1 vccd1 sky130_fd_sc_hd__fill_1
XFILLER_83_193 vssd1 vssd1 vccd1 vccd1 sky130_fd_sc_hd__fill_1
XANTENNA__08329__C _02350_ vssd1 vssd1 vccd1 vccd1 sky130_fd_sc_hd__diode_2
XTAP_TAPCELL_ROW_27_712 vssd1 vccd1 sky130_fd_sc_hd__tapvpwrvgnd_1
XFILLER_140_65 vccd1 vssd1 vccd1 vssd1 sky130_ef_sc_hd__decap_40_12
X_10861_ net8 net9 net10 net11 net365 net364 vssd1 vssd1 vccd1 vccd1 _05817_ sky130_fd_sc_hd__mux4_1
X_12600_ cell3.SB0.route_sel\[65\] cell3.SB0.route_sel\[64\] net910 vssd1 vssd1 vccd1
+ vccd1 _01029_ sky130_fd_sc_hd__mux2_1
X_10792_ net369 _05501_ _05747_ net368 vssd1 vssd1 vccd1 vccd1 _05748_ sky130_fd_sc_hd__o211a_1
XTAP_TAPCELL_ROW_80_1515 vssd1 vccd1 sky130_fd_sc_hd__tapvpwrvgnd_1
XTAP_TAPCELL_ROW_80_1504 vssd1 vccd1 sky130_fd_sc_hd__tapvpwrvgnd_1
X_13580_ clknet_leaf_89_clk net1461 net697 vssd1 vssd1 vccd1 vccd1 cell1.LEI0.config_data\[1\]
+ sky130_fd_sc_hd__dfrtp_1
XFILLER_129_107 vssd1 vssd1 vccd1 vccd1 sky130_fd_sc_hd__fill_1
X_12531_ net1438 net1502 net838 vssd1 vssd1 vccd1 vccd1 _00960_ sky130_fd_sc_hd__mux2_1
X_12462_ net967 net549 _06383_ vssd1 vssd1 vccd1 vccd1 _00892_ sky130_fd_sc_hd__a21bo_1
X_14201_ clknet_leaf_54_clk _01173_ net717 vssd1 vssd1 vccd1 vccd1 cell3.CB_0.config_dataA\[11\]
+ sky130_fd_sc_hd__dfstp_1
X_11413_ cell0.SB0.route_sel\[88\] cell0.SB0.route_sel\[89\] cell0.SB0.route_sel\[91\]
+ _01475_ _06275_ vssd1 vssd1 vccd1 vccd1 _06276_ sky130_fd_sc_hd__o221a_1
XANTENNA__10567__A2 _05519_ vssd1 vssd1 vccd1 vccd1 sky130_fd_sc_hd__diode_2
X_12393_ cell2.CB_1.config_dataB\[3\] cell2.CB_1.config_dataB\[2\] net835 vssd1 vssd1
+ vccd1 vccd1 _00826_ sky130_fd_sc_hd__mux2_1
X_11344_ _06237_ net282 _04546_ vssd1 vssd1 vccd1 vccd1 net182 sky130_fd_sc_hd__mux2_1
X_14132_ clknet_leaf_65_clk _01104_ net745 vssd1 vssd1 vccd1 vccd1 cell3.LE_1B.config_data\[12\]
+ sky130_fd_sc_hd__dfrtp_1
XTAP_TAPCELL_ROW_78_1477 vssd1 vccd1 sky130_fd_sc_hd__tapvpwrvgnd_1
XFILLER_4_643 vssd1 vssd1 vccd1 vccd1 sky130_fd_sc_hd__fill_1
XFILLER_141_839 vssd1 vssd1 vccd1 vccd1 sky130_fd_sc_hd__fill_1
X_11275_ _02314_ _05084_ vssd1 vssd1 vccd1 vccd1 _06206_ sky130_fd_sc_hd__nand2_1
X_14063_ clknet_leaf_82_clk _01035_ net701 vssd1 vssd1 vccd1 vccd1 cell3.SB0.route_sel\[71\]
+ sky130_fd_sc_hd__dfstp_2
XPHY_EDGE_ROW_18_Left_161 vssd1 vssd1 vccd1 vccd1 sky130_fd_sc_hd__decap_3
XANTENNA_input48_X net48 vssd1 vssd1 vccd1 vccd1 sky130_fd_sc_hd__diode_2
X_13014_ net1414 cell3.LEI0.config_data\[34\] net951 vssd1 vssd1 vccd1 vccd1 _01442_
+ sky130_fd_sc_hd__mux2_1
X_10226_ _01769_ _05207_ _05210_ _05226_ _01771_ vssd1 vssd1 vccd1 vccd1 _05227_ sky130_fd_sc_hd__o311a_1
XFILLER_106_571 vssd1 vssd1 vccd1 vccd1 sky130_fd_sc_hd__fill_1
XTAP_TAPCELL_ROW_91_1666 vssd1 vccd1 sky130_fd_sc_hd__tapvpwrvgnd_1
XFILLER_79_422 vssd1 vssd1 vccd1 vccd1 sky130_fd_sc_hd__fill_1
XANTENNA__07506__A_N cell0.SB0.config_data_out vssd1 vssd1 vccd1 vccd1 sky130_fd_sc_hd__diode_2
XANTENNA_output249_A net249 vssd1 vssd1 vccd1 vccd1 sky130_fd_sc_hd__diode_2
XFILLER_121_530 vssd1 vssd1 vccd1 vccd1 sky130_fd_sc_hd__fill_1
XTAP_TAPCELL_ROW_91_1677 vssd1 vccd1 sky130_fd_sc_hd__tapvpwrvgnd_1
XFILLER_79_455 vssd1 vssd1 vccd1 vccd1 sky130_fd_sc_hd__fill_1
XFILLER_79_444 vssd1 vssd1 vccd1 vccd1 sky130_fd_sc_hd__fill_4
Xhold4 cell2.LE_1A.dff0_out vssd1 vssd1 vccd1 vccd1 net963 sky130_fd_sc_hd__dlygate4sd3_1
X_10157_ net33 _05098_ _05157_ net417 cell2.CB_0.config_dataA\[7\] vssd1 vssd1 vccd1
+ vccd1 _05158_ sky130_fd_sc_hd__a221o_1
X_10088_ net419 _05088_ _05085_ net417 vssd1 vssd1 vccd1 vccd1 _05089_ sky130_fd_sc_hd__o211a_1
XANTENNA__07264__X bus2_0\[11\] vssd1 vssd1 vccd1 vccd1 sky130_fd_sc_hd__diode_2
X_13916_ clknet_leaf_36_clk _00888_ net639 vssd1 vssd1 vccd1 vccd1 cell2.LE_0B.edge_mode
+ sky130_fd_sc_hd__dfstp_1
XFILLER_35_503 vssd1 vssd1 vccd1 vccd1 sky130_fd_sc_hd__fill_1
XTAP_TAPCELL_ROW_122_2143 vssd1 vccd1 sky130_fd_sc_hd__tapvpwrvgnd_1
XTAP_TAPCELL_ROW_122_2132 vssd1 vccd1 sky130_fd_sc_hd__tapvpwrvgnd_1
XFILLER_74_193 vssd1 vssd1 vccd1 vccd1 sky130_fd_sc_hd__fill_2
XANTENNA__07143__C _02032_ vssd1 vssd1 vccd1 vccd1 sky130_fd_sc_hd__diode_2
X_13847_ clknet_leaf_120_clk _00819_ net596 vssd1 vssd1 vccd1 vccd1 cell1.SB0.route_sel\[124\]
+ sky130_fd_sc_hd__dfstp_1
XPHY_EDGE_ROW_27_Left_170 vssd1 vssd1 vccd1 vccd1 sky130_fd_sc_hd__decap_3
XANTENNA__11047__A3 net57 vssd1 vssd1 vccd1 vccd1 sky130_fd_sc_hd__diode_2
X_13778_ clknet_leaf_109_clk _00750_ net653 vssd1 vssd1 vccd1 vccd1 cell1.SB0.route_sel\[55\]
+ sky130_fd_sc_hd__dfstp_1
XANTENNA__10255__B2 _05093_ vssd1 vssd1 vccd1 vccd1 sky130_fd_sc_hd__diode_2
XANTENNA__10255__A1 _02106_ vssd1 vssd1 vccd1 vccd1 sky130_fd_sc_hd__diode_2
X_12729_ cell3.CB_0.config_dataB\[21\] cell3.CB_0.config_dataB\[20\] net930 vssd1
+ vssd1 vccd1 vccd1 _01158_ sky130_fd_sc_hd__mux2_1
XANTENNA__11204__A0 net42 vssd1 vssd1 vccd1 vccd1 sky130_fd_sc_hd__diode_2
XANTENNA__10007__B2 _04197_ vssd1 vssd1 vccd1 vccd1 sky130_fd_sc_hd__diode_2
XANTENNA__10007__A1 _04260_ vssd1 vssd1 vccd1 vccd1 sky130_fd_sc_hd__diode_2
XFILLER_117_814 vssd1 vssd1 vccd1 vccd1 sky130_fd_sc_hd__fill_1
Xhold404 cell2.LE_0B.config_data\[5\] vssd1 vssd1 vccd1 vccd1 net1363 sky130_fd_sc_hd__dlygate4sd3_1
XFILLER_128_195 vssd1 vssd1 vccd1 vccd1 sky130_fd_sc_hd__fill_1
XANTENNA__09367__A net59 vssd1 vssd1 vccd1 vccd1 sky130_fd_sc_hd__diode_2
XANTENNA__13934__RESET_B net619 vssd1 vssd1 vccd1 vccd1 sky130_fd_sc_hd__diode_2
Xhold415 cell0.LEI0.config_data\[44\] vssd1 vssd1 vccd1 vccd1 net1374 sky130_fd_sc_hd__dlygate4sd3_1
Xhold426 cell0.LEI0.config_data\[46\] vssd1 vssd1 vccd1 vccd1 net1385 sky130_fd_sc_hd__dlygate4sd3_1
Xhold448 _01344_ vssd1 vssd1 vccd1 vccd1 net1407 sky130_fd_sc_hd__dlygate4sd3_1
Xhold437 cell3.LE_1A.config_data\[15\] vssd1 vssd1 vccd1 vccd1 net1396 sky130_fd_sc_hd__dlygate4sd3_1
X_09940_ _04943_ vssd1 vssd1 vccd1 vccd1 _04944_ sky130_fd_sc_hd__inv_2
Xhold459 _00215_ vssd1 vssd1 vccd1 vccd1 net1418 sky130_fd_sc_hd__dlygate4sd3_1
XPHY_EDGE_ROW_115_Right_115 vssd1 vssd1 vccd1 vccd1 sky130_fd_sc_hd__decap_3
Xfanout906 net907 vssd1 vssd1 vccd1 vccd1 net906 sky130_fd_sc_hd__clkbuf_2
Xfanout928 net929 vssd1 vssd1 vccd1 vccd1 net928 sky130_fd_sc_hd__buf_2
XFILLER_124_390 vssd1 vssd1 vccd1 vccd1 sky130_fd_sc_hd__fill_1
X_09871_ _04527_ _04876_ vssd1 vssd1 vccd1 vccd1 _04877_ sky130_fd_sc_hd__and2b_1
Xfanout917 net920 vssd1 vssd1 vccd1 vccd1 net917 sky130_fd_sc_hd__clkbuf_4
Xfanout939 net940 vssd1 vssd1 vccd1 vccd1 net939 sky130_fd_sc_hd__clkbuf_2
XFILLER_112_596 vssd1 vssd1 vccd1 vccd1 sky130_fd_sc_hd__fill_4
X_08822_ _03827_ _03849_ _03853_ _03831_ cell1.CB_0.config_dataA\[7\] vssd1 vssd1
+ vccd1 vccd1 _03854_ sky130_fd_sc_hd__a221o_1
XANTENNA__08923__A2 _03817_ vssd1 vssd1 vccd1 vccd1 sky130_fd_sc_hd__diode_2
XANTENNA__07174__X _02235_ vssd1 vssd1 vccd1 vccd1 sky130_fd_sc_hd__diode_2
X_08753_ cell1.CB_1.config_dataB\[18\] cell1.CB_1.config_dataB\[17\] vssd1 vssd1 vccd1
+ vccd1 _03787_ sky130_fd_sc_hd__nor2_1
XTAP_TAPCELL_ROW_107_1916 vssd1 vccd1 sky130_fd_sc_hd__tapvpwrvgnd_1
X_07704_ cell0.SB0.route_sel\[28\] cell0.SB0.route_sel\[29\] net122 _02749_ _02748_
+ vssd1 vssd1 vccd1 vccd1 _02751_ sky130_fd_sc_hd__a41o_1
XANTENNA__12483__A2 net549 vssd1 vssd1 vccd1 vccd1 sky130_fd_sc_hd__diode_2
XFILLER_81_642 vssd1 vssd1 vccd1 vccd1 sky130_fd_sc_hd__fill_2
XANTENNA__08687__A1 net12 vssd1 vssd1 vccd1 vccd1 sky130_fd_sc_hd__diode_2
X_08684_ net461 _03529_ vssd1 vssd1 vccd1 vccd1 _03718_ sky130_fd_sc_hd__nand2_1
XTAP_TAPCELL_ROW_49_1045 vssd1 vccd1 sky130_fd_sc_hd__tapvpwrvgnd_1
X_07635_ net73 _02680_ vssd1 vssd1 vccd1 vccd1 _02684_ sky130_fd_sc_hd__nand2_1
X_07566_ cell0.SB0.route_sel\[7\] cell0.SB0.route_sel\[6\] vssd1 vssd1 vccd1 vccd1
+ _02616_ sky130_fd_sc_hd__nand2_1
XFILLER_139_405 vssd1 vssd1 vccd1 vccd1 sky130_fd_sc_hd__fill_2
XFILLER_110_68 vssd1 vssd1 vccd1 vccd1 sky130_fd_sc_hd__fill_1
X_09305_ net107 cell2.SB0.route_sel\[29\] cell2.SB0.route_sel\[28\] vssd1 vssd1 vccd1
+ vccd1 _04330_ sky130_fd_sc_hd__and3_1
X_06517_ cell2.SB0.route_sel\[18\] vssd1 vssd1 vccd1 vccd1 _01587_ sky130_fd_sc_hd__inv_2
XTAP_TAPCELL_ROW_62_1245 vssd1 vccd1 sky130_fd_sc_hd__tapvpwrvgnd_1
XTAP_TAPCELL_ROW_62_1234 vssd1 vccd1 sky130_fd_sc_hd__tapvpwrvgnd_1
XANTENNA__07350__A net355 vssd1 vssd1 vccd1 vccd1 sky130_fd_sc_hd__diode_2
X_09236_ _04242_ _04261_ _04262_ vssd1 vssd1 vccd1 vccd1 _04263_ sky130_fd_sc_hd__a21o_1
X_07497_ _02547_ _02548_ _02544_ _02545_ vssd1 vssd1 vccd1 vccd1 _02549_ sky130_fd_sc_hd__a2bb2o_1
XANTENNA__09939__A1 bus3_2\[9\] vssd1 vssd1 vccd1 vccd1 sky130_fd_sc_hd__diode_2
X_06448_ cell1.SB0.route_sel\[51\] vssd1 vssd1 vccd1 vccd1 _01518_ sky130_fd_sc_hd__inv_2
XPHY_EDGE_ROW_17_Right_17 vssd1 vssd1 vccd1 vccd1 sky130_fd_sc_hd__decap_3
XTAP_TAPCELL_ROW_32_781 vssd1 vccd1 sky130_fd_sc_hd__tapvpwrvgnd_1
XTAP_TAPCELL_ROW_32_792 vssd1 vccd1 sky130_fd_sc_hd__tapvpwrvgnd_1
XANTENNA__10549__A2 _05501_ vssd1 vssd1 vccd1 vccd1 sky130_fd_sc_hd__diode_2
X_09167_ cell2.SB0.route_sel\[5\] cell2.SB0.route_sel\[4\] vssd1 vssd1 vccd1 vccd1
+ _04195_ sky130_fd_sc_hd__nor2_1
XFILLER_119_184 vssd1 vssd1 vccd1 vccd1 sky130_fd_sc_hd__fill_1
XFILLER_119_55 vssd1 vssd1 vccd1 vccd1 sky130_fd_sc_hd__fill_1
XFILLER_108_847 vssd1 vssd1 vccd1 vccd1 sky130_fd_sc_hd__fill_1
XFILLER_79_15 vssd1 vssd1 vccd1 vccd1 sky130_fd_sc_hd__fill_1
X_08118_ cell0.LE_0B.config_data\[11\] cell0.LE_0B.config_data\[10\] _03087_ vssd1
+ vssd1 vccd1 vccd1 _03160_ sky130_fd_sc_hd__mux2_1
X_09098_ net475 net476 vssd1 vssd1 vccd1 vccd1 _04128_ sky130_fd_sc_hd__nor2_1
X_08049_ net526 net527 vssd1 vssd1 vccd1 vccd1 _03091_ sky130_fd_sc_hd__nor2_1
X_11060_ cell3.CB_0.config_dataA\[18\] cell3.CB_0.config_dataA\[17\] vssd1 vssd1 vccd1
+ vccd1 _06014_ sky130_fd_sc_hd__nor2_1
XANTENNA__10216__A _05136_ vssd1 vssd1 vccd1 vccd1 sky130_fd_sc_hd__diode_2
XFILLER_1_613 vssd1 vssd1 vccd1 vccd1 sky130_fd_sc_hd__fill_2
X_10011_ cell2.CB_1.config_dataB\[11\] _05013_ _05014_ vssd1 vssd1 vccd1 vccd1 _05015_
+ sky130_fd_sc_hd__a21oi_1
XANTENNA__08375__A0 net342 vssd1 vssd1 vccd1 vccd1 sky130_fd_sc_hd__diode_2
XFILLER_0_134 vssd1 vssd1 vccd1 vccd1 sky130_fd_sc_hd__fill_4
XTAP_TAPCELL_ROW_73_1396 vssd1 vccd1 sky130_fd_sc_hd__tapvpwrvgnd_1
XFILLER_49_617 vssd1 vssd1 vccd1 vccd1 sky130_fd_sc_hd__fill_1
XPHY_EDGE_ROW_26_Right_26 vssd1 vssd1 vccd1 vccd1 sky130_fd_sc_hd__decap_3
XFILLER_103_596 vssd1 vssd1 vccd1 vccd1 sky130_fd_sc_hd__fill_4
XFILLER_76_458 vssd1 vssd1 vccd1 vccd1 sky130_fd_sc_hd__fill_2
XFILLER_28_41 vccd1 vssd1 vccd1 vssd1 sky130_ef_sc_hd__decap_40_12
XFILLER_17_503 vssd1 vssd1 vccd1 vccd1 sky130_fd_sc_hd__fill_1
X_13701_ clknet_leaf_27_clk _00673_ net613 vssd1 vssd1 vccd1 vccd1 cell2.CB_0.config_dataA\[3\]
+ sky130_fd_sc_hd__dfstp_1
X_11962_ cell0.SB0.route_sel\[68\] cell0.SB0.route_sel\[67\] net764 vssd1 vssd1 vccd1
+ vccd1 _00399_ sky130_fd_sc_hd__mux2_1
XFILLER_29_374 vssd1 vssd1 vccd1 vccd1 sky130_fd_sc_hd__fill_1
X_10913_ _05866_ vssd1 vssd1 vccd1 vccd1 _05867_ sky130_fd_sc_hd__inv_2
X_11893_ cell1.CB_0.config_dataA\[24\] cell1.CB_0.config_dataA\[23\] net875 vssd1
+ vssd1 vccd1 vccd1 _00330_ sky130_fd_sc_hd__mux2_1
XFILLER_17_558 vssd1 vssd1 vccd1 vccd1 sky130_fd_sc_hd__fill_2
X_13632_ clknet_leaf_39_clk net1275 net647 vssd1 vssd1 vccd1 vccd1 cell2.LE_1B.config_data\[4\]
+ sky130_fd_sc_hd__dfrtp_1
X_10844_ net21 net22 net24 net25 net365 cell3.CB_1.config_dataB\[16\] vssd1 vssd1
+ vccd1 vccd1 _05800_ sky130_fd_sc_hd__mux4_1
X_13563_ clknet_leaf_118_clk net1356 net598 vssd1 vssd1 vccd1 vccd1 cell1.LE_0A.config_data\[6\]
+ sky130_fd_sc_hd__dfrtp_1
XANTENNA_clkbuf_4_11_0_clk_A clknet_0_clk vssd1 vssd1 vccd1 vccd1 sky130_fd_sc_hd__diode_2
X_12514_ net1470 net1336 net843 vssd1 vssd1 vccd1 vccd1 _00943_ sky130_fd_sc_hd__mux2_1
X_10775_ net21 net22 net24 net25 cell3.CB_1.config_dataB\[5\] cell3.CB_1.config_dataB\[6\]
+ vssd1 vssd1 vccd1 vccd1 _05731_ sky130_fd_sc_hd__mux4_1
XANTENNA__09739__X bus2_0\[2\] vssd1 vssd1 vccd1 vccd1 sky130_fd_sc_hd__diode_2
XPHY_EDGE_ROW_35_Right_35 vssd1 vssd1 vccd1 vccd1 sky130_fd_sc_hd__decap_3
X_13494_ clknet_leaf_94_clk _00466_ net692 vssd1 vssd1 vccd1 vccd1 cell1.CB_1.config_dataB\[7\]
+ sky130_fd_sc_hd__dfstp_2
XFILLER_9_746 vssd1 vssd1 vccd1 vccd1 sky130_fd_sc_hd__fill_1
XANTENNA_output199_A net199 vssd1 vssd1 vccd1 vccd1 sky130_fd_sc_hd__diode_2
X_12445_ net1363 cell2.LE_0B.config_data\[4\] net827 vssd1 vssd1 vccd1 vccd1 _00876_
+ sky130_fd_sc_hd__mux2_1
XTAP_TAPCELL_ROW_93_1706 vssd1 vccd1 sky130_fd_sc_hd__tapvpwrvgnd_1
XTAP_TAPCELL_ROW_10_453 vssd1 vccd1 sky130_fd_sc_hd__tapvpwrvgnd_1
XTAP_TAPCELL_ROW_10_464 vssd1 vccd1 sky130_fd_sc_hd__tapvpwrvgnd_1
X_12376_ cell1.SB0.route_sel\[114\] cell1.SB0.route_sel\[113\] net882 vssd1 vssd1
+ vccd1 vccd1 _00809_ sky130_fd_sc_hd__mux2_1
X_11327_ net278 _05924_ _04217_ vssd1 vssd1 vccd1 vccd1 _06229_ sky130_fd_sc_hd__mux2_1
X_14115_ clknet_leaf_49_clk _01087_ net705 vssd1 vssd1 vccd1 vccd1 cell3.SB0.route_sel\[123\]
+ sky130_fd_sc_hd__dfstp_1
XFILLER_126_699 vssd1 vssd1 vccd1 vccd1 sky130_fd_sc_hd__fill_1
XFILLER_4_473 vssd1 vssd1 vccd1 vccd1 sky130_fd_sc_hd__fill_2
X_11258_ net311 _04341_ _04342_ _06196_ vssd1 vssd1 vccd1 vccd1 net191 sky130_fd_sc_hd__a22o_1
X_14046_ clknet_leaf_49_clk _01018_ net705 vssd1 vssd1 vccd1 vccd1 cell3.SB0.route_sel\[54\]
+ sky130_fd_sc_hd__dfstp_1
XPHY_EDGE_ROW_44_Right_44 vssd1 vssd1 vccd1 vccd1 sky130_fd_sc_hd__decap_3
XANTENNA__08366__A0 bus1_0\[6\] vssd1 vssd1 vccd1 vccd1 sky130_fd_sc_hd__diode_2
X_11189_ cell3.LEI0.config_data\[28\] _06137_ _06140_ vssd1 vssd1 vccd1 vccd1 _06141_
+ sky130_fd_sc_hd__o21a_1
X_10209_ _05208_ _05209_ cell2.CB_0.config_dataA\[12\] vssd1 vssd1 vccd1 vccd1 _05210_
+ sky130_fd_sc_hd__mux2_1
XFILLER_79_252 vssd1 vssd1 vccd1 vccd1 sky130_fd_sc_hd__fill_2
XFILLER_94_222 vssd1 vssd1 vccd1 vccd1 sky130_fd_sc_hd__fill_2
XFILLER_67_447 vssd1 vssd1 vccd1 vccd1 sky130_fd_sc_hd__fill_1
XFILLER_39_149 vssd1 vssd1 vccd1 vccd1 sky130_fd_sc_hd__fill_1
XANTENNA__09650__A _02444_ vssd1 vssd1 vccd1 vccd1 sky130_fd_sc_hd__diode_2
XANTENNA__08133__A3 bus1_0\[11\] vssd1 vssd1 vccd1 vccd1 sky130_fd_sc_hd__diode_2
XFILLER_62_152 vssd1 vssd1 vccd1 vccd1 sky130_fd_sc_hd__fill_1
XTAP_TAPCELL_ROW_18_575 vssd1 vccd1 sky130_fd_sc_hd__tapvpwrvgnd_1
X_07420_ net361 _02326_ vssd1 vssd1 vccd1 vccd1 _02474_ sky130_fd_sc_hd__or2_1
XTAP_TAPCELL_ROW_102_1835 vssd1 vccd1 sky130_fd_sc_hd__tapvpwrvgnd_1
XPHY_EDGE_ROW_53_Right_53 vssd1 vssd1 vccd1 vccd1 sky130_fd_sc_hd__decap_3
X_07351_ net340 net355 _02326_ _02324_ _02109_ vssd1 vssd1 vccd1 vccd1 _02407_ sky130_fd_sc_hd__o32a_1
XFILLER_31_561 vssd1 vssd1 vccd1 vccd1 sky130_fd_sc_hd__fill_1
XANTENNA__09649__X bus3_1\[12\] vssd1 vssd1 vccd1 vccd1 sky130_fd_sc_hd__diode_2
XANTENNA__08841__A1 bus3_1\[7\] vssd1 vssd1 vccd1 vccd1 sky130_fd_sc_hd__diode_2
X_07282_ cell0.CB_0.config_dataB\[22\] cell0.CB_0.config_dataB\[23\] vssd1 vssd1 vccd1
+ vccd1 _02340_ sky130_fd_sc_hd__nand2_2
XTAP_TAPCELL_ROW_135_2334 vssd1 vccd1 sky130_fd_sc_hd__tapvpwrvgnd_1
XFILLER_129_460 vssd1 vssd1 vccd1 vccd1 sky130_fd_sc_hd__fill_1
X_09021_ cell1.CB_0.config_dataB\[8\] _04050_ _04049_ _04047_ vssd1 vssd1 vccd1 vccd1
+ _04051_ sky130_fd_sc_hd__o211a_2
Xhold201 _01102_ vssd1 vssd1 vccd1 vccd1 net1160 sky130_fd_sc_hd__dlygate4sd3_1
XANTENNA__09097__A _04120_ vssd1 vssd1 vccd1 vccd1 sky130_fd_sc_hd__diode_2
XANTENNA__11420__A _02346_ vssd1 vssd1 vccd1 vccd1 sky130_fd_sc_hd__diode_2
Xhold212 cell2.LE_1B.config_data\[10\] vssd1 vssd1 vccd1 vccd1 net1171 sky130_fd_sc_hd__dlygate4sd3_1
Xhold223 _01100_ vssd1 vssd1 vccd1 vccd1 net1182 sky130_fd_sc_hd__dlygate4sd3_1
Xhold234 _01423_ vssd1 vssd1 vccd1 vccd1 net1193 sky130_fd_sc_hd__dlygate4sd3_1
XANTENNA__07947__A3 bus2_0\[3\] vssd1 vssd1 vccd1 vccd1 sky130_fd_sc_hd__diode_2
Xhold256 cell3.LE_0B.config_data\[7\] vssd1 vssd1 vccd1 vccd1 net1215 sky130_fd_sc_hd__dlygate4sd3_1
XPHY_EDGE_ROW_62_Right_62 vssd1 vssd1 vccd1 vccd1 sky130_fd_sc_hd__decap_3
Xhold245 cell0.LE_1B.config_data\[1\] vssd1 vssd1 vccd1 vccd1 net1204 sky130_fd_sc_hd__dlygate4sd3_1
Xhold267 cell0.LEI0.config_data\[23\] vssd1 vssd1 vccd1 vccd1 net1226 sky130_fd_sc_hd__dlygate4sd3_1
Xhold278 cell1.LEI0.config_data\[34\] vssd1 vssd1 vccd1 vccd1 net1237 sky130_fd_sc_hd__dlygate4sd3_1
Xfanout714 net715 vssd1 vssd1 vccd1 vccd1 net714 sky130_fd_sc_hd__clkbuf_4
Xfanout703 net724 vssd1 vssd1 vccd1 vccd1 net703 sky130_fd_sc_hd__buf_2
X_09923_ net409 _04298_ _04926_ net408 vssd1 vssd1 vccd1 vccd1 _04927_ sky130_fd_sc_hd__o211a_1
Xhold289 _00125_ vssd1 vssd1 vccd1 vccd1 net1248 sky130_fd_sc_hd__dlygate4sd3_1
Xfanout747 net748 vssd1 vssd1 vccd1 vccd1 net747 sky130_fd_sc_hd__buf_4
Xfanout736 net742 vssd1 vssd1 vccd1 vccd1 net736 sky130_fd_sc_hd__clkbuf_4
XTAP_TAPCELL_ROW_113_1997 vssd1 vccd1 sky130_fd_sc_hd__tapvpwrvgnd_1
X_09854_ _04858_ _04859_ cell2.CB_1.config_dataA\[12\] vssd1 vssd1 vccd1 vccd1 _04860_
+ sky130_fd_sc_hd__or3b_1
Xfanout725 net727 vssd1 vssd1 vccd1 vccd1 net725 sky130_fd_sc_hd__clkbuf_4
XFILLER_86_701 vssd1 vssd1 vccd1 vccd1 sky130_fd_sc_hd__fill_4
Xfanout758 net807 vssd1 vssd1 vccd1 vccd1 net758 sky130_fd_sc_hd__buf_2
XFILLER_85_244 vssd1 vssd1 vccd1 vccd1 sky130_fd_sc_hd__fill_2
X_08805_ cell1.CB_0.config_dataA\[7\] _03836_ _03834_ cell1.CB_0.config_dataA\[8\]
+ vssd1 vssd1 vccd1 vccd1 _03837_ sky130_fd_sc_hd__o211a_1
Xfanout769 net780 vssd1 vssd1 vccd1 vccd1 net769 sky130_fd_sc_hd__clkbuf_4
X_09785_ cell2.CB_1.config_dataA\[9\] _04757_ _04773_ _04785_ _04790_ vssd1 vssd1
+ vccd1 vccd1 _04791_ sky130_fd_sc_hd__a311o_2
XANTENNA_fanout564_A net575 vssd1 vssd1 vccd1 vccd1 sky130_fd_sc_hd__diode_2
X_06997_ cell1.CB_0.config_dataB\[22\] cell1.CB_0.config_dataB\[23\] vssd1 vssd1 vccd1
+ vccd1 _02063_ sky130_fd_sc_hd__nand2b_2
XANTENNA__07064__B _02032_ vssd1 vssd1 vccd1 vccd1 sky130_fd_sc_hd__diode_2
X_08736_ net452 _03468_ vssd1 vssd1 vccd1 vccd1 _03770_ sky130_fd_sc_hd__nand2_1
XANTENNA_clkbuf_leaf_72_clk_A clknet_4_14_0_clk vssd1 vssd1 vccd1 vccd1 sky130_fd_sc_hd__diode_2
XANTENNA_fanout352_X net352 vssd1 vssd1 vccd1 vccd1 sky130_fd_sc_hd__diode_2
X_08667_ cell1.LEI0.config_data\[22\] _03697_ _03700_ vssd1 vssd1 vccd1 vccd1 _03701_
+ sky130_fd_sc_hd__o21a_1
XFILLER_81_461 vssd1 vssd1 vccd1 vccd1 sky130_fd_sc_hd__fill_1
XPHY_EDGE_ROW_71_Right_71 vssd1 vssd1 vccd1 vccd1 sky130_fd_sc_hd__decap_3
X_07618_ cell0.SB0.route_sel\[12\] cell0.SB0.route_sel\[13\] net108 _02665_ _02664_
+ vssd1 vssd1 vccd1 vccd1 _02667_ sky130_fd_sc_hd__a41o_1
XFILLER_26_377 vssd1 vssd1 vccd1 vccd1 sky130_fd_sc_hd__fill_1
XTAP_TAPCELL_ROW_37_862 vssd1 vccd1 sky130_fd_sc_hd__tapvpwrvgnd_1
XFILLER_81_494 vssd1 vssd1 vccd1 vccd1 sky130_fd_sc_hd__fill_8
XANTENNA__11314__B _05540_ vssd1 vssd1 vccd1 vccd1 sky130_fd_sc_hd__diode_2
XFILLER_14_10 vccd1 vssd1 vccd1 vssd1 sky130_ef_sc_hd__decap_40_12
X_08598_ _03540_ _03623_ _03624_ _03537_ _01666_ vssd1 vssd1 vccd1 vccd1 _03634_ sky130_fd_sc_hd__a221o_1
X_07549_ net306 _02001_ _02394_ _02397_ _02003_ vssd1 vssd1 vccd1 vccd1 _02600_ sky130_fd_sc_hd__o32a_1
XANTENNA_clkbuf_leaf_87_clk_A clknet_4_11_0_clk vssd1 vssd1 vccd1 vccd1 sky130_fd_sc_hd__diode_2
XFILLER_10_701 vccd1 vssd1 vccd1 vssd1 sky130_ef_sc_hd__decap_40_12
XFILLER_22_550 vssd1 vssd1 vccd1 vccd1 sky130_fd_sc_hd__fill_1
X_10560_ cell3.SB0.route_sel\[112\] _01744_ cell3.SB0.route_sel\[117\] cell3.SB0.route_sel\[116\]
+ _05517_ vssd1 vssd1 vccd1 vccd1 _05518_ sky130_fd_sc_hd__o221a_1
XFILLER_14_65 vccd1 vssd1 vccd1 vssd1 sky130_ef_sc_hd__decap_40_12
XFILLER_14_87 vssd1 vssd1 vccd1 vccd1 sky130_fd_sc_hd__fill_1
XFILLER_139_268 vssd1 vssd1 vccd1 vccd1 sky130_fd_sc_hd__fill_1
X_09219_ cell2.SB0.route_sel\[13\] cell2.SB0.route_sel\[12\] _02672_ _04245_ _02669_
+ vssd1 vssd1 vccd1 vccd1 _04246_ sky130_fd_sc_hd__a221o_1
X_10491_ _02783_ _03540_ vssd1 vssd1 vccd1 vccd1 _05461_ sky130_fd_sc_hd__nand2b_1
XANTENNA_clkbuf_leaf_130_clk_A clknet_4_0_0_clk vssd1 vssd1 vccd1 vccd1 sky130_fd_sc_hd__diode_2
X_12230_ cell2.CB_0.config_dataB\[18\] cell2.CB_0.config_dataB\[17\] net825 vssd1
+ vssd1 vccd1 vccd1 _00663_ sky130_fd_sc_hd__mux2_1
XANTENNA_clkbuf_leaf_10_clk_A clknet_4_1_0_clk vssd1 vssd1 vccd1 vccd1 sky130_fd_sc_hd__diode_2
XFILLER_6_749 vssd1 vssd1 vccd1 vccd1 sky130_fd_sc_hd__fill_4
XFILLER_5_215 vssd1 vssd1 vccd1 vccd1 sky130_fd_sc_hd__fill_8
XPHY_EDGE_ROW_80_Right_80 vssd1 vssd1 vccd1 vccd1 sky130_fd_sc_hd__decap_3
XTAP_TAPCELL_ROW_75_1436 vssd1 vccd1 sky130_fd_sc_hd__tapvpwrvgnd_1
XANTENNA__08115__S _03087_ vssd1 vssd1 vccd1 vccd1 sky130_fd_sc_hd__diode_2
XFILLER_30_53 vssd1 vssd1 vccd1 vccd1 sky130_fd_sc_hd__fill_4
XFILLER_108_699 vssd1 vssd1 vccd1 vccd1 sky130_fd_sc_hd__fill_1
X_12161_ net1444 cell1.LEI0.config_data\[42\] net894 vssd1 vssd1 vccd1 vccd1 _00594_
+ sky130_fd_sc_hd__mux2_1
X_11112_ net47 net48 net389 vssd1 vssd1 vccd1 vccd1 _06064_ sky130_fd_sc_hd__mux2_1
X_12092_ net1452 _01820_ _06378_ vssd1 vssd1 vccd1 vccd1 _00527_ sky130_fd_sc_hd__a21o_1
X_11043_ net373 cell3.CB_0.config_dataA\[16\] vssd1 vssd1 vccd1 vccd1 _05997_ sky130_fd_sc_hd__nor2_1
XANTENNA_clkbuf_leaf_25_clk_A clknet_4_5_0_clk vssd1 vssd1 vccd1 vccd1 sky130_fd_sc_hd__diode_2
XFILLER_89_561 vssd1 vssd1 vccd1 vccd1 sky130_fd_sc_hd__fill_1
XFILLER_77_723 vssd1 vssd1 vccd1 vccd1 sky130_fd_sc_hd__fill_1
XFILLER_39_51 vssd1 vssd1 vccd1 vccd1 sky130_fd_sc_hd__fill_4
XFILLER_49_447 vssd1 vssd1 vccd1 vccd1 sky130_fd_sc_hd__fill_1
XFILLER_1_487 vssd1 vssd1 vccd1 vccd1 sky130_fd_sc_hd__fill_1
XANTENNA__08363__A3 bus1_0\[3\] vssd1 vssd1 vccd1 vccd1 sky130_fd_sc_hd__diode_2
XFILLER_64_417 vssd1 vssd1 vccd1 vccd1 sky130_fd_sc_hd__fill_1
Xclkbuf_4_3_0_clk clknet_0_clk vssd1 vssd1 vccd1 vccd1 clknet_4_3_0_clk sky130_fd_sc_hd__clkbuf_8
XFILLER_39_95 vssd1 vssd1 vccd1 vccd1 sky130_fd_sc_hd__fill_1
X_12994_ net1192 cell3.LEI0.config_data\[14\] net946 vssd1 vssd1 vccd1 vccd1 _01422_
+ sky130_fd_sc_hd__mux2_1
X_11945_ cell0.SB0.route_sel\[51\] cell0.SB0.route_sel\[50\] net759 vssd1 vssd1 vccd1
+ vccd1 _00382_ sky130_fd_sc_hd__mux2_1
XFILLER_17_333 vssd1 vssd1 vccd1 vccd1 sky130_fd_sc_hd__fill_2
XTAP_TAPCELL_ROW_86_1598 vssd1 vccd1 sky130_fd_sc_hd__tapvpwrvgnd_1
X_11876_ cell1.CB_0.config_dataA\[7\] net469 net879 vssd1 vssd1 vccd1 vccd1 _00313_
+ sky130_fd_sc_hd__mux2_1
X_13615_ clknet_leaf_91_clk _00587_ net696 vssd1 vssd1 vccd1 vccd1 cell1.LEI0.config_data\[36\]
+ sky130_fd_sc_hd__dfrtp_1
XTAP_TAPCELL_ROW_15_534 vssd1 vccd1 sky130_fd_sc_hd__tapvpwrvgnd_1
X_10827_ _05540_ _05543_ net367 vssd1 vssd1 vccd1 vccd1 _05783_ sky130_fd_sc_hd__mux2_1
X_10758_ _04354_ _04362_ _04370_ _05503_ _01778_ vssd1 vssd1 vccd1 vccd1 _05714_ sky130_fd_sc_hd__a2111o_1
X_13546_ clknet_leaf_72_clk _00518_ net728 vssd1 vssd1 vccd1 vccd1 cell1.LE_0B.config_data\[11\]
+ sky130_fd_sc_hd__dfrtp_1
XFILLER_13_583 vssd1 vssd1 vccd1 vccd1 sky130_fd_sc_hd__fill_1
X_13477_ clknet_leaf_3_clk _00449_ net571 vssd1 vssd1 vccd1 vccd1 cell0.SB0.route_sel\[118\]
+ sky130_fd_sc_hd__dfstp_1
XFILLER_9_587 vssd1 vssd1 vccd1 vccd1 sky130_fd_sc_hd__fill_1
XTAP_TAPCELL_ROW_117_2064 vssd1 vccd1 sky130_fd_sc_hd__tapvpwrvgnd_1
X_12428_ cell2.LE_1A.config_data\[11\] net980 net924 vssd1 vssd1 vccd1 vccd1 _00860_
+ sky130_fd_sc_hd__mux2_1
X_10689_ net390 _05641_ _05646_ vssd1 vssd1 vccd1 vccd1 _05647_ sky130_fd_sc_hd__a21o_1
XANTENNA__10127__Y _05128_ vssd1 vssd1 vccd1 vccd1 sky130_fd_sc_hd__diode_2
XTAP_TAPCELL_ROW_130_2253 vssd1 vccd1 sky130_fd_sc_hd__tapvpwrvgnd_1
XANTENNA__10394__A0 net36 vssd1 vssd1 vccd1 vccd1 sky130_fd_sc_hd__diode_2
XFILLER_114_614 vssd1 vssd1 vccd1 vccd1 sky130_fd_sc_hd__fill_1
XFILLER_113_113 vssd1 vssd1 vccd1 vccd1 sky130_fd_sc_hd__fill_1
XANTENNA__07929__A3 bus2_0\[15\] vssd1 vssd1 vccd1 vccd1 sky130_fd_sc_hd__diode_2
X_12359_ cell1.SB0.route_sel\[97\] cell1.SB0.route_sel\[96\] net870 vssd1 vssd1 vccd1
+ vccd1 _00792_ sky130_fd_sc_hd__mux2_1
XTAP_TAPCELL_ROW_130_2264 vssd1 vccd1 sky130_fd_sc_hd__tapvpwrvgnd_1
X_14029_ clknet_leaf_82_clk _01001_ net668 vssd1 vssd1 vccd1 vccd1 cell3.SB0.route_sel\[37\]
+ sky130_fd_sc_hd__dfstp_2
X_06920_ _01948_ net267 _01985_ _01950_ vssd1 vssd1 vccd1 vccd1 _01987_ sky130_fd_sc_hd__a31o_1
XANTENNA__10697__A1 _05475_ vssd1 vssd1 vccd1 vccd1 sky130_fd_sc_hd__diode_2
XANTENNA__07011__B1 _02029_ vssd1 vssd1 vccd1 vccd1 sky130_fd_sc_hd__diode_2
X_06851_ cell2.CB_0.config_dataB\[23\] cell2.CB_0.config_dataB\[22\] vssd1 vssd1 vccd1
+ vccd1 _01920_ sky130_fd_sc_hd__nand2b_1
XANTENNA__09651__Y _04666_ vssd1 vssd1 vccd1 vccd1 sky130_fd_sc_hd__diode_2
XFILLER_82_214 vssd1 vssd1 vccd1 vccd1 sky130_fd_sc_hd__fill_1
X_09570_ cell3.SB0.route_sel\[83\] cell3.SB0.route_sel\[82\] vssd1 vssd1 vccd1 vccd1
+ _04588_ sky130_fd_sc_hd__nand2_1
X_06782_ cell0.CB_1.config_dataB\[23\] cell0.CB_1.config_dataB\[22\] vssd1 vssd1 vccd1
+ vccd1 _01852_ sky130_fd_sc_hd__nand2b_1
X_08521_ cell1.CB_1.config_dataA\[6\] _03555_ _03556_ vssd1 vssd1 vccd1 vccd1 _03557_
+ sky130_fd_sc_hd__a21oi_1
XFILLER_36_664 vssd1 vssd1 vccd1 vccd1 sky130_fd_sc_hd__fill_1
XTAP_TAPCELL_ROW_46_1004 vssd1 vccd1 sky130_fd_sc_hd__tapvpwrvgnd_1
X_08452_ _01550_ cell1.SB0.route_sel\[120\] cell1.SB0.config_data_out _01554_ vssd1
+ vssd1 vccd1 vccd1 _03488_ sky130_fd_sc_hd__o22a_1
XANTENNA__07171__Y bus1_0\[10\] vssd1 vssd1 vccd1 vccd1 sky130_fd_sc_hd__diode_2
X_07403_ cell2.SB0.route_sel\[109\] cell2.SB0.route_sel\[108\] _02416_ vssd1 vssd1
+ vccd1 vccd1 _02458_ sky130_fd_sc_hd__a21boi_1
XTAP_TAPCELL_ROW_34_821 vssd1 vccd1 sky130_fd_sc_hd__tapvpwrvgnd_1
X_08383_ net501 net499 vssd1 vssd1 vccd1 vccd1 _03421_ sky130_fd_sc_hd__or2_1
X_07334_ _02337_ _02389_ _02390_ _02338_ vssd1 vssd1 vccd1 vccd1 _02391_ sky130_fd_sc_hd__o211ai_2
XANTENNA__10621__A1 _05553_ vssd1 vssd1 vccd1 vccd1 sky130_fd_sc_hd__diode_2
X_07265_ cell0.CB_1.config_dataA\[22\] cell0.CB_1.config_dataA\[23\] vssd1 vssd1 vccd1
+ vccd1 _02323_ sky130_fd_sc_hd__and2_1
XANTENNA__11150__A _05924_ vssd1 vssd1 vccd1 vccd1 sky130_fd_sc_hd__diode_2
XANTENNA_fanout312_A net313 vssd1 vssd1 vccd1 vccd1 sky130_fd_sc_hd__diode_2
X_09004_ net481 _04031_ _04032_ _04033_ vssd1 vssd1 vccd1 vccd1 _04034_ sky130_fd_sc_hd__a31o_1
XANTENNA__11177__A2 net42 vssd1 vssd1 vccd1 vccd1 sky130_fd_sc_hd__diode_2
X_07196_ cell1.SB0.route_sel\[89\] cell1.SB0.route_sel\[88\] vssd1 vssd1 vccd1 vccd1
+ _02256_ sky130_fd_sc_hd__and2_1
XTAP_TAPCELL_ROW_57_1166 vssd1 vccd1 sky130_fd_sc_hd__tapvpwrvgnd_1
X_09906_ _04872_ _04911_ _04870_ vssd1 vssd1 vccd1 vccd1 _04912_ sky130_fd_sc_hd__mux2_1
XANTENNA_fanout779_A net780 vssd1 vssd1 vccd1 vccd1 sky130_fd_sc_hd__diode_2
Xfanout533 net534 vssd1 vssd1 vccd1 vccd1 net533 sky130_fd_sc_hd__clkbuf_2
Xfanout522 cell0.CB_0.config_dataA\[0\] vssd1 vssd1 vccd1 vccd1 net522 sky130_fd_sc_hd__dlymetal6s2s_1
Xfanout511 cell0.CB_0.config_dataA\[16\] vssd1 vssd1 vccd1 vccd1 net511 sky130_fd_sc_hd__clkbuf_2
Xfanout500 cell0.CB_1.config_dataB\[15\] vssd1 vssd1 vccd1 vccd1 net500 sky130_fd_sc_hd__clkbuf_2
XTAP_TAPCELL_ROW_70_1355 vssd1 vccd1 sky130_fd_sc_hd__tapvpwrvgnd_1
Xfanout566 net568 vssd1 vssd1 vccd1 vccd1 net566 sky130_fd_sc_hd__clkbuf_4
Xfanout555 net602 vssd1 vssd1 vccd1 vccd1 net555 sky130_fd_sc_hd__clkbuf_4
Xfanout544 cell0.CB_1.config_dataA\[1\] vssd1 vssd1 vccd1 vccd1 net544 sky130_fd_sc_hd__clkbuf_2
XANTENNA_fanout946_A net952 vssd1 vssd1 vccd1 vccd1 sky130_fd_sc_hd__diode_2
X_09837_ _04842_ vssd1 vssd1 vccd1 vccd1 _04843_ sky130_fd_sc_hd__inv_2
XANTENNA__10688__B2 _05531_ vssd1 vssd1 vccd1 vccd1 sky130_fd_sc_hd__diode_2
Xfanout599 net600 vssd1 vssd1 vccd1 vccd1 net599 sky130_fd_sc_hd__clkbuf_2
Xfanout588 net591 vssd1 vssd1 vccd1 vccd1 net588 sky130_fd_sc_hd__clkbuf_4
Xfanout577 net581 vssd1 vssd1 vccd1 vccd1 net577 sky130_fd_sc_hd__clkbuf_4
X_09768_ bus3_2\[6\] bus3_2\[7\] net444 vssd1 vssd1 vccd1 vccd1 _04774_ sky130_fd_sc_hd__mux2_1
XFILLER_100_374 vssd1 vssd1 vccd1 vccd1 sky130_fd_sc_hd__fill_1
XFILLER_73_225 vssd1 vssd1 vccd1 vccd1 sky130_fd_sc_hd__fill_1
XFILLER_73_203 vssd1 vssd1 vccd1 vccd1 sky130_fd_sc_hd__fill_2
X_08719_ _03477_ _03737_ _03738_ _03473_ cell1.CB_1.config_dataB\[12\] vssd1 vssd1
+ vccd1 vccd1 _03753_ sky130_fd_sc_hd__a221o_1
X_09699_ net922 _04712_ vssd1 vssd1 vccd1 vccd1 _04713_ sky130_fd_sc_hd__or2_1
XANTENNA__09845__A3 bus3_2\[3\] vssd1 vssd1 vccd1 vccd1 sky130_fd_sc_hd__diode_2
X_11730_ net1084 net1048 net808 vssd1 vssd1 vccd1 vccd1 _00168_ sky130_fd_sc_hd__mux2_1
X_11661_ cell0.CB_1.config_dataB\[7\] net505 net783 vssd1 vssd1 vccd1 vccd1 _00102_
+ sky130_fd_sc_hd__mux2_1
X_14380_ clknet_leaf_70_clk _01352_ net731 vssd1 vssd1 vccd1 vccd1 cell3.LE_1A.config_data\[11\]
+ sky130_fd_sc_hd__dfrtp_1
X_10612_ _05531_ _05568_ _01784_ vssd1 vssd1 vccd1 vccd1 _05570_ sky130_fd_sc_hd__a21o_1
XFILLER_41_199 vssd1 vssd1 vccd1 vccd1 sky130_fd_sc_hd__fill_1
X_11592_ cell0.CB_1.config_dataA\[13\] cell0.CB_1.config_dataA\[12\] net856 vssd1
+ vssd1 vccd1 vccd1 _00033_ sky130_fd_sc_hd__mux2_1
X_13400_ clknet_leaf_1_clk _00372_ net553 vssd1 vssd1 vccd1 vccd1 cell0.SB0.route_sel\[41\]
+ sky130_fd_sc_hd__dfstp_1
XANTENNA__10612__A1 _05531_ vssd1 vssd1 vccd1 vccd1 sky130_fd_sc_hd__diode_2
X_10543_ _04303_ _04312_ _04320_ _05500_ vssd1 vssd1 vccd1 vccd1 _05501_ sky130_fd_sc_hd__a211o_4
X_13331_ clknet_leaf_114_clk _00303_ net673 vssd1 vssd1 vccd1 vccd1 cell1.CB_0.config_dataB\[22\]
+ sky130_fd_sc_hd__dfstp_1
XANTENNA__08634__A net458 vssd1 vssd1 vccd1 vccd1 sky130_fd_sc_hd__diode_2
XANTENNA__06425__Y _01495_ vssd1 vssd1 vccd1 vccd1 sky130_fd_sc_hd__diode_2
XFILLER_6_535 vccd1 vssd1 vccd1 vssd1 sky130_ef_sc_hd__decap_40_12
XFILLER_6_513 vssd1 vssd1 vccd1 vccd1 sky130_fd_sc_hd__fill_1
XANTENNA__08353__B _02277_ vssd1 vssd1 vccd1 vccd1 sky130_fd_sc_hd__diode_2
XANTENNA__08281__A2 bus1_0\[10\] vssd1 vssd1 vccd1 vccd1 sky130_fd_sc_hd__diode_2
X_10474_ net272 _05456_ vssd1 vssd1 vccd1 vccd1 bus3_2\[15\] sky130_fd_sc_hd__and2b_2
X_13262_ clknet_leaf_123_clk _00234_ net587 vssd1 vssd1 vccd1 vccd1 cell0.CB_0.config_data_inA
+ sky130_fd_sc_hd__dfrtp_2
XANTENNA_input75_A SBsouth_in[19] vssd1 vssd1 vccd1 vccd1 sky130_fd_sc_hd__diode_2
XANTENNA__08569__A0 net4 vssd1 vssd1 vccd1 vccd1 sky130_fd_sc_hd__diode_2
X_12213_ net434 net436 net825 vssd1 vssd1 vccd1 vccd1 _00646_ sky130_fd_sc_hd__mux2_1
XFILLER_108_474 vssd1 vssd1 vccd1 vccd1 sky130_fd_sc_hd__fill_2
X_13193_ clknet_leaf_23_clk _00165_ net603 vssd1 vssd1 vccd1 vccd1 cell0.LE_0A.config_data\[0\]
+ sky130_fd_sc_hd__dfrtp_1
XANTENNA__08033__A2 _02894_ vssd1 vssd1 vccd1 vccd1 sky130_fd_sc_hd__diode_2
X_12144_ cell1.LEI0.config_data\[26\] net1345 net893 vssd1 vssd1 vccd1 vccd1 _00577_
+ sky130_fd_sc_hd__mux2_1
XFILLER_111_617 vssd1 vssd1 vccd1 vccd1 sky130_fd_sc_hd__fill_2
XFILLER_96_339 vssd1 vssd1 vccd1 vccd1 sky130_fd_sc_hd__fill_1
XANTENNA_input30_X net30 vssd1 vssd1 vccd1 vccd1 sky130_fd_sc_hd__diode_2
XFILLER_89_380 vssd1 vssd1 vccd1 vccd1 sky130_fd_sc_hd__fill_1
X_12075_ net1050 net1156 net904 vssd1 vssd1 vccd1 vccd1 _00510_ sky130_fd_sc_hd__mux2_1
XFILLER_1_273 vssd1 vssd1 vccd1 vccd1 sky130_fd_sc_hd__fill_4
X_11026_ net40 net41 net42 net43 net375 net374 vssd1 vssd1 vccd1 vccd1 _05980_ sky130_fd_sc_hd__mux4_1
XANTENNA_output231_A net231 vssd1 vssd1 vccd1 vccd1 sky130_fd_sc_hd__diode_2
XANTENNA__08741__A0 net4 vssd1 vssd1 vccd1 vccd1 sky130_fd_sc_hd__diode_2
XTAP_TAPCELL_ROW_88_1627 vssd1 vccd1 sky130_fd_sc_hd__tapvpwrvgnd_1
XANTENNA__11628__A0 cell0.CB_0.config_dataB\[24\] vssd1 vssd1 vccd1 vccd1 sky130_fd_sc_hd__diode_2
XFILLER_17_130 vssd1 vssd1 vccd1 vccd1 sky130_fd_sc_hd__fill_1
X_12977_ cell3.LE_0B.dff1_out _06191_ net756 vssd1 vssd1 vccd1 vccd1 _01405_ sky130_fd_sc_hd__mux2_1
XFILLER_92_589 vssd1 vssd1 vccd1 vccd1 sky130_fd_sc_hd__fill_2
XANTENNA__08528__B _03489_ vssd1 vssd1 vccd1 vccd1 sky130_fd_sc_hd__diode_2
X_11928_ cell0.SB0.route_sel\[34\] cell0.SB0.route_sel\[33\] net757 vssd1 vssd1 vccd1
+ vccd1 _00365_ sky130_fd_sc_hd__mux2_1
XFILLER_33_623 vssd1 vssd1 vccd1 vccd1 sky130_fd_sc_hd__fill_1
XANTENNA__10851__A1 net17 vssd1 vssd1 vccd1 vccd1 sky130_fd_sc_hd__diode_2
XANTENNA__10851__B2 net18 vssd1 vssd1 vccd1 vccd1 sky130_fd_sc_hd__diode_2
X_11859_ net477 cell1.CB_0.config_dataB\[14\] net897 vssd1 vssd1 vccd1 vccd1 _00296_
+ sky130_fd_sc_hd__mux2_1
XANTENNA_29 net1127 vssd1 vssd1 vccd1 vccd1 sky130_fd_sc_hd__diode_2
XANTENNA__11522__X net249 vssd1 vssd1 vccd1 vccd1 sky130_fd_sc_hd__diode_2
XANTENNA_18 net131 vssd1 vssd1 vccd1 vccd1 sky130_fd_sc_hd__diode_2
X_13529_ clknet_leaf_100_clk _00501_ net682 vssd1 vssd1 vccd1 vccd1 cell1.LE_1A.config_data\[16\]
+ sky130_fd_sc_hd__dfrtp_2
XANTENNA__10138__X _05139_ vssd1 vssd1 vccd1 vccd1 sky130_fd_sc_hd__diode_2
XFILLER_70_3 vssd1 vssd1 vccd1 vccd1 sky130_fd_sc_hd__fill_1
X_07050_ net357 net355 bus1_0\[9\] vssd1 vssd1 vccd1 vccd1 _02114_ sky130_fd_sc_hd__o21ai_1
XANTENNA__11159__A2 net51 vssd1 vssd1 vccd1 vccd1 sky130_fd_sc_hd__diode_2
XTAP_TAPCELL_ROW_99_1789 vssd1 vccd1 sky130_fd_sc_hd__tapvpwrvgnd_1
XFILLER_127_783 vssd1 vssd1 vccd1 vccd1 sky130_fd_sc_hd__fill_1
Xoutput158 net158 vssd1 vssd1 vccd1 vccd1 CBeast_out[31] sky130_fd_sc_hd__buf_2
Xoutput147 net147 vssd1 vssd1 vccd1 vccd1 CBeast_out[21] sky130_fd_sc_hd__buf_2
XANTENNA__07232__A0 bus3_1\[11\] vssd1 vssd1 vccd1 vccd1 sky130_fd_sc_hd__diode_2
Xoutput136 net136 vssd1 vssd1 vccd1 vccd1 CBeast_out[11] sky130_fd_sc_hd__buf_2
Xoutput169 net169 vssd1 vssd1 vccd1 vccd1 CBnorth_out[12] sky130_fd_sc_hd__buf_2
XTAP_TAPCELL_ROW_110_1956 vssd1 vccd1 sky130_fd_sc_hd__tapvpwrvgnd_1
X_07952_ net512 _02301_ vssd1 vssd1 vccd1 vccd1 _02996_ sky130_fd_sc_hd__nand2_1
XANTENNA__10033__B _04608_ vssd1 vssd1 vccd1 vccd1 sky130_fd_sc_hd__diode_2
XTAP_TAPCELL_ROW_52_1085 vssd1 vccd1 sky130_fd_sc_hd__tapvpwrvgnd_1
X_07883_ cell0.CB_0.config_dataA\[3\] cell0.CB_0.config_dataA\[2\] vssd1 vssd1 vccd1
+ vccd1 _02927_ sky130_fd_sc_hd__or2_1
X_06903_ _01885_ _01970_ vssd1 vssd1 vccd1 vccd1 _01971_ sky130_fd_sc_hd__or2_2
X_09622_ _01737_ _01738_ vssd1 vssd1 vccd1 vccd1 _04638_ sky130_fd_sc_hd__nor2_1
X_06834_ cell2.CB_1.config_dataB\[24\] cell2.CB_1.config_dataB\[20\] cell2.CB_1.config_dataB\[21\]
+ vssd1 vssd1 vccd1 vccd1 _01903_ sky130_fd_sc_hd__nor3b_2
X_09553_ net50 net277 _04570_ vssd1 vssd1 vccd1 vccd1 _04572_ sky130_fd_sc_hd__mux2_1
XFILLER_102_25 vssd1 vssd1 vccd1 vccd1 sky130_fd_sc_hd__fill_2
X_06765_ bus2_0\[8\] vssd1 vssd1 vccd1 vccd1 _01835_ sky130_fd_sc_hd__inv_2
X_08504_ _02820_ _03539_ vssd1 vssd1 vccd1 vccd1 _03540_ sky130_fd_sc_hd__or2_4
X_06696_ cell2.CB_0.config_dataA\[2\] vssd1 vssd1 vccd1 vccd1 _01766_ sky130_fd_sc_hd__inv_2
X_09484_ cell3.SB0.route_sel\[59\] cell3.SB0.route_sel\[58\] vssd1 vssd1 vccd1 vccd1
+ _04505_ sky130_fd_sc_hd__nand2_1
XFILLER_36_483 vssd1 vssd1 vccd1 vccd1 sky130_fd_sc_hd__fill_8
X_08435_ cell1.SB0.route_sel\[77\] cell1.SB0.route_sel\[76\] vssd1 vssd1 vccd1 vccd1
+ _03471_ sky130_fd_sc_hd__nor2_1
XANTENNA__11432__X net235 vssd1 vssd1 vccd1 vccd1 sky130_fd_sc_hd__diode_2
X_08366_ bus1_0\[6\] bus1_0\[7\] net504 vssd1 vssd1 vccd1 vccd1 _03404_ sky130_fd_sc_hd__mux2_1
XFILLER_137_503 vssd1 vssd1 vccd1 vccd1 sky130_fd_sc_hd__fill_1
X_07317_ cell1.SB0.route_sel\[98\] _01541_ cell1.SB0.route_sel\[101\] _01542_ _02374_
+ vssd1 vssd1 vccd1 vccd1 _02375_ sky130_fd_sc_hd__a221o_1
XANTENNA_fanout315_X net315 vssd1 vssd1 vccd1 vccd1 sky130_fd_sc_hd__diode_2
X_08297_ net505 _03333_ _03334_ vssd1 vssd1 vccd1 vccd1 _03335_ sky130_fd_sc_hd__a21oi_1
X_07248_ cell2.SB0.route_sel\[91\] cell2.SB0.route_sel\[90\] vssd1 vssd1 vccd1 vccd1
+ _02307_ sky130_fd_sc_hd__nand2_1
XANTENNA__10358__A0 net61 vssd1 vssd1 vccd1 vccd1 sky130_fd_sc_hd__diode_2
XANTENNA_fanout896_A net897 vssd1 vssd1 vccd1 vccd1 sky130_fd_sc_hd__diode_2
X_07179_ _02238_ _02239_ cell2.SB0.route_sel\[83\] cell2.SB0.route_sel\[82\] vssd1
+ vssd1 vccd1 vccd1 _02240_ sky130_fd_sc_hd__o211a_1
XANTENNA__09212__A1 net330 vssd1 vssd1 vccd1 vccd1 sky130_fd_sc_hd__diode_2
XFILLER_3_505 vssd1 vssd1 vccd1 vccd1 sky130_fd_sc_hd__fill_4
XFILLER_11_55 vssd1 vssd1 vccd1 vccd1 sky130_fd_sc_hd__fill_1
XFILLER_127_55 vssd1 vssd1 vccd1 vccd1 sky130_fd_sc_hd__fill_1
X_10190_ net63 net64 net34 net35 net422 cell2.CB_0.config_dataA\[1\] vssd1 vssd1 vccd1
+ vccd1 _05191_ sky130_fd_sc_hd__mux4_1
XFILLER_87_15 vccd1 vssd1 vccd1 vssd1 sky130_ef_sc_hd__decap_40_12
XANTENNA__10373__A3 net39 vssd1 vssd1 vccd1 vccd1 sky130_fd_sc_hd__diode_2
XANTENNA_fanout684_X net684 vssd1 vssd1 vccd1 vccd1 sky130_fd_sc_hd__diode_2
Xfanout330 cell1.CB_0.le_outA vssd1 vssd1 vccd1 vccd1 net330 sky130_fd_sc_hd__buf_2
Xfanout374 cell3.CB_0.config_dataA\[11\] vssd1 vssd1 vccd1 vccd1 net374 sky130_fd_sc_hd__clkbuf_2
XFILLER_101_650 vssd1 vssd1 vccd1 vccd1 sky130_fd_sc_hd__fill_1
Xfanout363 cell3.CB_1.config_dataB\[22\] vssd1 vssd1 vccd1 vccd1 net363 sky130_fd_sc_hd__clkbuf_2
Xfanout352 _03025_ vssd1 vssd1 vccd1 vccd1 net352 sky130_fd_sc_hd__buf_2
Xfanout385 cell3.CB_0.config_dataB\[10\] vssd1 vssd1 vccd1 vccd1 net385 sky130_fd_sc_hd__buf_2
X_13880_ clknet_leaf_40_clk net985 net715 vssd1 vssd1 vccd1 vccd1 cell2.LE_1A.config_data\[3\]
+ sky130_fd_sc_hd__dfrtp_1
Xfanout396 net397 vssd1 vssd1 vccd1 vccd1 net396 sky130_fd_sc_hd__clkbuf_2
X_12900_ cell3.CB_1.config_dataB\[14\] cell3.CB_1.config_dataB\[13\] net941 vssd1
+ vssd1 vccd1 vccd1 _01329_ sky130_fd_sc_hd__mux2_1
XTAP_TAPCELL_ROW_6_398 vssd1 vccd1 sky130_fd_sc_hd__tapvpwrvgnd_1
X_12831_ cell2.SB0.route_sel\[73\] cell2.SB0.route_sel\[72\] net777 vssd1 vssd1 vccd1
+ vccd1 _01260_ sky130_fd_sc_hd__mux2_1
XFILLER_36_41 vccd1 vssd1 vccd1 vssd1 sky130_ef_sc_hd__decap_40_12
XTAP_TAPCELL_ROW_83_1546 vssd1 vccd1 sky130_fd_sc_hd__tapvpwrvgnd_1
X_12762_ cell2.SB0.route_sel\[4\] cell2.SB0.route_sel\[3\] net795 vssd1 vssd1 vccd1
+ vccd1 _01191_ sky130_fd_sc_hd__mux2_1
X_12693_ net393 cell3.CB_1.config_dataA\[9\] net943 vssd1 vssd1 vccd1 vccd1 _01122_
+ sky130_fd_sc_hd__mux2_1
XTAP_TAPCELL_ROW_83_1557 vssd1 vccd1 sky130_fd_sc_hd__tapvpwrvgnd_1
X_11713_ net1369 net1285 net803 vssd1 vssd1 vccd1 vccd1 _00152_ sky130_fd_sc_hd__mux2_1
X_14432_ clknet_leaf_63_clk _01404_ net748 vssd1 vssd1 vccd1 vccd1 cell3.LE_0A.reset_mode
+ sky130_fd_sc_hd__dfrtp_1
XANTENNA__11342__X net181 vssd1 vssd1 vccd1 vccd1 sky130_fd_sc_hd__diode_2
X_11644_ cell0.CB_0.config_dataA\[15\] cell0.CB_0.config_dataA\[14\] net771 vssd1
+ vssd1 vccd1 vccd1 _00085_ sky130_fd_sc_hd__mux2_1
XTAP_TAPCELL_ROW_25_684 vssd1 vccd1 sky130_fd_sc_hd__tapvpwrvgnd_1
Xinput16 CBeast_in[23] vssd1 vssd1 vccd1 vccd1 net16 sky130_fd_sc_hd__clkbuf_4
Xinput27 CBeast_in[4] vssd1 vssd1 vccd1 vccd1 net27 sky130_fd_sc_hd__clkbuf_4
X_14363_ clknet_leaf_72_clk _01335_ net729 vssd1 vssd1 vccd1 vccd1 cell3.CB_1.config_dataB\[20\]
+ sky130_fd_sc_hd__dfstp_1
X_11575_ cell0.LE_1B.config_data\[16\] net1318 net800 vssd1 vssd1 vccd1 vccd1 _00016_
+ sky130_fd_sc_hd__mux2_1
Xinput49 CBnorth_in[24] vssd1 vssd1 vccd1 vccd1 net49 sky130_fd_sc_hd__buf_2
Xinput38 CBnorth_in[14] vssd1 vssd1 vccd1 vccd1 net38 sky130_fd_sc_hd__buf_2
XANTENNA_output181_A net181 vssd1 vssd1 vccd1 vccd1 sky130_fd_sc_hd__diode_2
XTAP_TAPCELL_ROW_114_2023 vssd1 vccd1 sky130_fd_sc_hd__tapvpwrvgnd_1
XTAP_TAPCELL_ROW_114_2012 vssd1 vccd1 sky130_fd_sc_hd__tapvpwrvgnd_1
X_10526_ net275 _05482_ vssd1 vssd1 vccd1 vccd1 _05484_ sky130_fd_sc_hd__nand2_1
X_13314_ clknet_leaf_88_clk _00286_ net690 vssd1 vssd1 vccd1 vccd1 cell1.CB_0.config_dataB\[5\]
+ sky130_fd_sc_hd__dfstp_1
X_14294_ clknet_leaf_12_clk _01266_ net591 vssd1 vssd1 vccd1 vccd1 cell2.SB0.route_sel\[79\]
+ sky130_fd_sc_hd__dfstp_1
XANTENNA_input78_X net78 vssd1 vssd1 vccd1 vccd1 sky130_fd_sc_hd__diode_2
X_10457_ _01729_ cell3.SB0.route_sel\[82\] vssd1 vssd1 vccd1 vccd1 _05445_ sky130_fd_sc_hd__nand2_1
X_13245_ clknet_leaf_122_clk _00217_ net586 vssd1 vssd1 vccd1 vccd1 cell0.LEI0.config_data\[30\]
+ sky130_fd_sc_hd__dfrtp_1
X_10388_ net319 _05113_ _05386_ _01761_ vssd1 vssd1 vccd1 vccd1 _05387_ sky130_fd_sc_hd__a31o_1
X_13176_ clknet_leaf_118_clk net1241 net599 vssd1 vssd1 vccd1 vccd1 cell0.LE_0B.config_data\[5\]
+ sky130_fd_sc_hd__dfrtp_1
X_12127_ net1501 net1360 net899 vssd1 vssd1 vccd1 vccd1 _00560_ sky130_fd_sc_hd__mux2_1
XFILLER_111_458 vssd1 vssd1 vccd1 vccd1 sky130_fd_sc_hd__fill_2
X_12058_ net1008 cell1.LE_1A.config_data\[8\] net888 vssd1 vssd1 vccd1 vccd1 _00494_
+ sky130_fd_sc_hd__mux2_1
X_11009_ net375 net374 vssd1 vssd1 vccd1 vccd1 _05963_ sky130_fd_sc_hd__nor2_1
XANTENNA__10521__A0 _05475_ vssd1 vssd1 vccd1 vccd1 sky130_fd_sc_hd__diode_2
XANTENNA__07517__A1 net322 vssd1 vssd1 vccd1 vccd1 sky130_fd_sc_hd__diode_2
XTAP_TAPCELL_ROW_125_2185 vssd1 vccd1 sky130_fd_sc_hd__tapvpwrvgnd_1
XFILLER_80_504 vssd1 vssd1 vccd1 vccd1 sky130_fd_sc_hd__fill_1
XFILLER_92_386 vssd1 vssd1 vccd1 vccd1 sky130_fd_sc_hd__fill_1
X_06550_ cell2.SB0.route_sel\[67\] vssd1 vssd1 vccd1 vccd1 _01620_ sky130_fd_sc_hd__inv_2
XFILLER_80_548 vssd1 vssd1 vccd1 vccd1 sky130_fd_sc_hd__fill_1
XANTENNA__08826__X _03858_ vssd1 vssd1 vccd1 vccd1 sky130_fd_sc_hd__diode_2
XANTENNA__10824__A1 net18 vssd1 vssd1 vccd1 vccd1 sky130_fd_sc_hd__diode_2
X_06481_ cell1.SB0.route_sel\[122\] vssd1 vssd1 vccd1 vccd1 _01551_ sky130_fd_sc_hd__inv_2
XANTENNA__11252__X net166 vssd1 vssd1 vccd1 vccd1 sky130_fd_sc_hd__diode_2
XTAP_TAPCELL_ROW_44_971 vssd1 vccd1 sky130_fd_sc_hd__tapvpwrvgnd_1
XFILLER_20_103 vssd1 vssd1 vccd1 vccd1 sky130_fd_sc_hd__fill_1
X_08220_ _03249_ _03259_ cell0.CB_1.config_dataA\[14\] _03244_ vssd1 vssd1 vccd1 vccd1
+ _03260_ sky130_fd_sc_hd__a211oi_1
X_08151_ net546 _02719_ _03190_ net545 vssd1 vssd1 vccd1 vccd1 _03191_ sky130_fd_sc_hd__o211a_1
XANTENNA__07048__A3 net355 vssd1 vssd1 vccd1 vccd1 sky130_fd_sc_hd__diode_2
X_07102_ _02084_ _02164_ vssd1 vssd1 vccd1 vccd1 _02165_ sky130_fd_sc_hd__or2_1
X_08082_ net525 _01913_ _03123_ net523 vssd1 vssd1 vccd1 vccd1 _03124_ sky130_fd_sc_hd__o211a_1
X_07033_ _02094_ _02096_ net63 vssd1 vssd1 vccd1 vccd1 _02098_ sky130_fd_sc_hd__a21oi_1
XANTENNA__11001__A1 _05916_ vssd1 vssd1 vccd1 vccd1 sky130_fd_sc_hd__diode_2
XFILLER_130_701 vssd1 vssd1 vccd1 vccd1 sky130_fd_sc_hd__fill_1
XTAP_TAPCELL_ROW_54_1125 vssd1 vccd1 sky130_fd_sc_hd__tapvpwrvgnd_1
XTAP_TAPCELL_ROW_54_1114 vssd1 vccd1 sky130_fd_sc_hd__tapvpwrvgnd_1
XFILLER_114_274 vssd1 vssd1 vccd1 vccd1 sky130_fd_sc_hd__fill_1
X_08984_ _04015_ _04014_ _03902_ vssd1 vssd1 vccd1 vccd1 _04016_ sky130_fd_sc_hd__mux2_1
XFILLER_102_469 vssd1 vssd1 vccd1 vccd1 sky130_fd_sc_hd__fill_1
X_07935_ cell0.LE_0A.config_data\[7\] cell0.LE_0A.config_data\[6\] _02947_ vssd1 vssd1
+ vccd1 vccd1 _02979_ sky130_fd_sc_hd__mux2_1
XANTENNA__09902__C1 _04907_ vssd1 vssd1 vccd1 vccd1 sky130_fd_sc_hd__diode_2
XANTENNA__07624__Y _02673_ vssd1 vssd1 vccd1 vccd1 sky130_fd_sc_hd__diode_2
XANTENNA__08705__A0 net1 vssd1 vssd1 vccd1 vccd1 sky130_fd_sc_hd__diode_2
X_09605_ net294 _04621_ _04619_ vssd1 vssd1 vccd1 vccd1 _04622_ sky130_fd_sc_hd__mux2_1
X_07866_ bus2_0\[4\] _02869_ _02870_ bus2_0\[5\] cell0.CB_0.config_dataA\[8\] vssd1
+ vssd1 vccd1 vccd1 _02910_ sky130_fd_sc_hd__a221o_1
XTAP_TAPCELL_ROW_3_357 vssd1 vccd1 sky130_fd_sc_hd__tapvpwrvgnd_1
XTAP_TAPCELL_ROW_3_346 vssd1 vccd1 sky130_fd_sc_hd__tapvpwrvgnd_1
XANTENNA__08181__A1 bus1_0\[13\] vssd1 vssd1 vccd1 vccd1 sky130_fd_sc_hd__diode_2
XANTENNA_fanout644_A net649 vssd1 vssd1 vccd1 vccd1 sky130_fd_sc_hd__diode_2
XFILLER_113_57 vssd1 vssd1 vccd1 vccd1 sky130_fd_sc_hd__fill_1
X_06817_ cell1.CB_0.config_dataB\[24\] cell1.CB_0.config_dataB\[20\] cell1.CB_0.config_dataB\[21\]
+ vssd1 vssd1 vccd1 vccd1 _01887_ sky130_fd_sc_hd__nor3b_1
X_07797_ cell0.SB0.route_sel\[41\] cell0.SB0.route_sel\[40\] _02832_ _02841_ net757
+ vssd1 vssd1 vccd1 vccd1 _02842_ sky130_fd_sc_hd__a311o_4
X_09536_ net264 _04554_ vssd1 vssd1 vccd1 vccd1 _04555_ sky130_fd_sc_hd__nand2_4
XFILLER_71_548 vssd1 vssd1 vccd1 vccd1 sky130_fd_sc_hd__fill_1
X_06748_ cell0.SB0.route_sel\[24\] vssd1 vssd1 vccd1 vccd1 _01818_ sky130_fd_sc_hd__inv_2
X_09467_ cell3.SB0.route_sel\[48\] cell3.SB0.route_sel\[49\] net281 _04487_ vssd1
+ vssd1 vccd1 vccd1 _04489_ sky130_fd_sc_hd__a22o_1
X_06679_ cell3.SB0.route_sel\[124\] vssd1 vssd1 vccd1 vccd1 _01749_ sky130_fd_sc_hd__inv_2
XANTENNA_fanout811_A net828 vssd1 vssd1 vccd1 vccd1 sky130_fd_sc_hd__diode_2
XTAP_TAPCELL_ROW_65_1287 vssd1 vccd1 sky130_fd_sc_hd__tapvpwrvgnd_1
XTAP_TAPCELL_ROW_65_1276 vssd1 vccd1 sky130_fd_sc_hd__tapvpwrvgnd_1
X_08418_ _03455_ _03454_ _03347_ vssd1 vssd1 vccd1 vccd1 _03456_ sky130_fd_sc_hd__mux2_1
X_09398_ _04419_ _04421_ vssd1 vssd1 vccd1 vccd1 bus3_1\[4\] sky130_fd_sc_hd__and2_4
XTAP_TAPCELL_ROW_22_632 vssd1 vccd1 sky130_fd_sc_hd__tapvpwrvgnd_1
XTAP_TAPCELL_ROW_22_643 vssd1 vccd1 sky130_fd_sc_hd__tapvpwrvgnd_1
XANTENNA__09433__A1 _04423_ vssd1 vssd1 vccd1 vccd1 sky130_fd_sc_hd__diode_2
X_08349_ net503 net502 _02350_ _03383_ cell0.CB_1.config_dataB\[12\] vssd1 vssd1 vccd1
+ vccd1 _03387_ sky130_fd_sc_hd__o311a_1
XFILLER_11_169 vssd1 vssd1 vccd1 vccd1 sky130_fd_sc_hd__fill_1
XANTENNA__08236__A2 _02211_ vssd1 vssd1 vccd1 vccd1 sky130_fd_sc_hd__diode_2
XFILLER_138_21 vssd1 vssd1 vccd1 vccd1 sky130_fd_sc_hd__fill_4
XPHY_EDGE_ROW_129_Right_129 vssd1 vssd1 vccd1 vccd1 sky130_fd_sc_hd__decap_3
X_11360_ net747 cell3.LE_1B.reset_mode vssd1 vssd1 vccd1 vccd1 _11360_/X sky130_fd_sc_hd__xor2_2
XFILLER_22_76 vssd1 vssd1 vccd1 vccd1 sky130_fd_sc_hd__fill_8
XANTENNA__07444__B1 net349 vssd1 vssd1 vccd1 vccd1 sky130_fd_sc_hd__diode_2
XFILLER_138_65 vccd1 vssd1 vccd1 vssd1 sky130_ef_sc_hd__decap_40_12
X_10311_ net435 _05131_ net433 vssd1 vssd1 vccd1 vccd1 _05310_ sky130_fd_sc_hd__o21ai_1
XFILLER_98_25 vssd1 vssd1 vccd1 vccd1 sky130_fd_sc_hd__fill_2
XANTENNA__07995__A1 bus2_0\[9\] vssd1 vssd1 vccd1 vccd1 sky130_fd_sc_hd__diode_2
X_11291_ clknet_leaf_43_clk cell2.LE_0A.edge_mode vssd1 vssd1 vccd1 vccd1 cell2.LE_0A.sel_clk
+ sky130_fd_sc_hd__xnor2_2
X_13030_ clknet_leaf_119_clk _00002_ net595 vssd1 vssd1 vccd1 vccd1 cell0.LE_1B.config_data\[2\]
+ sky130_fd_sc_hd__dfrtp_1
XANTENNA__08190__Y _03230_ vssd1 vssd1 vccd1 vccd1 sky130_fd_sc_hd__diode_2
XFILLER_3_335 vssd1 vssd1 vccd1 vccd1 sky130_fd_sc_hd__fill_1
X_10242_ cell2.CB_0.config_dataA\[18\] cell2.CB_0.config_dataA\[17\] vssd1 vssd1 vccd1
+ vccd1 _05243_ sky130_fd_sc_hd__nor2_1
XFILLER_0_3 vccd1 vssd1 vccd1 vssd1 sky130_ef_sc_hd__decap_40_12
X_10173_ net420 _05171_ _05172_ _05173_ vssd1 vssd1 vccd1 vccd1 _05174_ sky130_fd_sc_hd__a31o_1
XANTENNA_input38_A CBnorth_in[14] vssd1 vssd1 vccd1 vccd1 sky130_fd_sc_hd__diode_2
X_13932_ clknet_leaf_25_clk _00904_ net609 vssd1 vssd1 vccd1 vccd1 cell2.LE_0A.config_data\[11\]
+ sky130_fd_sc_hd__dfrtp_1
XFILLER_101_491 vssd1 vssd1 vccd1 vccd1 sky130_fd_sc_hd__fill_1
XANTENNA_input132_X net132 vssd1 vssd1 vccd1 vccd1 sky130_fd_sc_hd__diode_2
XFILLER_19_225 vssd1 vssd1 vccd1 vccd1 sky130_fd_sc_hd__fill_1
XANTENNA__10503__B1 _03465_ vssd1 vssd1 vccd1 vccd1 sky130_fd_sc_hd__diode_2
XANTENNA__10401__B _05144_ vssd1 vssd1 vccd1 vccd1 sky130_fd_sc_hd__diode_2
X_13863_ clknet_leaf_43_clk _00835_ net628 vssd1 vssd1 vccd1 vccd1 cell2.CB_1.config_dataB\[12\]
+ sky130_fd_sc_hd__dfstp_2
XANTENNA__11059__A1 net41 vssd1 vssd1 vccd1 vccd1 sky130_fd_sc_hd__diode_2
X_12814_ cell2.SB0.route_sel\[56\] cell2.SB0.route_sel\[55\] net810 vssd1 vssd1 vccd1
+ vccd1 _01243_ sky130_fd_sc_hd__mux2_1
X_13794_ clknet_leaf_105_clk _00766_ net662 vssd1 vssd1 vccd1 vccd1 cell1.SB0.route_sel\[71\]
+ sky130_fd_sc_hd__dfstp_1
X_12745_ cell3.CB_0.config_dataA\[12\] net374 net927 vssd1 vssd1 vccd1 vccd1 _01174_
+ sky130_fd_sc_hd__mux2_1
XFILLER_27_291 vssd1 vssd1 vccd1 vccd1 sky130_fd_sc_hd__fill_1
X_12676_ cell3.LE_1B.config_data\[13\] net1165 net955 vssd1 vssd1 vccd1 vccd1 _01105_
+ sky130_fd_sc_hd__mux2_1
XTAP_TAPCELL_ROW_41_930 vssd1 vccd1 sky130_fd_sc_hd__tapvpwrvgnd_1
XANTENNA__07710__B _02756_ vssd1 vssd1 vccd1 vccd1 sky130_fd_sc_hd__diode_2
X_14415_ clknet_leaf_39_clk net1217 net717 vssd1 vssd1 vccd1 vccd1 cell3.LE_0A.config_data\[2\]
+ sky130_fd_sc_hd__dfrtp_1
X_11627_ cell0.CB_0.config_dataB\[23\] cell0.CB_0.config_dataB\[22\] net777 vssd1
+ vssd1 vccd1 vccd1 _00068_ sky130_fd_sc_hd__mux2_1
X_14346_ clknet_leaf_69_clk _01318_ net732 vssd1 vssd1 vccd1 vccd1 cell3.CB_1.config_dataB\[3\]
+ sky130_fd_sc_hd__dfstp_1
XANTENNA__09477__X _04498_ vssd1 vssd1 vccd1 vccd1 sky130_fd_sc_hd__diode_2
X_11558_ _06372_ net268 vssd1 vssd1 vccd1 vccd1 net255 sky130_fd_sc_hd__and2b_1
XFILLER_7_641 vccd1 vssd1 vccd1 vssd1 sky130_ef_sc_hd__decap_40_12
XFILLER_11_670 vssd1 vssd1 vccd1 vccd1 sky130_fd_sc_hd__fill_2
XANTENNA__11161__A1_N _05879_ vssd1 vssd1 vccd1 vccd1 sky130_fd_sc_hd__diode_2
XFILLER_116_506 vssd1 vssd1 vccd1 vccd1 sky130_fd_sc_hd__fill_1
XTAP_TAPCELL_ROW_96_1748 vssd1 vccd1 sky130_fd_sc_hd__tapvpwrvgnd_1
XFILLER_7_685 vccd1 vssd1 vccd1 vssd1 sky130_ef_sc_hd__decap_40_12
X_10509_ _03494_ net322 _02432_ vssd1 vssd1 vccd1 vccd1 _05470_ sky130_fd_sc_hd__mux2_1
X_11489_ _06326_ _04194_ vssd1 vssd1 vccd1 vccd1 net237 sky130_fd_sc_hd__and2b_1
X_14277_ clknet_leaf_23_clk _01249_ net604 vssd1 vssd1 vccd1 vccd1 cell2.SB0.route_sel\[62\]
+ sky130_fd_sc_hd__dfstp_1
XANTENNA__07709__Y _02756_ vssd1 vssd1 vccd1 vccd1 sky130_fd_sc_hd__diode_2
XFILLER_6_184 vccd1 vssd1 vccd1 vssd1 sky130_ef_sc_hd__decap_40_12
X_13228_ clknet_leaf_2_clk net1436 net569 vssd1 vssd1 vccd1 vccd1 cell0.LEI0.config_data\[13\]
+ sky130_fd_sc_hd__dfrtp_1
XANTENNA__10337__A3 net35 vssd1 vssd1 vccd1 vccd1 sky130_fd_sc_hd__diode_2
X_13159_ clknet_leaf_116_clk _00131_ net665 vssd1 vssd1 vccd1 vccd1 cell0.LE_1A.config_data\[10\]
+ sky130_fd_sc_hd__dfrtp_1
XFILLER_33_3 vccd1 vssd1 vccd1 vssd1 sky130_ef_sc_hd__decap_40_12
XFILLER_85_607 vssd1 vssd1 vccd1 vccd1 sky130_fd_sc_hd__fill_4
XTAP_TAPCELL_ROW_127_2214 vssd1 vccd1 sky130_fd_sc_hd__tapvpwrvgnd_1
XANTENNA__08950__A3 bus3_1\[3\] vssd1 vssd1 vccd1 vccd1 sky130_fd_sc_hd__diode_2
X_07720_ net449 net450 _01962_ vssd1 vssd1 vccd1 vccd1 _02767_ sky130_fd_sc_hd__or3b_1
XANTENNA__10151__X _05152_ vssd1 vssd1 vccd1 vccd1 sky130_fd_sc_hd__diode_2
XFILLER_84_139 vssd1 vssd1 vccd1 vccd1 sky130_fd_sc_hd__fill_1
XTAP_TAPCELL_ROW_140_2414 vssd1 vccd1 sky130_fd_sc_hd__tapvpwrvgnd_1
XTAP_TAPCELL_ROW_140_2403 vssd1 vccd1 sky130_fd_sc_hd__tapvpwrvgnd_1
Xclkbuf_1_1__f_cell0.LE_0A.sel_clk clknet_0_cell0.LE_0A.sel_clk vssd1 vssd1 vccd1
+ vccd1 clknet_1_1__leaf_cell0.LE_0A.sel_clk sky130_fd_sc_hd__clkbuf_16
XFILLER_38_589 vssd1 vssd1 vccd1 vccd1 sky130_fd_sc_hd__fill_1
XTAP_TAPCELL_ROW_0_305 vssd1 vccd1 sky130_fd_sc_hd__tapvpwrvgnd_1
X_07651_ cell1.SB0.route_sel\[8\] cell1.SB0.route_sel\[9\] _01503_ cell1.SB0.route_sel\[11\]
+ _02699_ vssd1 vssd1 vccd1 vccd1 _02700_ sky130_fd_sc_hd__o221a_1
X_06602_ cell1.LE_0B.config_data\[16\] vssd1 vssd1 vccd1 vccd1 _01672_ sky130_fd_sc_hd__inv_2
X_07582_ cell0.SB0.route_sel\[4\] cell0.SB0.route_sel\[5\] _01815_ cell0.SB0.route_sel\[0\]
+ _02631_ vssd1 vssd1 vccd1 vccd1 _02632_ sky130_fd_sc_hd__o221a_1
X_09321_ cell2.SB0.route_sel\[24\] cell2.SB0.route_sel\[25\] vssd1 vssd1 vccd1 vccd1
+ _04346_ sky130_fd_sc_hd__nand2b_1
X_06533_ cell0.SB0.route_sel\[35\] vssd1 vssd1 vccd1 vccd1 _01603_ sky130_fd_sc_hd__inv_2
XTAP_TAPCELL_ROW_105_1888 vssd1 vccd1 sky130_fd_sc_hd__tapvpwrvgnd_1
XTAP_TAPCELL_ROW_105_1877 vssd1 vccd1 sky130_fd_sc_hd__tapvpwrvgnd_1
XANTENNA__11423__A _02422_ vssd1 vssd1 vccd1 vccd1 sky130_fd_sc_hd__diode_2
XANTENNA__13555__SET_B net753 vssd1 vssd1 vccd1 vccd1 sky130_fd_sc_hd__diode_2
X_09252_ cell3.SB0.route_sel\[21\] cell3.SB0.route_sel\[20\] _02735_ _04276_ _02733_
+ vssd1 vssd1 vccd1 vccd1 _04278_ sky130_fd_sc_hd__a221o_1
X_06464_ cell1.SB0.route_sel\[83\] vssd1 vssd1 vccd1 vccd1 _01534_ sky130_fd_sc_hd__inv_2
X_09183_ net363 net362 _04210_ vssd1 vssd1 vccd1 vccd1 _04211_ sky130_fd_sc_hd__or3_1
X_06395_ cell0.SB0.route_sel\[59\] vssd1 vssd1 vccd1 vccd1 _01465_ sky130_fd_sc_hd__inv_2
X_08203_ cell0.CB_1.config_dataA\[12\] _03242_ vssd1 vssd1 vccd1 vccd1 _03243_ sky130_fd_sc_hd__nand2b_1
XTAP_TAPCELL_ROW_138_2376 vssd1 vccd1 sky130_fd_sc_hd__tapvpwrvgnd_1
X_08134_ _03173_ _03172_ cell0.CB_1.config_dataA\[2\] vssd1 vssd1 vccd1 vccd1 _03174_
+ sky130_fd_sc_hd__mux2_1
XANTENNA__10576__A3 net20 vssd1 vssd1 vccd1 vccd1 sky130_fd_sc_hd__diode_2
XFILLER_104_9 vssd1 vssd1 vccd1 vccd1 sky130_fd_sc_hd__fill_8
X_08065_ net527 _01913_ vssd1 vssd1 vccd1 vccd1 _03107_ sky130_fd_sc_hd__or2_1
X_07016_ cell2.CB_1.config_dataB\[24\] cell2.CB_1.config_dataB\[21\] cell2.CB_1.config_dataB\[20\]
+ vssd1 vssd1 vccd1 vccd1 _02081_ sky130_fd_sc_hd__nor3_1
XTAP_TAPCELL_ROW_8_427 vssd1 vccd1 sky130_fd_sc_hd__tapvpwrvgnd_1
XFILLER_108_79 vssd1 vssd1 vccd1 vccd1 sky130_fd_sc_hd__fill_1
XFILLER_88_412 vssd1 vssd1 vccd1 vccd1 sky130_fd_sc_hd__fill_1
XANTENNA_fanout594_A net601 vssd1 vssd1 vccd1 vccd1 sky130_fd_sc_hd__diode_2
XFILLER_0_316 vssd1 vssd1 vccd1 vccd1 sky130_fd_sc_hd__fill_4
XFILLER_130_531 vssd1 vssd1 vccd1 vccd1 sky130_fd_sc_hd__fill_1
X_08967_ cell1.CB_0.config_dataA\[19\] _03986_ _03998_ vssd1 vssd1 vccd1 vccd1 _03999_
+ sky130_fd_sc_hd__or3_1
XFILLER_48_309 vssd1 vssd1 vccd1 vccd1 sky130_fd_sc_hd__fill_1
XANTENNA_fanout761_A net768 vssd1 vssd1 vccd1 vccd1 sky130_fd_sc_hd__diode_2
XFILLER_84_27 vssd1 vssd1 vccd1 vccd1 sky130_fd_sc_hd__fill_1
XFILLER_68_191 vssd1 vssd1 vccd1 vccd1 sky130_fd_sc_hd__fill_2
X_07918_ net514 _02960_ _02961_ vssd1 vssd1 vccd1 vccd1 _02962_ sky130_fd_sc_hd__a21o_1
X_08898_ _03890_ _03905_ _03906_ _03894_ _01678_ vssd1 vssd1 vccd1 vccd1 _03930_ sky130_fd_sc_hd__a221o_1
XTAP_TAPCELL_ROW_67_1316 vssd1 vccd1 sky130_fd_sc_hd__tapvpwrvgnd_1
XFILLER_17_718 vssd1 vssd1 vccd1 vccd1 sky130_fd_sc_hd__fill_1
X_07849_ cell0.SB0.route_sel\[20\] _01591_ cell0.SB0.route_sel\[23\] _01593_ _02892_
+ vssd1 vssd1 vccd1 vccd1 _02893_ sky130_fd_sc_hd__a221o_1
X_10860_ net364 _05814_ _05815_ vssd1 vssd1 vccd1 vccd1 _05816_ sky130_fd_sc_hd__a21oi_1
XTAP_TAPCELL_ROW_27_713 vssd1 vccd1 sky130_fd_sc_hd__tapvpwrvgnd_1
X_09519_ _01826_ _04535_ _04538_ vssd1 vssd1 vccd1 vccd1 _04539_ sky130_fd_sc_hd__a21oi_1
XFILLER_140_77 vssd1 vssd1 vccd1 vccd1 sky130_fd_sc_hd__fill_4
X_10791_ _04354_ _04362_ _04370_ _05503_ _01780_ vssd1 vssd1 vccd1 vccd1 _05747_ sky130_fd_sc_hd__a2111o_1
XTAP_TAPCELL_ROW_80_1505 vssd1 vccd1 sky130_fd_sc_hd__tapvpwrvgnd_1
XFILLER_71_389 vssd1 vssd1 vccd1 vccd1 sky130_fd_sc_hd__fill_2
X_12530_ net1502 cell2.LEI0.config_data\[43\] net838 vssd1 vssd1 vccd1 vccd1 _00959_
+ sky130_fd_sc_hd__mux2_1
XANTENNA__08118__S _03087_ vssd1 vssd1 vccd1 vccd1 sky130_fd_sc_hd__diode_2
X_12461_ net755 _05425_ vssd1 vssd1 vccd1 vccd1 _06383_ sky130_fd_sc_hd__nand2_1
XANTENNA__09979__A_N _04527_ vssd1 vssd1 vccd1 vccd1 sky130_fd_sc_hd__diode_2
X_14200_ clknet_leaf_54_clk _01172_ net717 vssd1 vssd1 vccd1 vccd1 cell3.CB_0.config_dataA\[10\]
+ sky130_fd_sc_hd__dfstp_1
XANTENNA__09957__A2 _04298_ vssd1 vssd1 vccd1 vccd1 sky130_fd_sc_hd__diode_2
X_11412_ cell0.SB0.route_sel\[92\] cell0.SB0.route_sel\[93\] vssd1 vssd1 vccd1 vccd1
+ _06275_ sky130_fd_sc_hd__nand2b_1
XFILLER_126_826 vssd1 vssd1 vccd1 vccd1 sky130_fd_sc_hd__fill_1
X_14131_ clknet_leaf_65_clk _01103_ net745 vssd1 vssd1 vccd1 vccd1 cell3.LE_1B.config_data\[11\]
+ sky130_fd_sc_hd__dfrtp_1
X_12392_ cell2.CB_1.config_dataB\[2\] net408 net835 vssd1 vssd1 vccd1 vccd1 _00825_
+ sky130_fd_sc_hd__mux2_1
X_11343_ _05879_ net278 _04544_ vssd1 vssd1 vccd1 vccd1 _06237_ sky130_fd_sc_hd__mux2_1
XTAP_TAPCELL_ROW_78_1478 vssd1 vccd1 sky130_fd_sc_hd__tapvpwrvgnd_1
X_11274_ _06205_ net312 _02249_ vssd1 vssd1 vccd1 vccd1 net167 sky130_fd_sc_hd__mux2_2
XFILLER_98_209 vssd1 vssd1 vccd1 vccd1 sky130_fd_sc_hd__fill_4
XANTENNA__09709__A2 cell2.SB0.config_data_out vssd1 vssd1 vccd1 vccd1 sky130_fd_sc_hd__diode_2
X_14062_ clknet_leaf_46_clk _01034_ net701 vssd1 vssd1 vccd1 vccd1 cell3.SB0.route_sel\[70\]
+ sky130_fd_sc_hd__dfstp_1
X_13013_ net1539 cell3.LEI0.config_data\[33\] net951 vssd1 vssd1 vccd1 vccd1 _01441_
+ sky130_fd_sc_hd__mux2_1
X_10225_ _05214_ _05219_ _05225_ _01770_ _05224_ vssd1 vssd1 vccd1 vccd1 _05226_ sky130_fd_sc_hd__a221o_1
XFILLER_4_699 vssd1 vssd1 vccd1 vccd1 sky130_fd_sc_hd__fill_1
XFILLER_3_165 vssd1 vssd1 vccd1 vccd1 sky130_fd_sc_hd__fill_2
XFILLER_133_391 vssd1 vssd1 vccd1 vccd1 sky130_fd_sc_hd__fill_1
XTAP_TAPCELL_ROW_91_1678 vssd1 vccd1 sky130_fd_sc_hd__tapvpwrvgnd_1
XTAP_TAPCELL_ROW_91_1667 vssd1 vccd1 sky130_fd_sc_hd__tapvpwrvgnd_1
X_10156_ net55 net58 net418 vssd1 vssd1 vccd1 vccd1 _05157_ sky130_fd_sc_hd__mux2_1
XANTENNA_output144_A net144 vssd1 vssd1 vccd1 vccd1 sky130_fd_sc_hd__diode_2
XFILLER_121_597 vssd1 vssd1 vccd1 vccd1 sky130_fd_sc_hd__fill_1
X_10087_ _02253_ _05087_ vssd1 vssd1 vccd1 vccd1 _05088_ sky130_fd_sc_hd__and2_4
XFILLER_59_191 vssd1 vssd1 vccd1 vccd1 sky130_fd_sc_hd__fill_1
Xhold5 cell1.LE_0A.config_data\[3\] vssd1 vssd1 vccd1 vccd1 net964 sky130_fd_sc_hd__dlygate4sd3_1
XANTENNA__08145__A1 bus1_0\[5\] vssd1 vssd1 vccd1 vccd1 sky130_fd_sc_hd__diode_2
X_13915_ clknet_leaf_35_clk _00887_ net639 vssd1 vssd1 vccd1 vccd1 cell2.LE_0B.config_data\[16\]
+ sky130_fd_sc_hd__dfrtp_1
XANTENNA__08145__B2 bus1_0\[4\] vssd1 vssd1 vccd1 vccd1 sky130_fd_sc_hd__diode_2
XTAP_TAPCELL_ROW_122_2133 vssd1 vccd1 sky130_fd_sc_hd__tapvpwrvgnd_1
XFILLER_75_684 vssd1 vssd1 vccd1 vccd1 sky130_fd_sc_hd__fill_4
XANTENNA_clkload3_A clknet_4_3_0_clk vssd1 vssd1 vccd1 vccd1 sky130_fd_sc_hd__diode_2
XTAP_TAPCELL_ROW_122_2144 vssd1 vccd1 sky130_fd_sc_hd__tapvpwrvgnd_1
X_13846_ clknet_leaf_120_clk _00818_ net665 vssd1 vssd1 vccd1 vccd1 cell1.SB0.route_sel\[123\]
+ sky130_fd_sc_hd__dfstp_1
XANTENNA__08376__X _03414_ vssd1 vssd1 vccd1 vccd1 sky130_fd_sc_hd__diode_2
X_10989_ net376 _05941_ _05942_ cell3.CB_0.config_dataA\[7\] vssd1 vssd1 vccd1 vccd1
+ _05943_ sky130_fd_sc_hd__a211o_1
X_13777_ clknet_leaf_109_clk _00749_ net653 vssd1 vssd1 vccd1 vccd1 cell1.SB0.route_sel\[54\]
+ sky130_fd_sc_hd__dfstp_1
X_12728_ cell3.CB_0.config_dataB\[20\] cell3.CB_0.config_dataB\[19\] net930 vssd1
+ vssd1 vccd1 vccd1 _01157_ sky130_fd_sc_hd__mux2_1
XANTENNA__10255__A2 _05096_ vssd1 vssd1 vccd1 vccd1 sky130_fd_sc_hd__diode_2
XFILLER_15_294 vssd1 vssd1 vccd1 vccd1 sky130_fd_sc_hd__fill_1
X_12659_ cell3.SB0.route_sel\[124\] cell3.SB0.route_sel\[123\] net914 vssd1 vssd1
+ vccd1 vccd1 _01088_ sky130_fd_sc_hd__mux2_1
XANTENNA__11204__A1 net43 vssd1 vssd1 vccd1 vccd1 sky130_fd_sc_hd__diode_2
Xhold427 cell2.LEI0.config_data\[40\] vssd1 vssd1 vccd1 vccd1 net1386 sky130_fd_sc_hd__dlygate4sd3_1
XANTENNA__10963__B1 _04370_ vssd1 vssd1 vccd1 vccd1 sky130_fd_sc_hd__diode_2
X_14329_ clknet_leaf_26_clk _01301_ net608 vssd1 vssd1 vccd1 vccd1 cell2.SB0.route_sel\[114\]
+ sky130_fd_sc_hd__dfstp_1
Xhold416 cell1.LEI0.config_data\[2\] vssd1 vssd1 vccd1 vccd1 net1375 sky130_fd_sc_hd__dlygate4sd3_1
Xhold405 cell1.LEI0.config_data\[28\] vssd1 vssd1 vccd1 vccd1 net1364 sky130_fd_sc_hd__dlygate4sd3_1
XFILLER_132_807 vssd1 vssd1 vccd1 vccd1 sky130_fd_sc_hd__fill_4
Xhold449 cell3.CB_0.config_data_inA vssd1 vssd1 vccd1 vccd1 net1408 sky130_fd_sc_hd__dlygate4sd3_1
Xhold438 cell3.LEI0.config_data\[10\] vssd1 vssd1 vccd1 vccd1 net1397 sky130_fd_sc_hd__dlygate4sd3_1
X_09870_ cell2.CB_1.config_dataA\[16\] net439 vssd1 vssd1 vccd1 vccd1 _04876_ sky130_fd_sc_hd__nor2_1
Xfanout907 net908 vssd1 vssd1 vccd1 vccd1 net907 sky130_fd_sc_hd__buf_2
Xfanout929 net934 vssd1 vssd1 vccd1 vccd1 net929 sky130_fd_sc_hd__clkbuf_4
Xfanout918 net920 vssd1 vssd1 vccd1 vccd1 net918 sky130_fd_sc_hd__clkbuf_2
X_08821_ _03850_ _03851_ _03852_ _02069_ vssd1 vssd1 vccd1 vccd1 _03853_ sky130_fd_sc_hd__a31o_4
XFILLER_112_586 vssd1 vssd1 vccd1 vccd1 sky130_fd_sc_hd__fill_2
XFILLER_112_564 vssd1 vssd1 vccd1 vccd1 sky130_fd_sc_hd__fill_1
XFILLER_97_286 vssd1 vssd1 vccd1 vccd1 sky130_fd_sc_hd__fill_4
X_08752_ net1 net12 net23 net26 net453 net451 vssd1 vssd1 vccd1 vccd1 _03786_ sky130_fd_sc_hd__mux4_1
Xclkbuf_1_1__f_cell2.LE_0B.sel_clk clknet_0_cell2.LE_0B.sel_clk vssd1 vssd1 vccd1
+ vccd1 clknet_1_1__leaf_cell2.LE_0B.sel_clk sky130_fd_sc_hd__clkbuf_16
XTAP_TAPCELL_ROW_107_1917 vssd1 vccd1 sky130_fd_sc_hd__tapvpwrvgnd_1
XTAP_TAPCELL_ROW_107_1906 vssd1 vccd1 sky130_fd_sc_hd__tapvpwrvgnd_1
X_07703_ cell0.SB0.route_sel\[28\] cell0.SB0.route_sel\[29\] net90 vssd1 vssd1 vccd1
+ vccd1 _02750_ sky130_fd_sc_hd__a21boi_1
X_08683_ _03712_ _03716_ _03715_ cell1.CB_1.config_dataB\[3\] vssd1 vssd1 vccd1 vccd1
+ _03717_ sky130_fd_sc_hd__and4bb_1
XANTENNA__09884__A1 _04260_ vssd1 vssd1 vccd1 vccd1 sky130_fd_sc_hd__diode_2
XANTENNA__09884__B2 _04197_ vssd1 vssd1 vccd1 vccd1 sky130_fd_sc_hd__diode_2
XANTENNA__08687__A2 net23 vssd1 vssd1 vccd1 vccd1 sky130_fd_sc_hd__diode_2
X_07634_ cell1.SB0.route_sel\[10\] cell1.SB0.route_sel\[11\] vssd1 vssd1 vccd1 vccd1
+ _02683_ sky130_fd_sc_hd__and2_1
XANTENNA__07190__X _02251_ vssd1 vssd1 vccd1 vccd1 sky130_fd_sc_hd__diode_2
XTAP_TAPCELL_ROW_49_1046 vssd1 vccd1 sky130_fd_sc_hd__tapvpwrvgnd_1
XFILLER_110_25 vssd1 vssd1 vccd1 vccd1 sky130_fd_sc_hd__fill_2
X_07565_ cell0.SB0.route_sel\[3\] cell0.SB0.route_sel\[2\] vssd1 vssd1 vccd1 vccd1
+ _02615_ sky130_fd_sc_hd__nand2_1
X_09304_ net303 _04328_ _04327_ vssd1 vssd1 vccd1 vccd1 _04329_ sky130_fd_sc_hd__a21bo_1
X_06516_ cell2.SB0.route_sel\[16\] vssd1 vssd1 vccd1 vccd1 _01586_ sky130_fd_sc_hd__inv_2
XTAP_TAPCELL_ROW_62_1235 vssd1 vccd1 sky130_fd_sc_hd__tapvpwrvgnd_1
XANTENNA__07647__A0 net330 vssd1 vssd1 vccd1 vccd1 sky130_fd_sc_hd__diode_2
X_07496_ cell0.SB0.route_sel\[125\] cell0.SB0.route_sel\[124\] net103 _02546_ _02545_
+ vssd1 vssd1 vccd1 vccd1 _02548_ sky130_fd_sc_hd__a41o_1
X_09235_ cell3.SB0.route_sel\[14\] cell3.SB0.route_sel\[15\] _04238_ _04249_ vssd1
+ vssd1 vccd1 vccd1 _04262_ sky130_fd_sc_hd__a211o_1
X_06447_ cell1.SB0.route_sel\[46\] vssd1 vssd1 vccd1 vccd1 _01517_ sky130_fd_sc_hd__inv_2
XANTENNA__10992__A _05898_ vssd1 vssd1 vccd1 vccd1 sky130_fd_sc_hd__diode_2
XFILLER_21_286 vssd1 vssd1 vccd1 vccd1 sky130_fd_sc_hd__fill_1
XTAP_TAPCELL_ROW_32_782 vssd1 vccd1 sky130_fd_sc_hd__tapvpwrvgnd_1
XTAP_TAPCELL_ROW_32_793 vssd1 vccd1 sky130_fd_sc_hd__tapvpwrvgnd_1
XANTENNA__09939__A2 bus3_2\[10\] vssd1 vssd1 vccd1 vccd1 sky130_fd_sc_hd__diode_2
X_09166_ cell2.SB0.route_sel\[0\] cell2.SB0.route_sel\[1\] _04186_ _04193_ net829
+ vssd1 vssd1 vccd1 vccd1 _04194_ sky130_fd_sc_hd__a311oi_2
XFILLER_5_419 vccd1 vssd1 vccd1 vssd1 sky130_ef_sc_hd__decap_40_12
XANTENNA__10954__A0 net40 vssd1 vssd1 vccd1 vccd1 sky130_fd_sc_hd__diode_2
X_08117_ cell0.LE_0B.config_data\[9\] cell0.LE_0B.config_data\[8\] _03087_ vssd1 vssd1
+ vccd1 vccd1 _03159_ sky130_fd_sc_hd__mux2_1
X_09097_ _04120_ _04126_ vssd1 vssd1 vccd1 vccd1 _04127_ sky130_fd_sc_hd__or2_1
XANTENNA__08072__A0 bus2_0\[0\] vssd1 vssd1 vccd1 vccd1 sky130_fd_sc_hd__diode_2
X_08048_ net527 _02235_ _03089_ net526 vssd1 vssd1 vccd1 vccd1 _03090_ sky130_fd_sc_hd__o211a_1
XFILLER_135_55 vssd1 vssd1 vccd1 vccd1 sky130_fd_sc_hd__fill_1
X_10010_ bus3_2\[5\] _04996_ _04997_ bus3_2\[4\] cell2.CB_1.config_dataB\[13\] vssd1
+ vssd1 vccd1 vccd1 _05014_ sky130_fd_sc_hd__a221o_1
XFILLER_88_242 vssd1 vssd1 vccd1 vccd1 sky130_fd_sc_hd__fill_1
XANTENNA__08375__A1 net346 vssd1 vssd1 vccd1 vccd1 sky130_fd_sc_hd__diode_2
XFILLER_0_113 vssd1 vssd1 vccd1 vccd1 sky130_fd_sc_hd__fill_4
XFILLER_1_669 vssd1 vssd1 vccd1 vccd1 sky130_fd_sc_hd__fill_2
X_09999_ _05002_ _05001_ cell2.CB_1.config_dataB\[12\] vssd1 vssd1 vccd1 vccd1 _05003_
+ sky130_fd_sc_hd__mux2_1
XFILLER_95_15 vccd1 vssd1 vccd1 vssd1 sky130_ef_sc_hd__decap_40_12
XTAP_TAPCELL_ROW_73_1397 vssd1 vccd1 sky130_fd_sc_hd__tapvpwrvgnd_1
XFILLER_0_146 vssd1 vssd1 vccd1 vccd1 sky130_fd_sc_hd__fill_8
XFILLER_48_128 vssd1 vssd1 vccd1 vccd1 sky130_fd_sc_hd__fill_1
XFILLER_28_20 vssd1 vssd1 vccd1 vccd1 sky130_fd_sc_hd__fill_8
XANTENNA__11131__A0 net53 vssd1 vssd1 vccd1 vccd1 sky130_fd_sc_hd__diode_2
XFILLER_91_418 vssd1 vssd1 vccd1 vccd1 sky130_fd_sc_hd__fill_8
X_11961_ cell0.SB0.route_sel\[67\] cell0.SB0.route_sel\[66\] net764 vssd1 vssd1 vccd1
+ vccd1 _00398_ sky130_fd_sc_hd__mux2_1
XFILLER_28_53 vssd1 vssd1 vccd1 vccd1 sky130_fd_sc_hd__fill_8
X_10912_ net49 net50 net51 net52 net379 net378 vssd1 vssd1 vccd1 vccd1 _05866_ sky130_fd_sc_hd__mux4_1
X_13700_ clknet_leaf_27_clk _00672_ net613 vssd1 vssd1 vccd1 vccd1 cell2.CB_0.config_dataA\[2\]
+ sky130_fd_sc_hd__dfstp_1
XANTENNA__07335__C1 _02390_ vssd1 vssd1 vccd1 vccd1 sky130_fd_sc_hd__diode_2
XFILLER_17_537 vssd1 vssd1 vccd1 vccd1 sky130_fd_sc_hd__fill_1
XFILLER_72_643 vssd1 vssd1 vccd1 vccd1 sky130_fd_sc_hd__fill_1
X_11892_ cell1.CB_0.config_dataA\[23\] cell1.CB_0.config_dataA\[22\] net875 vssd1
+ vssd1 vccd1 vccd1 _00329_ sky130_fd_sc_hd__mux2_1
XANTENNA__10485__A2 _03514_ vssd1 vssd1 vccd1 vccd1 sky130_fd_sc_hd__diode_2
XANTENNA__10890__C1 net352 vssd1 vssd1 vccd1 vccd1 sky130_fd_sc_hd__diode_2
X_13631_ clknet_leaf_39_clk net1295 net647 vssd1 vssd1 vccd1 vccd1 cell2.LE_1B.config_data\[3\]
+ sky130_fd_sc_hd__dfrtp_1
XANTENNA__11334__Y net176 vssd1 vssd1 vccd1 vccd1 sky130_fd_sc_hd__diode_2
X_10843_ net364 net365 vssd1 vssd1 vccd1 vccd1 _05799_ sky130_fd_sc_hd__nand2b_1
X_10774_ net17 net18 net19 net20 net369 cell3.CB_1.config_dataB\[6\] vssd1 vssd1 vccd1
+ vccd1 _05730_ sky130_fd_sc_hd__mux4_1
X_13562_ clknet_leaf_118_clk net1388 net669 vssd1 vssd1 vccd1 vccd1 cell1.LE_0A.config_data\[5\]
+ sky130_fd_sc_hd__dfrtp_1
X_12513_ net1336 net1316 net843 vssd1 vssd1 vccd1 vccd1 _00942_ sky130_fd_sc_hd__mux2_1
XFILLER_9_725 vssd1 vssd1 vccd1 vccd1 sky130_fd_sc_hd__fill_2
X_13493_ clknet_leaf_94_clk _00465_ net692 vssd1 vssd1 vccd1 vccd1 cell1.CB_1.config_dataB\[6\]
+ sky130_fd_sc_hd__dfstp_1
XFILLER_8_224 vssd1 vssd1 vccd1 vccd1 sky130_fd_sc_hd__fill_4
XANTENNA__07653__A3 net353 vssd1 vssd1 vccd1 vccd1 sky130_fd_sc_hd__diode_2
X_12444_ net1176 net1161 net844 vssd1 vssd1 vccd1 vccd1 _00875_ sky130_fd_sc_hd__mux2_1
XFILLER_60_51 vssd1 vssd1 vccd1 vccd1 sky130_fd_sc_hd__fill_1
XTAP_TAPCELL_ROW_93_1707 vssd1 vccd1 sky130_fd_sc_hd__tapvpwrvgnd_1
XANTENNA__11510__B _02008_ vssd1 vssd1 vccd1 vccd1 sky130_fd_sc_hd__diode_2
X_12375_ cell1.SB0.route_sel\[113\] cell1.SB0.route_sel\[112\] net881 vssd1 vssd1
+ vccd1 vccd1 _00808_ sky130_fd_sc_hd__mux2_1
XTAP_TAPCELL_ROW_10_454 vssd1 vccd1 sky130_fd_sc_hd__tapvpwrvgnd_1
XTAP_TAPCELL_ROW_10_465 vssd1 vccd1 sky130_fd_sc_hd__tapvpwrvgnd_1
XANTENNA_input60_X net60 vssd1 vssd1 vccd1 vccd1 sky130_fd_sc_hd__diode_2
X_14114_ clknet_leaf_50_clk _01086_ net705 vssd1 vssd1 vccd1 vccd1 cell3.SB0.route_sel\[122\]
+ sky130_fd_sc_hd__dfstp_1
X_11326_ _06228_ net294 _04729_ vssd1 vssd1 vccd1 vccd1 net158 sky130_fd_sc_hd__mux2_1
XFILLER_126_689 vssd1 vssd1 vccd1 vccd1 sky130_fd_sc_hd__fill_1
X_14045_ clknet_leaf_49_clk _01017_ net705 vssd1 vssd1 vccd1 vccd1 cell3.SB0.route_sel\[53\]
+ sky130_fd_sc_hd__dfstp_1
XANTENNA_output261_A net261 vssd1 vssd1 vccd1 vccd1 sky130_fd_sc_hd__diode_2
XFILLER_5_57 vccd1 vssd1 vccd1 vssd1 sky130_ef_sc_hd__decap_40_12
X_11257_ _04339_ _05144_ vssd1 vssd1 vccd1 vccd1 _06196_ sky130_fd_sc_hd__nand2_1
X_11188_ cell3.LEI0.config_data\[28\] _06139_ cell3.LEI0.config_data\[29\] vssd1 vssd1
+ vccd1 vccd1 _06140_ sky130_fd_sc_hd__a21oi_1
X_10208_ net36 net37 net38 net39 net416 cell2.CB_0.config_dataA\[11\] vssd1 vssd1
+ vccd1 vccd1 _05209_ sky130_fd_sc_hd__mux4_1
X_10139_ _05094_ _05136_ _05139_ _05099_ vssd1 vssd1 vccd1 vccd1 _05140_ sky130_fd_sc_hd__o2bb2a_1
XANTENNA__09315__B1 net58 vssd1 vssd1 vccd1 vccd1 sky130_fd_sc_hd__diode_2
XFILLER_36_813 vssd1 vssd1 vccd1 vccd1 sky130_fd_sc_hd__fill_1
XANTENNA__11122__A0 net286 vssd1 vssd1 vccd1 vccd1 sky130_fd_sc_hd__diode_2
XFILLER_75_481 vssd1 vssd1 vccd1 vccd1 sky130_fd_sc_hd__fill_1
XFILLER_48_673 vssd1 vssd1 vccd1 vccd1 sky130_fd_sc_hd__fill_1
XANTENNA__09142__S cell1.LE_0B.reset_val vssd1 vssd1 vccd1 vccd1 sky130_fd_sc_hd__diode_2
X_13829_ clknet_leaf_115_clk _00801_ net666 vssd1 vssd1 vccd1 vccd1 cell1.SB0.route_sel\[106\]
+ sky130_fd_sc_hd__dfstp_1
XTAP_TAPCELL_ROW_18_576 vssd1 vccd1 sky130_fd_sc_hd__tapvpwrvgnd_1
XTAP_TAPCELL_ROW_102_1836 vssd1 vccd1 sky130_fd_sc_hd__tapvpwrvgnd_1
X_07350_ net355 _02326_ vssd1 vssd1 vccd1 vccd1 _02406_ sky130_fd_sc_hd__nor2_1
XANTENNA__10633__C1 _05503_ vssd1 vssd1 vccd1 vccd1 sky130_fd_sc_hd__diode_2
XANTENNA__11260__X net192 vssd1 vssd1 vccd1 vccd1 sky130_fd_sc_hd__diode_2
X_09020_ _01670_ cell1.CB_0.config_dataB\[9\] _04021_ vssd1 vssd1 vccd1 vccd1 _04050_
+ sky130_fd_sc_hd__nand3_1
X_07281_ cell0.CB_0.config_dataB\[22\] cell0.CB_0.config_dataB\[23\] vssd1 vssd1 vccd1
+ vccd1 _02339_ sky130_fd_sc_hd__and2_1
XTAP_TAPCELL_ROW_135_2335 vssd1 vccd1 sky130_fd_sc_hd__tapvpwrvgnd_1
Xhold202 cell2.LE_0B.config_data\[3\] vssd1 vssd1 vccd1 vccd1 net1161 sky130_fd_sc_hd__dlygate4sd3_1
XFILLER_8_780 vssd1 vssd1 vccd1 vccd1 sky130_fd_sc_hd__fill_1
Xhold213 cell2.LE_1B.config_data\[6\] vssd1 vssd1 vccd1 vccd1 net1172 sky130_fd_sc_hd__dlygate4sd3_1
Xhold235 cell1.LE_0B.config_data\[1\] vssd1 vssd1 vccd1 vccd1 net1194 sky130_fd_sc_hd__dlygate4sd3_1
Xhold224 cell1.LEI0.config_data\[15\] vssd1 vssd1 vccd1 vccd1 net1183 sky130_fd_sc_hd__dlygate4sd3_1
Xhold257 cell3.LE_0A.config_data\[2\] vssd1 vssd1 vccd1 vccd1 net1216 sky130_fd_sc_hd__dlygate4sd3_1
XANTENNA__10036__B _04724_ vssd1 vssd1 vccd1 vccd1 sky130_fd_sc_hd__diode_2
XANTENNA__11847__S net897 vssd1 vssd1 vccd1 vccd1 sky130_fd_sc_hd__diode_2
Xhold246 _00001_ vssd1 vssd1 vccd1 vccd1 net1205 sky130_fd_sc_hd__dlygate4sd3_1
Xhold268 _00211_ vssd1 vssd1 vccd1 vccd1 net1227 sky130_fd_sc_hd__dlygate4sd3_1
Xfanout715 net716 vssd1 vssd1 vccd1 vccd1 net715 sky130_fd_sc_hd__clkbuf_4
Xfanout704 net706 vssd1 vssd1 vccd1 vccd1 net704 sky130_fd_sc_hd__clkbuf_4
X_09922_ net409 _04348_ vssd1 vssd1 vccd1 vccd1 _04926_ sky130_fd_sc_hd__nand2_1
Xhold279 cell1.LEI0.config_data\[38\] vssd1 vssd1 vccd1 vccd1 net1238 sky130_fd_sc_hd__dlygate4sd3_1
Xfanout748 net749 vssd1 vssd1 vccd1 vccd1 net748 sky130_fd_sc_hd__buf_2
Xfanout737 net742 vssd1 vssd1 vccd1 vccd1 net737 sky130_fd_sc_hd__clkbuf_4
XTAP_TAPCELL_ROW_113_1998 vssd1 vccd1 sky130_fd_sc_hd__tapvpwrvgnd_1
Xfanout726 net727 vssd1 vssd1 vccd1 vccd1 net726 sky130_fd_sc_hd__clkbuf_4
X_09853_ _04399_ _04837_ _04445_ _04835_ vssd1 vssd1 vccd1 vccd1 _04859_ sky130_fd_sc_hd__a2bb2o_1
X_09784_ cell2.LEI0.config_data\[19\] _04786_ _04789_ vssd1 vssd1 vccd1 vccd1 _04790_
+ sky130_fd_sc_hd__o21a_1
XFILLER_85_223 vssd1 vssd1 vccd1 vccd1 sky130_fd_sc_hd__fill_1
X_08804_ _03835_ vssd1 vssd1 vccd1 vccd1 _03836_ sky130_fd_sc_hd__inv_2
XPHY_EDGE_ROW_0_Left_143 vssd1 vssd1 vccd1 vccd1 sky130_fd_sc_hd__decap_3
Xfanout759 net807 vssd1 vssd1 vccd1 vccd1 net759 sky130_fd_sc_hd__clkbuf_4
X_06996_ cell1.CB_0.config_dataB\[24\] cell1.CB_0.config_dataB\[21\] cell1.CB_0.config_dataB\[20\]
+ vssd1 vssd1 vccd1 vccd1 _02062_ sky130_fd_sc_hd__or3_4
X_08735_ _03736_ _03768_ _03702_ vssd1 vssd1 vccd1 vccd1 _03769_ sky130_fd_sc_hd__mux2_1
XANTENNA__11435__X net204 vssd1 vssd1 vccd1 vccd1 sky130_fd_sc_hd__diode_2
X_08666_ cell1.LEI0.config_data\[23\] _03699_ vssd1 vssd1 vccd1 vccd1 _03700_ sky130_fd_sc_hd__nor2_1
XANTENNA__07868__A0 bus2_0\[0\] vssd1 vssd1 vccd1 vccd1 sky130_fd_sc_hd__diode_2
XFILLER_121_57 vssd1 vssd1 vccd1 vccd1 sky130_fd_sc_hd__fill_4
XANTENNA__09609__A1 net52 vssd1 vssd1 vccd1 vccd1 sky130_fd_sc_hd__diode_2
XANTENNA__07332__A2 _02346_ vssd1 vssd1 vccd1 vccd1 sky130_fd_sc_hd__diode_2
XANTENNA__12069__B1_N _06377_ vssd1 vssd1 vccd1 vccd1 sky130_fd_sc_hd__diode_2
X_07617_ cell0.SB0.route_sel\[12\] cell0.SB0.route_sel\[13\] net76 vssd1 vssd1 vccd1
+ vccd1 _02666_ sky130_fd_sc_hd__a21boi_1
X_08597_ net488 _03533_ _03632_ net487 vssd1 vssd1 vccd1 vccd1 _03633_ sky130_fd_sc_hd__o211a_1
XTAP_TAPCELL_ROW_37_863 vssd1 vccd1 sky130_fd_sc_hd__tapvpwrvgnd_1
XANTENNA_fanout724_A net750 vssd1 vssd1 vccd1 vccd1 sky130_fd_sc_hd__diode_2
X_07548_ _02003_ _02397_ vssd1 vssd1 vccd1 vccd1 _02599_ sky130_fd_sc_hd__nor2_1
XFILLER_14_22 vssd1 vssd1 vccd1 vccd1 sky130_fd_sc_hd__fill_4
XANTENNA__08293__A0 bus1_0\[0\] vssd1 vssd1 vccd1 vccd1 sky130_fd_sc_hd__diode_2
XFILLER_22_540 vssd1 vssd1 vccd1 vccd1 sky130_fd_sc_hd__fill_1
X_07479_ _01919_ _02394_ vssd1 vssd1 vccd1 vccd1 _02532_ sky130_fd_sc_hd__nor2_1
XANTENNA__08832__A2 _03858_ vssd1 vssd1 vccd1 vccd1 sky130_fd_sc_hd__diode_2
XPHY_EDGE_ROW_46_Left_189 vssd1 vssd1 vccd1 vccd1 sky130_fd_sc_hd__decap_3
XFILLER_10_713 vccd1 vssd1 vccd1 vssd1 sky130_ef_sc_hd__decap_40_12
XFILLER_14_77 vssd1 vssd1 vccd1 vccd1 sky130_fd_sc_hd__fill_4
XFILLER_139_258 vssd1 vssd1 vccd1 vccd1 sky130_fd_sc_hd__fill_1
XANTENNA__06705__A cell2.LE_0A.config_data\[16\] vssd1 vssd1 vccd1 vccd1 sky130_fd_sc_hd__diode_2
X_09218_ _02670_ _02675_ _02904_ vssd1 vssd1 vccd1 vccd1 _04245_ sky130_fd_sc_hd__or3_1
XFILLER_10_757 vssd1 vssd1 vccd1 vccd1 sky130_fd_sc_hd__fill_1
X_10490_ _05460_ net334 _02768_ vssd1 vssd1 vccd1 vccd1 net159 sky130_fd_sc_hd__mux2_1
X_09149_ net356 _04175_ vssd1 vssd1 vccd1 vccd1 _04177_ sky130_fd_sc_hd__nand2_1
XFILLER_30_10 vccd1 vssd1 vccd1 vssd1 sky130_ef_sc_hd__decap_40_12
XTAP_TAPCELL_ROW_75_1426 vssd1 vccd1 sky130_fd_sc_hd__tapvpwrvgnd_1
X_12160_ cell1.LEI0.config_data\[42\] net1271 net893 vssd1 vssd1 vccd1 vccd1 _00593_
+ sky130_fd_sc_hd__mux2_1
XFILLER_5_238 vssd1 vssd1 vccd1 vccd1 sky130_fd_sc_hd__fill_1
XFILLER_123_615 vssd1 vssd1 vccd1 vccd1 sky130_fd_sc_hd__fill_1
X_11111_ cell3.CB_0.config_dataB\[3\] cell3.CB_0.config_dataB\[2\] vssd1 vssd1 vccd1
+ vccd1 _06063_ sky130_fd_sc_hd__nor2_1
XTAP_TAPCELL_ROW_75_1437 vssd1 vccd1 sky130_fd_sc_hd__tapvpwrvgnd_1
Xclkbuf_0_cell1.LE_0A.sel_clk cell1.LE_0A.sel_clk vssd1 vssd1 vccd1 vccd1 clknet_0_cell1.LE_0A.sel_clk
+ sky130_fd_sc_hd__clkbuf_16
X_12091_ cell1.LE_0B.reset_mode cell1.LE_0B.reset_val net890 vssd1 vssd1 vccd1 vccd1
+ _00526_ sky130_fd_sc_hd__mux2_1
X_11042_ net373 _05847_ _05995_ net372 vssd1 vssd1 vccd1 vccd1 _05996_ sky130_fd_sc_hd__o211a_1
XPHY_EDGE_ROW_55_Left_198 vssd1 vssd1 vccd1 vccd1 sky130_fd_sc_hd__decap_3
XANTENNA_input20_A CBeast_in[27] vssd1 vssd1 vccd1 vccd1 sky130_fd_sc_hd__diode_2
X_12993_ net1453 net1433 net946 vssd1 vssd1 vccd1 vccd1 _01421_ sky130_fd_sc_hd__mux2_1
XANTENNA__10897__A net272 vssd1 vssd1 vccd1 vccd1 sky130_fd_sc_hd__diode_2
XANTENNA__09848__B2 bus3_2\[4\] vssd1 vssd1 vccd1 vccd1 sky130_fd_sc_hd__diode_2
XANTENNA__09848__A1 bus3_2\[5\] vssd1 vssd1 vccd1 vccd1 sky130_fd_sc_hd__diode_2
XFILLER_29_150 vssd1 vssd1 vccd1 vccd1 sky130_fd_sc_hd__fill_4
X_11944_ cell0.SB0.route_sel\[50\] cell0.SB0.route_sel\[49\] net759 vssd1 vssd1 vccd1
+ vccd1 _00381_ sky130_fd_sc_hd__mux2_1
XTAP_TAPCELL_ROW_86_1599 vssd1 vccd1 sky130_fd_sc_hd__tapvpwrvgnd_1
X_11875_ net469 net470 net879 vssd1 vssd1 vccd1 vccd1 _00312_ sky130_fd_sc_hd__mux2_1
XANTENNA__08520__A1 net27 vssd1 vssd1 vccd1 vccd1 sky130_fd_sc_hd__diode_2
XANTENNA__08520__B2 net28 vssd1 vssd1 vccd1 vccd1 sky130_fd_sc_hd__diode_2
X_10826_ _05780_ _05781_ cell3.CB_1.config_dataB\[12\] vssd1 vssd1 vccd1 vccd1 _05782_
+ sky130_fd_sc_hd__mux2_1
XANTENNA__12604__A0 cell3.SB0.route_sel\[69\] vssd1 vssd1 vccd1 vccd1 sky130_fd_sc_hd__diode_2
X_13614_ clknet_leaf_92_clk _00586_ net695 vssd1 vssd1 vccd1 vccd1 cell1.LEI0.config_data\[35\]
+ sky130_fd_sc_hd__dfrtp_1
XTAP_TAPCELL_ROW_15_535 vssd1 vccd1 sky130_fd_sc_hd__tapvpwrvgnd_1
XANTENNA__08086__B _02897_ vssd1 vssd1 vccd1 vccd1 sky130_fd_sc_hd__diode_2
X_10757_ _05707_ _05710_ _05712_ cell3.CB_1.config_dataB\[2\] vssd1 vssd1 vccd1 vccd1
+ _05713_ sky130_fd_sc_hd__o22a_1
X_13545_ clknet_leaf_72_clk _00517_ net728 vssd1 vssd1 vccd1 vccd1 cell1.LE_0B.config_data\[10\]
+ sky130_fd_sc_hd__dfrtp_1
Xclkbuf_leaf_133_clk clknet_4_0_0_clk vssd1 vssd1 vccd1 vccd1 clknet_leaf_133_clk
+ sky130_fd_sc_hd__clkbuf_8
X_10688_ _05528_ _05642_ _05644_ _05531_ _01792_ vssd1 vssd1 vccd1 vccd1 _05646_ sky130_fd_sc_hd__a221o_1
X_13476_ clknet_leaf_2_clk _00448_ net571 vssd1 vssd1 vccd1 vccd1 cell0.SB0.route_sel\[117\]
+ sky130_fd_sc_hd__dfstp_1
XTAP_TAPCELL_ROW_117_2065 vssd1 vccd1 sky130_fd_sc_hd__tapvpwrvgnd_1
X_12427_ net980 net1126 net924 vssd1 vssd1 vccd1 vccd1 _00859_ sky130_fd_sc_hd__mux2_1
XANTENNA__10394__A1 net37 vssd1 vssd1 vccd1 vccd1 sky130_fd_sc_hd__diode_2
XANTENNA__08830__A _02780_ vssd1 vssd1 vccd1 vccd1 sky130_fd_sc_hd__diode_2
X_12358_ cell1.SB0.route_sel\[96\] cell1.SB0.route_sel\[95\] net870 vssd1 vssd1 vccd1
+ vccd1 _00791_ sky130_fd_sc_hd__mux2_1
XTAP_TAPCELL_ROW_130_2265 vssd1 vccd1 sky130_fd_sc_hd__tapvpwrvgnd_1
XTAP_TAPCELL_ROW_130_2254 vssd1 vccd1 sky130_fd_sc_hd__tapvpwrvgnd_1
XFILLER_113_136 vssd1 vssd1 vccd1 vccd1 sky130_fd_sc_hd__fill_1
X_11309_ net293 _06219_ _04508_ vssd1 vssd1 vccd1 vccd1 net149 sky130_fd_sc_hd__mux2_1
X_12289_ cell1.SB0.route_sel\[27\] cell1.SB0.route_sel\[26\] net857 vssd1 vssd1 vccd1
+ vccd1 _00722_ sky130_fd_sc_hd__mux2_1
XANTENNA__11343__A0 _05879_ vssd1 vssd1 vccd1 vccd1 sky130_fd_sc_hd__diode_2
XFILLER_113_169 vssd1 vssd1 vccd1 vccd1 sky130_fd_sc_hd__fill_1
X_14028_ clknet_leaf_47_clk _01000_ net703 vssd1 vssd1 vccd1 vccd1 cell3.SB0.route_sel\[36\]
+ sky130_fd_sc_hd__dfstp_1
XFILLER_121_180 vssd1 vssd1 vccd1 vccd1 sky130_fd_sc_hd__fill_1
X_06850_ cell2.CB_0.config_dataB\[24\] cell2.CB_0.config_dataB\[20\] cell2.CB_0.config_dataB\[21\]
+ vssd1 vssd1 vccd1 vccd1 _01919_ sky130_fd_sc_hd__or3b_1
XANTENNA__10143__Y _05144_ vssd1 vssd1 vccd1 vccd1 sky130_fd_sc_hd__diode_2
XFILLER_83_727 vssd1 vssd1 vccd1 vccd1 sky130_fd_sc_hd__fill_1
X_06781_ cell0.CB_1.config_dataB\[23\] cell0.CB_1.config_dataB\[22\] vssd1 vssd1 vccd1
+ vccd1 _01851_ sky130_fd_sc_hd__and2b_1
X_08520_ net27 _03549_ _03550_ net28 cell1.CB_1.config_dataA\[8\] vssd1 vssd1 vccd1
+ vccd1 _03556_ sky130_fd_sc_hd__a221o_1
XTAP_TAPCELL_ROW_46_1005 vssd1 vccd1 sky130_fd_sc_hd__tapvpwrvgnd_1
X_08451_ cell1.SB0.route_sel\[125\] cell1.SB0.route_sel\[124\] vssd1 vssd1 vccd1 vccd1
+ _03487_ sky130_fd_sc_hd__or2_1
X_07402_ net354 _02340_ _02421_ _02455_ vssd1 vssd1 vccd1 vccd1 _02457_ sky130_fd_sc_hd__o211a_1
XFILLER_23_315 vssd1 vssd1 vccd1 vccd1 sky130_fd_sc_hd__fill_1
XTAP_TAPCELL_ROW_34_811 vssd1 vccd1 sky130_fd_sc_hd__tapvpwrvgnd_1
XTAP_TAPCELL_ROW_34_822 vssd1 vccd1 sky130_fd_sc_hd__tapvpwrvgnd_1
X_08382_ net500 net499 vssd1 vssd1 vccd1 vccd1 _03420_ sky130_fd_sc_hd__nor2_1
X_07333_ cell2.SB0.route_sel\[100\] cell2.SB0.route_sel\[101\] vssd1 vssd1 vccd1 vccd1
+ _02390_ sky130_fd_sc_hd__nand2_2
XANTENNA__08814__A2 _03841_ vssd1 vssd1 vccd1 vccd1 sky130_fd_sc_hd__diode_2
XANTENNA__07078__A1 net82 vssd1 vssd1 vccd1 vccd1 sky130_fd_sc_hd__diode_2
Xclkbuf_leaf_124_clk clknet_4_2_0_clk vssd1 vssd1 vccd1 vccd1 clknet_leaf_124_clk
+ sky130_fd_sc_hd__clkbuf_8
XFILLER_136_206 vssd1 vssd1 vccd1 vccd1 sky130_fd_sc_hd__fill_1
X_07264_ _02322_ _02320_ vssd1 vssd1 vccd1 vccd1 bus2_0\[11\] sky130_fd_sc_hd__and2b_4
XANTENNA__10082__B1 cell2.SB0.route_sel\[92\] vssd1 vssd1 vccd1 vccd1 sky130_fd_sc_hd__diode_2
X_09003_ _03894_ _04020_ _04021_ _03890_ _01670_ vssd1 vssd1 vccd1 vccd1 _04033_ sky130_fd_sc_hd__a221o_1
XANTENNA__11177__A3 net43 vssd1 vssd1 vccd1 vccd1 sky130_fd_sc_hd__diode_2
XANTENNA__10909__B1 _05861_ vssd1 vssd1 vccd1 vccd1 sky130_fd_sc_hd__diode_2
X_07195_ _02254_ _02255_ _02253_ vssd1 vssd1 vccd1 vccd1 bus2_0\[10\] sky130_fd_sc_hd__a21boi_4
XFILLER_3_709 vccd1 vssd1 vccd1 vssd1 sky130_ef_sc_hd__decap_40_12
XTAP_TAPCELL_ROW_57_1167 vssd1 vccd1 sky130_fd_sc_hd__tapvpwrvgnd_1
XTAP_TAPCELL_ROW_57_1156 vssd1 vccd1 sky130_fd_sc_hd__tapvpwrvgnd_1
X_09905_ _04910_ _04909_ _04791_ vssd1 vssd1 vccd1 vccd1 _04911_ sky130_fd_sc_hd__mux2_1
XANTENNA__09527__A0 net49 vssd1 vssd1 vccd1 vccd1 sky130_fd_sc_hd__diode_2
XFILLER_116_57 vssd1 vssd1 vccd1 vccd1 sky130_fd_sc_hd__fill_2
Xfanout512 cell0.CB_0.config_dataA\[15\] vssd1 vssd1 vccd1 vccd1 net512 sky130_fd_sc_hd__buf_2
Xfanout523 cell0.CB_0.config_dataB\[16\] vssd1 vssd1 vccd1 vccd1 net523 sky130_fd_sc_hd__buf_2
Xfanout501 cell0.CB_1.config_dataB\[15\] vssd1 vssd1 vccd1 vccd1 net501 sky130_fd_sc_hd__clkbuf_2
XTAP_TAPCELL_ROW_70_1356 vssd1 vccd1 sky130_fd_sc_hd__tapvpwrvgnd_1
XANTENNA_fanout674_A net675 vssd1 vssd1 vccd1 vccd1 sky130_fd_sc_hd__diode_2
Xfanout534 cell0.CB_0.config_dataB\[0\] vssd1 vssd1 vccd1 vccd1 net534 sky130_fd_sc_hd__clkbuf_2
Xfanout545 cell0.CB_1.config_dataA\[1\] vssd1 vssd1 vccd1 vccd1 net545 sky130_fd_sc_hd__buf_1
Xfanout556 net559 vssd1 vssd1 vccd1 vccd1 net556 sky130_fd_sc_hd__clkbuf_4
XFILLER_112_191 vssd1 vssd1 vccd1 vccd1 sky130_fd_sc_hd__fill_1
X_09836_ _04840_ _04841_ cell2.CB_1.config_dataA\[12\] vssd1 vssd1 vccd1 vccd1 _04842_
+ sky130_fd_sc_hd__mux2_1
Xfanout567 net568 vssd1 vssd1 vccd1 vccd1 net567 sky130_fd_sc_hd__clkbuf_2
Xfanout589 net591 vssd1 vssd1 vccd1 vccd1 net589 sky130_fd_sc_hd__clkbuf_4
Xfanout578 net579 vssd1 vssd1 vccd1 vccd1 net578 sky130_fd_sc_hd__clkbuf_4
XANTENNA_fanout841_A net845 vssd1 vssd1 vccd1 vccd1 sky130_fd_sc_hd__diode_2
X_09767_ cell2.CB_1.config_dataA\[8\] cell2.CB_1.config_dataA\[7\] vssd1 vssd1 vccd1
+ vccd1 _04773_ sky130_fd_sc_hd__nor2_1
XFILLER_86_587 vssd1 vssd1 vccd1 vccd1 sky130_fd_sc_hd__fill_1
X_06979_ net81 _02042_ vssd1 vssd1 vccd1 vccd1 _02045_ sky130_fd_sc_hd__nand2_1
X_09698_ _04708_ _04710_ _04711_ vssd1 vssd1 vccd1 vccd1 _04712_ sky130_fd_sc_hd__a21oi_1
XFILLER_92_27 vssd1 vssd1 vccd1 vccd1 sky130_fd_sc_hd__fill_1
XANTENNA_fanout939_A net940 vssd1 vssd1 vccd1 vccd1 sky130_fd_sc_hd__diode_2
X_08718_ net455 _03465_ _03751_ net454 vssd1 vssd1 vccd1 vccd1 _03752_ sky130_fd_sc_hd__o211a_1
XANTENNA__07091__A bus3_1\[9\] vssd1 vssd1 vccd1 vccd1 sky130_fd_sc_hd__diode_2
X_08649_ cell1.CB_1.config_dataB\[7\] _03674_ _03675_ _03678_ _03682_ vssd1 vssd1
+ vccd1 vccd1 _03683_ sky130_fd_sc_hd__o221a_1
XANTENNA_fanout727_X net727 vssd1 vssd1 vccd1 vccd1 sky130_fd_sc_hd__diode_2
XFILLER_81_281 vssd1 vssd1 vccd1 vccd1 sky130_fd_sc_hd__fill_1
XFILLER_14_326 vssd1 vssd1 vccd1 vccd1 sky130_fd_sc_hd__fill_1
XFILLER_26_197 vssd1 vssd1 vccd1 vccd1 sky130_fd_sc_hd__fill_1
X_11660_ net505 net506 net783 vssd1 vssd1 vccd1 vccd1 _00101_ sky130_fd_sc_hd__mux2_1
XFILLER_25_65 vssd1 vssd1 vccd1 vccd1 sky130_fd_sc_hd__fill_2
X_10611_ _01785_ net396 vssd1 vssd1 vccd1 vccd1 _05569_ sky130_fd_sc_hd__or2_1
Xclkbuf_leaf_115_clk clknet_4_9_0_clk vssd1 vssd1 vccd1 vccd1 clknet_leaf_115_clk
+ sky130_fd_sc_hd__clkbuf_8
X_11591_ cell0.CB_1.config_dataA\[12\] net538 net856 vssd1 vssd1 vccd1 vccd1 _00032_
+ sky130_fd_sc_hd__mux2_1
XFILLER_10_510 vssd1 vssd1 vccd1 vccd1 sky130_fd_sc_hd__fill_2
X_10542_ cell3.SB0.route_sel\[16\] _01690_ cell3.SB0.route_sel\[21\] cell3.SB0.route_sel\[20\]
+ _05499_ vssd1 vssd1 vccd1 vccd1 _05500_ sky130_fd_sc_hd__o221a_1
X_13330_ clknet_leaf_85_clk _00302_ net673 vssd1 vssd1 vccd1 vccd1 cell1.CB_0.config_dataB\[21\]
+ sky130_fd_sc_hd__dfstp_1
XANTENNA__08634__B _03529_ vssd1 vssd1 vccd1 vccd1 sky130_fd_sc_hd__diode_2
XANTENNA__10228__Y _05229_ vssd1 vssd1 vccd1 vccd1 sky130_fd_sc_hd__diode_2
X_13261_ clknet_leaf_123_clk _00233_ net587 vssd1 vssd1 vccd1 vccd1 cell0.LEI0.config_data\[46\]
+ sky130_fd_sc_hd__dfrtp_1
XFILLER_41_53 vssd1 vssd1 vccd1 vccd1 sky130_fd_sc_hd__fill_1
XANTENNA__08281__A3 bus1_0\[11\] vssd1 vssd1 vccd1 vccd1 sky130_fd_sc_hd__diode_2
X_12212_ net435 cell2.CB_0.config_dataA\[24\] net841 vssd1 vssd1 vccd1 vccd1 _00645_
+ sky130_fd_sc_hd__mux2_1
X_10473_ _01748_ cell3.SB0.route_sel\[122\] cell3.SB0.route_sel\[125\] _01749_ _05455_
+ vssd1 vssd1 vccd1 vccd1 _05456_ sky130_fd_sc_hd__a221o_1
XFILLER_6_547 vssd1 vssd1 vccd1 vccd1 sky130_fd_sc_hd__fill_2
XFILLER_6_558 vssd1 vssd1 vccd1 vccd1 sky130_fd_sc_hd__fill_4
XANTENNA__08569__A1 net5 vssd1 vssd1 vccd1 vccd1 sky130_fd_sc_hd__diode_2
Xclkbuf_0_cell3.LE_0B.sel_clk cell3.LE_0B.sel_clk vssd1 vssd1 vccd1 vccd1 clknet_0_cell3.LE_0B.sel_clk
+ sky130_fd_sc_hd__clkbuf_16
XFILLER_135_250 vssd1 vssd1 vccd1 vccd1 sky130_fd_sc_hd__fill_1
XFILLER_108_486 vccd1 vssd1 vccd1 vssd1 sky130_ef_sc_hd__decap_40_12
X_13192_ clknet_1_0__leaf_cell0.LE_0B.sel_clk _00164_ net751 vssd1 vssd1 vccd1 vccd1
+ cell0.LE_0B.dff0_out sky130_fd_sc_hd__dfrtp_1
XANTENNA_input68_A SBsouth_in[12] vssd1 vssd1 vccd1 vccd1 sky130_fd_sc_hd__diode_2
XANTENNA__07537__Y _02588_ vssd1 vssd1 vccd1 vccd1 sky130_fd_sc_hd__diode_2
XPHY_EDGE_ROW_63_Left_206 vssd1 vssd1 vccd1 vccd1 sky130_fd_sc_hd__decap_3
X_12143_ net1345 net1400 net893 vssd1 vssd1 vccd1 vccd1 _00576_ sky130_fd_sc_hd__mux2_1
X_12074_ net1156 net1194 net903 vssd1 vssd1 vccd1 vccd1 _00509_ sky130_fd_sc_hd__mux2_1
XANTENNA__07792__A2 net354 vssd1 vssd1 vccd1 vccd1 sky130_fd_sc_hd__diode_2
XANTENNA__12117__A2 net548 vssd1 vssd1 vccd1 vccd1 sky130_fd_sc_hd__diode_2
XFILLER_2_753 vssd1 vssd1 vccd1 vccd1 sky130_fd_sc_hd__fill_2
X_11025_ cell3.CB_0.config_dataA\[11\] _05976_ _05977_ _05978_ vssd1 vssd1 vccd1 vccd1
+ _05979_ sky130_fd_sc_hd__a211o_1
XFILLER_49_234 vssd1 vssd1 vccd1 vccd1 sky130_fd_sc_hd__fill_1
XANTENNA__08741__A1 net5 vssd1 vssd1 vccd1 vccd1 sky130_fd_sc_hd__diode_2
XTAP_TAPCELL_ROW_88_1628 vssd1 vccd1 sky130_fd_sc_hd__tapvpwrvgnd_1
XANTENNA_input23_X net23 vssd1 vssd1 vccd1 vccd1 sky130_fd_sc_hd__diode_2
XFILLER_77_576 vssd1 vssd1 vccd1 vccd1 sky130_fd_sc_hd__fill_2
XFILLER_65_749 vssd1 vssd1 vccd1 vccd1 sky130_fd_sc_hd__fill_1
XFILLER_18_610 vssd1 vssd1 vccd1 vccd1 sky130_fd_sc_hd__fill_8
XANTENNA__07272__Y _02330_ vssd1 vssd1 vccd1 vccd1 sky130_fd_sc_hd__diode_2
X_12976_ cell3.LE_0A.reset_mode cell3.LE_0A.reset_val net957 vssd1 vssd1 vccd1 vccd1
+ _01404_ sky130_fd_sc_hd__mux2_1
XPHY_EDGE_ROW_72_Left_215 vssd1 vssd1 vccd1 vccd1 sky130_fd_sc_hd__decap_3
X_11927_ cell0.SB0.route_sel\[33\] cell0.SB0.route_sel\[32\] net764 vssd1 vssd1 vccd1
+ vccd1 _00364_ sky130_fd_sc_hd__mux2_1
X_11858_ cell1.CB_0.config_dataB\[14\] cell1.CB_0.config_dataB\[13\] net897 vssd1
+ vssd1 vccd1 vccd1 _00295_ sky130_fd_sc_hd__mux2_1
X_10809_ net366 _05760_ _05764_ _01782_ vssd1 vssd1 vccd1 vccd1 _05765_ sky130_fd_sc_hd__a211o_1
X_11789_ net1196 cell0.LEI0.config_data\[38\] net776 vssd1 vssd1 vccd1 vccd1 _00226_
+ sky130_fd_sc_hd__mux2_1
Xclkbuf_leaf_106_clk clknet_4_8_0_clk vssd1 vssd1 vccd1 vccd1 clknet_leaf_106_clk
+ sky130_fd_sc_hd__clkbuf_8
XANTENNA_19 net136 vssd1 vssd1 vccd1 vccd1 sky130_fd_sc_hd__diode_2
XFILLER_20_307 vssd1 vssd1 vccd1 vccd1 sky130_fd_sc_hd__fill_1
XANTENNA__08257__A0 net344 vssd1 vssd1 vccd1 vccd1 sky130_fd_sc_hd__diode_2
XANTENNA__11800__A1 net1347 vssd1 vssd1 vccd1 vccd1 sky130_fd_sc_hd__diode_2
XFILLER_41_690 vssd1 vssd1 vccd1 vccd1 sky130_fd_sc_hd__fill_1
X_13528_ clknet_leaf_101_clk _00500_ net682 vssd1 vssd1 vccd1 vccd1 cell1.LE_1A.config_data\[15\]
+ sky130_fd_sc_hd__dfrtp_1
XANTENNA__08009__A0 bus2_0\[0\] vssd1 vssd1 vccd1 vccd1 sky130_fd_sc_hd__diode_2
XANTENNA__09757__A0 bus3_2\[8\] vssd1 vssd1 vccd1 vccd1 sky130_fd_sc_hd__diode_2
X_13459_ clknet_leaf_130_clk _00431_ net562 vssd1 vssd1 vccd1 vccd1 cell0.SB0.route_sel\[100\]
+ sky130_fd_sc_hd__dfstp_1
XANTENNA__11159__A3 net52 vssd1 vssd1 vccd1 vccd1 sky130_fd_sc_hd__diode_2
XANTENNA_clkbuf_leaf_71_clk_A clknet_4_14_0_clk vssd1 vssd1 vccd1 vccd1 sky130_fd_sc_hd__diode_2
XANTENNA__09656__A _02469_ vssd1 vssd1 vccd1 vccd1 sky130_fd_sc_hd__diode_2
XPHY_EDGE_ROW_81_Left_224 vssd1 vssd1 vccd1 vccd1 sky130_fd_sc_hd__decap_3
Xoutput148 net148 vssd1 vssd1 vccd1 vccd1 CBeast_out[22] sky130_fd_sc_hd__buf_2
XANTENNA__07232__A1 net327 vssd1 vssd1 vccd1 vccd1 sky130_fd_sc_hd__diode_2
Xoutput159 net159 vssd1 vssd1 vccd1 vccd1 CBeast_out[3] sky130_fd_sc_hd__buf_2
Xoutput137 net137 vssd1 vssd1 vccd1 vccd1 CBeast_out[12] sky130_fd_sc_hd__buf_2
XFILLER_142_787 vssd1 vssd1 vccd1 vccd1 sky130_fd_sc_hd__fill_1
XFILLER_99_167 vssd1 vssd1 vccd1 vccd1 sky130_fd_sc_hd__fill_1
X_07951_ _01575_ _02991_ _02994_ _02988_ vssd1 vssd1 vccd1 vccd1 _02995_ sky130_fd_sc_hd__a211oi_1
XFILLER_142_798 vssd1 vssd1 vccd1 vccd1 sky130_fd_sc_hd__fill_2
XTAP_TAPCELL_ROW_110_1957 vssd1 vccd1 sky130_fd_sc_hd__tapvpwrvgnd_1
X_06902_ cell1.CB_0.config_dataA\[24\] cell1.CB_0.config_dataA\[21\] cell1.CB_0.config_dataA\[20\]
+ vssd1 vssd1 vccd1 vccd1 _01970_ sky130_fd_sc_hd__nand3b_1
X_07882_ _02919_ _02922_ _02924_ _02925_ vssd1 vssd1 vccd1 vccd1 _02926_ sky130_fd_sc_hd__o22a_1
XANTENNA_clkbuf_leaf_86_clk_A clknet_4_11_0_clk vssd1 vssd1 vccd1 vccd1 sky130_fd_sc_hd__diode_2
X_06833_ _01900_ _01901_ vssd1 vssd1 vccd1 vccd1 _01902_ sky130_fd_sc_hd__nor2_1
X_09621_ _02370_ _04635_ _04636_ vssd1 vssd1 vccd1 vccd1 _04637_ sky130_fd_sc_hd__a21oi_1
XTAP_TAPCELL_ROW_52_1086 vssd1 vccd1 sky130_fd_sc_hd__tapvpwrvgnd_1
XANTENNA__10330__A _05111_ vssd1 vssd1 vccd1 vccd1 sky130_fd_sc_hd__diode_2
X_09552_ _04267_ _04545_ vssd1 vssd1 vccd1 vccd1 _04571_ sky130_fd_sc_hd__nor2_1
XFILLER_95_395 vssd1 vssd1 vccd1 vccd1 sky130_fd_sc_hd__fill_2
X_06764_ bus2_0\[11\] vssd1 vssd1 vccd1 vccd1 _01834_ sky130_fd_sc_hd__inv_2
XPHY_EDGE_ROW_90_Left_233 vssd1 vssd1 vccd1 vccd1 sky130_fd_sc_hd__decap_3
XFILLER_71_719 vssd1 vssd1 vccd1 vccd1 sky130_fd_sc_hd__fill_1
X_08503_ cell1.SB0.route_sel\[37\] cell1.SB0.route_sel\[36\] _01514_ cell1.SB0.route_sel\[39\]
+ _03538_ vssd1 vssd1 vccd1 vccd1 _03539_ sky130_fd_sc_hd__o221a_1
XANTENNA__12956__S net756 vssd1 vssd1 vccd1 vccd1 sky130_fd_sc_hd__diode_2
X_06695_ cell2.CB_0.config_dataA\[3\] vssd1 vssd1 vccd1 vccd1 _01765_ sky130_fd_sc_hd__inv_2
XFILLER_70_229 vssd1 vssd1 vccd1 vccd1 sky130_fd_sc_hd__fill_1
XANTENNA__11860__S net897 vssd1 vssd1 vccd1 vccd1 sky130_fd_sc_hd__diode_2
X_09483_ net328 _01971_ _01976_ _04503_ _04500_ vssd1 vssd1 vccd1 vccd1 _04504_ sky130_fd_sc_hd__o221ai_4
X_08434_ net497 _03465_ _03469_ net496 vssd1 vssd1 vccd1 vccd1 _03470_ sky130_fd_sc_hd__o211a_1
XANTENNA_clkbuf_leaf_24_clk_A clknet_4_4_0_clk vssd1 vssd1 vccd1 vccd1 sky130_fd_sc_hd__diode_2
X_08365_ cell0.CB_1.config_dataB\[13\] cell0.CB_1.config_dataB\[12\] vssd1 vssd1 vccd1
+ vccd1 _03403_ sky130_fd_sc_hd__nor2_1
XFILLER_23_178 vssd1 vssd1 vccd1 vccd1 sky130_fd_sc_hd__fill_4
XFILLER_134_9 vccd1 vssd1 vccd1 vssd1 sky130_ef_sc_hd__decap_40_12
XANTENNA__08454__B _03489_ vssd1 vssd1 vccd1 vccd1 sky130_fd_sc_hd__diode_2
X_07316_ cell1.SB0.route_sel\[97\] cell1.SB0.route_sel\[96\] vssd1 vssd1 vccd1 vccd1
+ _02374_ sky130_fd_sc_hd__nor2_1
X_08296_ bus1_0\[5\] _03315_ _03316_ bus1_0\[4\] cell0.CB_1.config_dataB\[8\] vssd1
+ vssd1 vccd1 vccd1 _03334_ sky130_fd_sc_hd__a221o_1
XANTENNA_fanout308_X net308 vssd1 vssd1 vccd1 vccd1 sky130_fd_sc_hd__diode_2
XANTENNA__12691__S net944 vssd1 vssd1 vccd1 vccd1 sky130_fd_sc_hd__diode_2
X_07247_ cell2.SB0.route_sel\[94\] cell2.SB0.route_sel\[95\] _02305_ vssd1 vssd1 vccd1
+ vccd1 _02306_ sky130_fd_sc_hd__a21bo_1
Xclkbuf_4_2_0_clk clknet_0_clk vssd1 vssd1 vccd1 vccd1 clknet_4_2_0_clk sky130_fd_sc_hd__clkbuf_8
XANTENNA__10358__A1 net62 vssd1 vssd1 vccd1 vccd1 sky130_fd_sc_hd__diode_2
XANTENNA_clkbuf_leaf_39_clk_A clknet_4_7_0_clk vssd1 vssd1 vccd1 vccd1 sky130_fd_sc_hd__diode_2
X_07178_ _01631_ _01632_ net115 cell2.SB0.route_sel\[84\] cell2.SB0.route_sel\[85\]
+ vssd1 vssd1 vccd1 vccd1 _02239_ sky130_fd_sc_hd__o2111a_1
XFILLER_87_27 vccd1 vssd1 vccd1 vssd1 sky130_ef_sc_hd__decap_40_12
XFILLER_78_318 vssd1 vssd1 vccd1 vccd1 sky130_fd_sc_hd__fill_1
XFILLER_78_307 vssd1 vssd1 vccd1 vccd1 sky130_fd_sc_hd__fill_1
Xfanout331 net332 vssd1 vssd1 vccd1 vccd1 net331 sky130_fd_sc_hd__clkbuf_2
Xfanout320 net322 vssd1 vssd1 vccd1 vccd1 net320 sky130_fd_sc_hd__clkbuf_2
Xfanout375 cell3.CB_0.config_dataA\[10\] vssd1 vssd1 vccd1 vccd1 net375 sky130_fd_sc_hd__buf_2
Xfanout364 cell3.CB_1.config_dataB\[16\] vssd1 vssd1 vccd1 vccd1 net364 sky130_fd_sc_hd__clkbuf_2
Xfanout342 _01827_ vssd1 vssd1 vccd1 vccd1 net342 sky130_fd_sc_hd__buf_2
Xfanout353 _02609_ vssd1 vssd1 vccd1 vccd1 net353 sky130_fd_sc_hd__buf_2
Xfanout386 cell3.CB_0.config_dataB\[6\] vssd1 vssd1 vccd1 vccd1 net386 sky130_fd_sc_hd__clkbuf_2
XPHY_EDGE_ROW_129_Left_272 vssd1 vssd1 vccd1 vccd1 sky130_fd_sc_hd__decap_3
X_09819_ net313 net308 cell2.LEI0.config_data\[6\] vssd1 vssd1 vccd1 vccd1 _04825_
+ sky130_fd_sc_hd__mux2_1
Xfanout397 cell3.CB_1.config_dataA\[1\] vssd1 vssd1 vccd1 vccd1 net397 sky130_fd_sc_hd__dlymetal6s2s_1
XFILLER_100_161 vccd1 vssd1 vccd1 vssd1 sky130_ef_sc_hd__decap_40_12
XTAP_TAPCELL_ROW_6_399 vssd1 vccd1 sky130_fd_sc_hd__tapvpwrvgnd_1
XFILLER_19_407 vssd1 vssd1 vccd1 vccd1 sky130_fd_sc_hd__fill_1
XANTENNA__13027__S net756 vssd1 vssd1 vccd1 vccd1 sky130_fd_sc_hd__diode_2
XFILLER_100_194 vssd1 vssd1 vccd1 vccd1 sky130_fd_sc_hd__fill_2
X_12830_ cell2.SB0.route_sel\[72\] cell2.SB0.route_sel\[71\] net815 vssd1 vssd1 vccd1
+ vccd1 _01259_ sky130_fd_sc_hd__mux2_1
XANTENNA_input122_A SBwest_in[3] vssd1 vssd1 vccd1 vccd1 sky130_fd_sc_hd__diode_2
XFILLER_27_451 vssd1 vssd1 vccd1 vccd1 sky130_fd_sc_hd__fill_2
XFILLER_27_462 vssd1 vssd1 vccd1 vccd1 sky130_fd_sc_hd__fill_8
XFILLER_36_53 vccd1 vssd1 vccd1 vssd1 sky130_ef_sc_hd__decap_40_12
XANTENNA__10294__A0 net33 vssd1 vssd1 vccd1 vccd1 sky130_fd_sc_hd__diode_2
X_12761_ cell2.SB0.route_sel\[3\] cell2.SB0.route_sel\[2\] net795 vssd1 vssd1 vccd1
+ vccd1 _01190_ sky130_fd_sc_hd__mux2_1
XFILLER_27_473 vssd1 vssd1 vccd1 vccd1 sky130_fd_sc_hd__fill_1
X_12692_ cell3.CB_1.config_dataA\[9\] cell3.CB_1.config_dataA\[8\] net947 vssd1 vssd1
+ vccd1 vccd1 _01121_ sky130_fd_sc_hd__mux2_1
XTAP_TAPCELL_ROW_83_1558 vssd1 vccd1 sky130_fd_sc_hd__tapvpwrvgnd_1
XTAP_TAPCELL_ROW_83_1547 vssd1 vccd1 sky130_fd_sc_hd__tapvpwrvgnd_1
X_11712_ net1285 net1210 net805 vssd1 vssd1 vccd1 vccd1 _00151_ sky130_fd_sc_hd__mux2_1
XFILLER_42_454 vssd1 vssd1 vccd1 vccd1 sky130_fd_sc_hd__fill_1
XANTENNA__08645__A net458 vssd1 vssd1 vccd1 vccd1 sky130_fd_sc_hd__diode_2
XFILLER_15_668 vssd1 vssd1 vccd1 vccd1 sky130_fd_sc_hd__fill_4
X_14431_ clknet_leaf_55_clk _01403_ net719 vssd1 vssd1 vccd1 vccd1 cell3.LE_0A.reset_val
+ sky130_fd_sc_hd__dfrtp_2
XANTENNA__10894__B net262 vssd1 vssd1 vccd1 vccd1 sky130_fd_sc_hd__diode_2
X_11643_ cell0.CB_0.config_dataA\[14\] cell0.CB_0.config_dataA\[13\] net772 vssd1
+ vssd1 vccd1 vccd1 _00084_ sky130_fd_sc_hd__mux2_1
XTAP_TAPCELL_ROW_25_685 vssd1 vccd1 sky130_fd_sc_hd__tapvpwrvgnd_1
XANTENNA__08239__A0 bus1_0\[8\] vssd1 vssd1 vccd1 vccd1 sky130_fd_sc_hd__diode_2
XFILLER_52_85 vssd1 vssd1 vccd1 vccd1 sky130_fd_sc_hd__fill_1
XPHY_EDGE_ROW_138_Left_281 vssd1 vssd1 vccd1 vccd1 sky130_fd_sc_hd__decap_3
Xinput17 CBeast_in[24] vssd1 vssd1 vccd1 vccd1 net17 sky130_fd_sc_hd__clkbuf_4
Xinput28 CBeast_in[5] vssd1 vssd1 vccd1 vccd1 net28 sky130_fd_sc_hd__clkbuf_4
X_14362_ clknet_leaf_72_clk _01334_ net728 vssd1 vssd1 vccd1 vccd1 cell3.CB_1.config_dataB\[19\]
+ sky130_fd_sc_hd__dfstp_1
X_11574_ net1318 cell0.LE_1B.config_data\[14\] net800 vssd1 vssd1 vccd1 vccd1 _00015_
+ sky130_fd_sc_hd__mux2_1
Xinput39 CBnorth_in[15] vssd1 vssd1 vccd1 vccd1 net39 sky130_fd_sc_hd__buf_2
XTAP_TAPCELL_ROW_114_2013 vssd1 vccd1 sky130_fd_sc_hd__tapvpwrvgnd_1
X_10525_ net275 _05482_ vssd1 vssd1 vccd1 vccd1 _05483_ sky130_fd_sc_hd__and2_2
X_13313_ clknet_leaf_88_clk _00285_ net690 vssd1 vssd1 vccd1 vccd1 cell1.CB_0.config_dataB\[4\]
+ sky130_fd_sc_hd__dfstp_1
X_14293_ clknet_leaf_8_clk _01265_ net588 vssd1 vssd1 vccd1 vccd1 cell2.SB0.route_sel\[78\]
+ sky130_fd_sc_hd__dfstp_1
XTAP_TAPCELL_ROW_114_2024 vssd1 vccd1 sky130_fd_sc_hd__tapvpwrvgnd_1
X_10456_ _05444_ _04576_ vssd1 vssd1 vccd1 vccd1 bus3_2\[9\] sky130_fd_sc_hd__and2b_2
X_13244_ clknet_leaf_11_clk net1329 net586 vssd1 vssd1 vccd1 vccd1 cell0.LEI0.config_data\[29\]
+ sky130_fd_sc_hd__dfrtp_1
XANTENNA_output174_A net174 vssd1 vssd1 vccd1 vccd1 sky130_fd_sc_hd__diode_2
X_13175_ clknet_leaf_118_clk net1243 net599 vssd1 vssd1 vccd1 vccd1 cell0.LE_0B.config_data\[4\]
+ sky130_fd_sc_hd__dfrtp_1
X_10387_ net424 net423 vssd1 vssd1 vccd1 vccd1 _05386_ sky130_fd_sc_hd__nor2_1
X_12126_ net1360 net1354 net899 vssd1 vssd1 vccd1 vccd1 _00559_ sky130_fd_sc_hd__mux2_1
XFILLER_78_830 vssd1 vssd1 vccd1 vccd1 sky130_fd_sc_hd__fill_1
X_12057_ cell1.LE_1A.config_data\[8\] net1115 net889 vssd1 vssd1 vccd1 vccd1 _00493_
+ sky130_fd_sc_hd__mux2_1
X_11008_ _05847_ _05851_ net375 vssd1 vssd1 vccd1 vccd1 _05962_ sky130_fd_sc_hd__mux2_1
XANTENNA__08714__A1 _03540_ vssd1 vssd1 vccd1 vccd1 sky130_fd_sc_hd__diode_2
XANTENNA__08714__B2 _03537_ vssd1 vssd1 vccd1 vccd1 sky130_fd_sc_hd__diode_2
XANTENNA__10521__A1 _05478_ vssd1 vssd1 vccd1 vccd1 sky130_fd_sc_hd__diode_2
XTAP_TAPCELL_ROW_125_2186 vssd1 vccd1 sky130_fd_sc_hd__tapvpwrvgnd_1
XFILLER_92_365 vssd1 vssd1 vccd1 vccd1 sky130_fd_sc_hd__fill_1
X_12959_ net1216 cell3.LE_0A.config_data\[1\] net927 vssd1 vssd1 vccd1 vccd1 _01387_
+ sky130_fd_sc_hd__mux2_1
XFILLER_45_281 vssd1 vssd1 vccd1 vccd1 sky130_fd_sc_hd__fill_4
XANTENNA__10824__A2 net19 vssd1 vssd1 vccd1 vccd1 sky130_fd_sc_hd__diode_2
X_06480_ cell1.SB0.route_sel\[121\] vssd1 vssd1 vccd1 vccd1 _01550_ sky130_fd_sc_hd__inv_2
XFILLER_61_785 vssd1 vssd1 vccd1 vccd1 sky130_fd_sc_hd__fill_1
XTAP_TAPCELL_ROW_44_972 vssd1 vccd1 sky130_fd_sc_hd__tapvpwrvgnd_1
XTAP_TAPCELL_ROW_44_961 vssd1 vccd1 sky130_fd_sc_hd__tapvpwrvgnd_1
X_08150_ net546 _02761_ vssd1 vssd1 vccd1 vccd1 _03190_ sky130_fd_sc_hd__nand2_1
X_07101_ cell2.CB_1.config_dataB\[24\] cell2.CB_1.config_dataB\[21\] cell2.CB_1.config_dataB\[20\]
+ vssd1 vssd1 vccd1 vccd1 _02164_ sky130_fd_sc_hd__or3b_2
X_08081_ net524 _01986_ vssd1 vssd1 vccd1 vccd1 _03123_ sky130_fd_sc_hd__nand2_1
XFILLER_9_182 vssd1 vssd1 vccd1 vccd1 sky130_fd_sc_hd__fill_4
X_07032_ cell2.CB_0.config_dataB\[22\] cell2.CB_0.config_dataB\[23\] vssd1 vssd1 vccd1
+ vccd1 _02097_ sky130_fd_sc_hd__nand2b_1
XFILLER_115_787 vssd1 vssd1 vccd1 vccd1 sky130_fd_sc_hd__fill_1
XFILLER_114_253 vssd1 vssd1 vccd1 vccd1 sky130_fd_sc_hd__fill_1
XTAP_TAPCELL_ROW_54_1115 vssd1 vccd1 sky130_fd_sc_hd__tapvpwrvgnd_1
XFILLER_114_286 vssd1 vssd1 vccd1 vccd1 sky130_fd_sc_hd__fill_1
XANTENNA__10760__A1 _05513_ vssd1 vssd1 vccd1 vccd1 sky130_fd_sc_hd__diode_2
X_08983_ cell1.LE_0A.config_data\[11\] cell1.LE_0A.config_data\[10\] _03936_ vssd1
+ vssd1 vccd1 vccd1 _04015_ sky130_fd_sc_hd__mux2_1
XFILLER_87_148 vssd1 vssd1 vccd1 vccd1 sky130_fd_sc_hd__fill_1
XANTENNA__11855__S net897 vssd1 vssd1 vccd1 vccd1 sky130_fd_sc_hd__diode_2
X_07934_ cell0.CB_0.config_dataA\[14\] _02952_ _02958_ _02975_ _02977_ vssd1 vssd1
+ vccd1 vccd1 _02978_ sky130_fd_sc_hd__a311o_1
X_07865_ bus2_0\[6\] bus2_0\[7\] net518 vssd1 vssd1 vccd1 vccd1 _02909_ sky130_fd_sc_hd__mux2_1
XANTENNA__08705__A1 net12 vssd1 vssd1 vccd1 vccd1 sky130_fd_sc_hd__diode_2
XFILLER_29_716 vssd1 vssd1 vccd1 vccd1 sky130_fd_sc_hd__fill_1
X_09604_ net287 net20 _04620_ vssd1 vssd1 vccd1 vccd1 _04621_ sky130_fd_sc_hd__mux2_1
XTAP_TAPCELL_ROW_3_358 vssd1 vccd1 sky130_fd_sc_hd__tapvpwrvgnd_1
XTAP_TAPCELL_ROW_3_347 vssd1 vccd1 sky130_fd_sc_hd__tapvpwrvgnd_1
XANTENNA__08181__A2 bus1_0\[14\] vssd1 vssd1 vccd1 vccd1 sky130_fd_sc_hd__diode_2
XANTENNA__10512__A1 net337 vssd1 vssd1 vccd1 vccd1 sky130_fd_sc_hd__diode_2
X_06816_ _01884_ _01885_ vssd1 vssd1 vccd1 vccd1 _01886_ sky130_fd_sc_hd__nor2_1
X_07796_ cell0.SB0.route_sel\[41\] cell0.SB0.route_sel\[40\] _02840_ vssd1 vssd1 vccd1
+ vccd1 _02841_ sky130_fd_sc_hd__a21oi_1
X_09535_ cell2.SB0.route_sel\[79\] _01627_ _04553_ vssd1 vssd1 vccd1 vccd1 _04554_
+ sky130_fd_sc_hd__o21ai_2
X_06747_ cell0.SB0.route_sel\[16\] vssd1 vssd1 vccd1 vccd1 _01817_ sky130_fd_sc_hd__inv_2
XANTENNA_fanout637_A net640 vssd1 vssd1 vccd1 vccd1 sky130_fd_sc_hd__diode_2
X_09466_ _01825_ _04485_ _04487_ vssd1 vssd1 vccd1 vccd1 _04488_ sky130_fd_sc_hd__a21oi_1
X_06678_ cell3.SB0.route_sel\[123\] vssd1 vssd1 vccd1 vccd1 _01748_ sky130_fd_sc_hd__inv_2
XANTENNA__11590__S net790 vssd1 vssd1 vccd1 vccd1 sky130_fd_sc_hd__diode_2
XTAP_TAPCELL_ROW_65_1288 vssd1 vccd1 sky130_fd_sc_hd__tapvpwrvgnd_1
XTAP_TAPCELL_ROW_65_1277 vssd1 vccd1 sky130_fd_sc_hd__tapvpwrvgnd_1
X_08417_ cell0.LE_1B.config_data\[9\] cell0.LE_1B.config_data\[8\] _03380_ vssd1 vssd1
+ vccd1 vccd1 _03455_ sky130_fd_sc_hd__mux2_1
X_09397_ cell3.SB0.route_sel\[32\] _01698_ cell3.SB0.route_sel\[35\] _01700_ _04420_
+ vssd1 vssd1 vccd1 vccd1 _04421_ sky130_fd_sc_hd__a221o_1
XTAP_TAPCELL_ROW_22_633 vssd1 vccd1 sky130_fd_sc_hd__tapvpwrvgnd_1
XTAP_TAPCELL_ROW_22_644 vssd1 vccd1 sky130_fd_sc_hd__tapvpwrvgnd_1
XFILLER_138_813 vccd1 vssd1 vccd1 vssd1 sky130_ef_sc_hd__decap_40_12
X_08348_ net504 cell0.CB_1.config_dataB\[11\] vssd1 vssd1 vccd1 vccd1 _03386_ sky130_fd_sc_hd__nor2_1
XFILLER_22_11 vccd1 vssd1 vccd1 vssd1 sky130_ef_sc_hd__decap_40_12
X_08279_ net505 net506 vssd1 vssd1 vccd1 vccd1 _03317_ sky130_fd_sc_hd__or2_1
XFILLER_138_77 vssd1 vssd1 vccd1 vccd1 sky130_fd_sc_hd__fill_4
X_10310_ _01756_ _01757_ cell2.CB_0.config_dataB\[9\] _05282_ _05308_ vssd1 vssd1
+ vccd1 vccd1 _05309_ sky130_fd_sc_hd__a41o_1
X_11290_ net647 cell2.LE_0B.reset_mode vssd1 vssd1 vccd1 vccd1 _11290_/X sky130_fd_sc_hd__xor2_2
XANTENNA__07995__A2 bus2_0\[10\] vssd1 vssd1 vccd1 vccd1 sky130_fd_sc_hd__diode_2
XANTENNA__07809__A net28 vssd1 vssd1 vccd1 vccd1 sky130_fd_sc_hd__diode_2
XANTENNA__07368__X _02424_ vssd1 vssd1 vccd1 vccd1 sky130_fd_sc_hd__diode_2
X_10241_ _05136_ _05235_ _05240_ _05241_ vssd1 vssd1 vccd1 vccd1 _05242_ sky130_fd_sc_hd__a211o_1
XFILLER_106_721 vssd1 vssd1 vccd1 vccd1 sky130_fd_sc_hd__fill_1
X_10172_ _05152_ _05167_ _05168_ _05156_ cell2.CB_0.config_dataA\[2\] vssd1 vssd1
+ vccd1 vccd1 _05173_ sky130_fd_sc_hd__a221o_1
XFILLER_121_746 vssd1 vssd1 vccd1 vccd1 sky130_fd_sc_hd__fill_1
X_13931_ clknet_leaf_25_clk net1077 net609 vssd1 vssd1 vccd1 vccd1 cell2.LE_0A.config_data\[10\]
+ sky130_fd_sc_hd__dfrtp_1
XANTENNA__07544__A net314 vssd1 vssd1 vccd1 vccd1 sky130_fd_sc_hd__diode_2
XFILLER_87_671 vssd1 vssd1 vccd1 vccd1 sky130_fd_sc_hd__fill_1
XANTENNA__11066__A _05924_ vssd1 vssd1 vccd1 vccd1 sky130_fd_sc_hd__diode_2
X_13862_ clknet_leaf_43_clk _00834_ net628 vssd1 vssd1 vccd1 vccd1 cell2.CB_1.config_dataB\[11\]
+ sky130_fd_sc_hd__dfstp_1
XANTENNA__11059__A2 net42 vssd1 vssd1 vccd1 vccd1 sky130_fd_sc_hd__diode_2
X_12813_ cell2.SB0.route_sel\[55\] cell2.SB0.route_sel\[54\] net811 vssd1 vssd1 vccd1
+ vccd1 _01242_ sky130_fd_sc_hd__mux2_1
X_13793_ clknet_leaf_105_clk _00765_ net662 vssd1 vssd1 vccd1 vccd1 cell1.SB0.route_sel\[70\]
+ sky130_fd_sc_hd__dfstp_1
X_12744_ net374 net375 net927 vssd1 vssd1 vccd1 vccd1 _01173_ sky130_fd_sc_hd__mux2_1
XFILLER_27_281 vssd1 vssd1 vccd1 vccd1 sky130_fd_sc_hd__fill_1
XANTENNA__07132__B1 bus1_0\[10\] vssd1 vssd1 vccd1 vccd1 sky130_fd_sc_hd__diode_2
XANTENNA__11513__B _02106_ vssd1 vssd1 vccd1 vccd1 sky130_fd_sc_hd__diode_2
X_12675_ net1165 net1229 net955 vssd1 vssd1 vccd1 vccd1 _01104_ sky130_fd_sc_hd__mux2_1
XTAP_TAPCELL_ROW_41_920 vssd1 vccd1 sky130_fd_sc_hd__tapvpwrvgnd_1
X_14414_ clknet_leaf_39_clk net1234 net717 vssd1 vssd1 vccd1 vccd1 cell3.LE_0A.config_data\[1\]
+ sky130_fd_sc_hd__dfrtp_1
X_11626_ cell0.CB_0.config_dataB\[22\] cell0.CB_0.config_dataB\[21\] net777 vssd1
+ vssd1 vccd1 vccd1 _00067_ sky130_fd_sc_hd__mux2_1
XANTENNA_input90_X net90 vssd1 vssd1 vccd1 vccd1 sky130_fd_sc_hd__diode_2
X_14345_ clknet_leaf_76_clk _01317_ net732 vssd1 vssd1 vccd1 vccd1 cell3.CB_1.config_dataB\[2\]
+ sky130_fd_sc_hd__dfstp_1
XANTENNA__08632__B1 net352 vssd1 vssd1 vccd1 vccd1 sky130_fd_sc_hd__diode_2
X_11557_ cell0.SB0.route_sel\[27\] _01597_ cell0.SB0.route_sel\[25\] cell0.SB0.route_sel\[24\]
+ _06371_ vssd1 vssd1 vccd1 vccd1 _06372_ sky130_fd_sc_hd__o221a_1
XTAP_TAPCELL_ROW_96_1749 vssd1 vccd1 sky130_fd_sc_hd__tapvpwrvgnd_1
XFILLER_7_653 vccd1 vssd1 vccd1 vssd1 sky130_ef_sc_hd__decap_40_12
XFILLER_6_141 vssd1 vssd1 vccd1 vccd1 sky130_fd_sc_hd__fill_1
X_10508_ net335 _02359_ _05469_ vssd1 vssd1 vccd1 vccd1 net137 sky130_fd_sc_hd__a21o_1
X_14276_ clknet_leaf_22_clk _01248_ net604 vssd1 vssd1 vccd1 vccd1 cell2.SB0.route_sel\[61\]
+ sky130_fd_sc_hd__dfstp_1
XANTENNA__06623__A cell3.SB0.route_sel\[21\] vssd1 vssd1 vccd1 vccd1 sky130_fd_sc_hd__diode_2
X_11488_ cell2.SB0.route_sel\[0\] cell2.SB0.route_sel\[1\] cell2.SB0.route_sel\[3\]
+ _01565_ _06325_ vssd1 vssd1 vccd1 vccd1 _06326_ sky130_fd_sc_hd__o221a_1
XFILLER_7_697 vccd1 vssd1 vccd1 vssd1 sky130_ef_sc_hd__decap_40_12
X_10439_ cell3.SB0.route_sel\[32\] cell3.SB0.route_sel\[33\] vssd1 vssd1 vccd1 vccd1
+ _05433_ sky130_fd_sc_hd__nor2_1
X_13227_ clknet_leaf_10_clk _00199_ net569 vssd1 vssd1 vccd1 vccd1 cell0.LEI0.config_data\[12\]
+ sky130_fd_sc_hd__dfrtp_1
X_13158_ clknet_leaf_115_clk _00130_ net665 vssd1 vssd1 vccd1 vccd1 cell0.LE_1A.config_data\[9\]
+ sky130_fd_sc_hd__dfrtp_1
XANTENNA__13229__Q cell0.LEI0.config_data\[14\] vssd1 vssd1 vccd1 vccd1 sky130_fd_sc_hd__diode_2
XFILLER_88_92 vssd1 vssd1 vccd1 vccd1 sky130_fd_sc_hd__fill_1
XANTENNA__10432__X bus3_2\[1\] vssd1 vssd1 vccd1 vccd1 sky130_fd_sc_hd__diode_2
X_12109_ net1102 net1037 net878 vssd1 vssd1 vccd1 vccd1 _00543_ sky130_fd_sc_hd__mux2_1
X_13089_ clknet_leaf_3_clk _00061_ net571 vssd1 vssd1 vccd1 vccd1 cell0.CB_0.config_dataB\[16\]
+ sky130_fd_sc_hd__dfstp_1
XTAP_TAPCELL_ROW_127_2215 vssd1 vccd1 sky130_fd_sc_hd__tapvpwrvgnd_1
XTAP_TAPCELL_ROW_140_2415 vssd1 vccd1 sky130_fd_sc_hd__tapvpwrvgnd_1
XTAP_TAPCELL_ROW_140_2404 vssd1 vccd1 sky130_fd_sc_hd__tapvpwrvgnd_1
X_07650_ cell1.SB0.route_sel\[12\] cell1.SB0.route_sel\[13\] vssd1 vssd1 vccd1 vccd1
+ _02699_ sky130_fd_sc_hd__nand2b_1
XTAP_TAPCELL_ROW_0_306 vssd1 vccd1 sky130_fd_sc_hd__tapvpwrvgnd_1
X_06601_ cell1.CB_0.config_dataB\[12\] vssd1 vssd1 vccd1 vccd1 _01671_ sky130_fd_sc_hd__inv_2
X_07581_ cell0.SB0.route_sel\[7\] cell0.SB0.route_sel\[6\] vssd1 vssd1 vccd1 vccd1
+ _02631_ sky130_fd_sc_hd__nand2b_1
XANTENNA__10258__A0 net36 vssd1 vssd1 vccd1 vccd1 sky130_fd_sc_hd__diode_2
X_06532_ cell2.SB0.route_sel\[36\] vssd1 vssd1 vccd1 vccd1 _01602_ sky130_fd_sc_hd__inv_2
XFILLER_92_195 vssd1 vssd1 vccd1 vccd1 sky130_fd_sc_hd__fill_1
X_09320_ _04335_ _04336_ _04338_ _04344_ net551 vssd1 vssd1 vccd1 vccd1 _04345_ sky130_fd_sc_hd__o311a_2
XANTENNA__09112__A1 _03894_ vssd1 vssd1 vccd1 vccd1 sky130_fd_sc_hd__diode_2
XANTENNA__09112__B2 _03890_ vssd1 vssd1 vccd1 vccd1 sky130_fd_sc_hd__diode_2
XFILLER_18_292 vssd1 vssd1 vccd1 vccd1 sky130_fd_sc_hd__fill_1
XTAP_TAPCELL_ROW_105_1889 vssd1 vccd1 sky130_fd_sc_hd__tapvpwrvgnd_1
XTAP_TAPCELL_ROW_105_1878 vssd1 vccd1 sky130_fd_sc_hd__tapvpwrvgnd_1
X_09251_ cell3.SB0.route_sel\[21\] cell3.SB0.route_sel\[20\] vssd1 vssd1 vccd1 vccd1
+ _04277_ sky130_fd_sc_hd__nand2_1
XFILLER_34_785 vssd1 vssd1 vccd1 vccd1 sky130_fd_sc_hd__fill_1
XANTENNA__11423__B _06282_ vssd1 vssd1 vccd1 vccd1 sky130_fd_sc_hd__diode_2
X_08202_ bus1_0\[8\] bus1_0\[9\] bus1_0\[10\] bus1_0\[11\] net539 cell0.CB_1.config_dataA\[11\]
+ vssd1 vssd1 vccd1 vccd1 _03242_ sky130_fd_sc_hd__mux4_1
X_06463_ cell1.SB0.route_sel\[82\] vssd1 vssd1 vccd1 vccd1 _01533_ sky130_fd_sc_hd__inv_2
XFILLER_138_109 vssd1 vssd1 vccd1 vccd1 sky130_fd_sc_hd__fill_2
X_09182_ cell3.CB_1.config_dataB\[24\] cell3.CB_1.config_dataB\[20\] cell3.CB_1.config_dataB\[21\]
+ vssd1 vssd1 vccd1 vccd1 _04210_ sky130_fd_sc_hd__or3_2
X_06394_ cell0.SB0.route_sel\[63\] vssd1 vssd1 vccd1 vccd1 _01464_ sky130_fd_sc_hd__inv_2
XTAP_TAPCELL_ROW_138_2377 vssd1 vccd1 sky130_fd_sc_hd__tapvpwrvgnd_1
X_08133_ bus1_0\[8\] bus1_0\[9\] bus1_0\[10\] bus1_0\[11\] net547 net545 vssd1 vssd1
+ vccd1 vccd1 _03173_ sky130_fd_sc_hd__mux4_1
X_08064_ net527 _01986_ vssd1 vssd1 vccd1 vccd1 _03106_ sky130_fd_sc_hd__nand2_1
XANTENNA__07629__A _02675_ vssd1 vssd1 vccd1 vccd1 sky130_fd_sc_hd__diode_2
XANTENNA__06804__Y _01874_ vssd1 vssd1 vccd1 vccd1 sky130_fd_sc_hd__diode_2
XFILLER_108_25 vssd1 vssd1 vccd1 vccd1 sky130_fd_sc_hd__fill_2
X_07015_ cell2.SB0.route_sel\[64\] cell2.SB0.route_sel\[65\] vssd1 vssd1 vccd1 vccd1
+ _02080_ sky130_fd_sc_hd__nand2_2
XFILLER_108_69 vssd1 vssd1 vccd1 vccd1 sky130_fd_sc_hd__fill_1
XTAP_TAPCELL_ROW_8_428 vssd1 vccd1 sky130_fd_sc_hd__tapvpwrvgnd_1
XFILLER_1_807 vccd1 vssd1 vccd1 vssd1 sky130_ef_sc_hd__decap_40_12
XFILLER_68_29 vssd1 vssd1 vccd1 vccd1 sky130_fd_sc_hd__fill_1
XANTENNA__08926__A1 bus3_1\[9\] vssd1 vssd1 vccd1 vccd1 sky130_fd_sc_hd__diode_2
XFILLER_0_328 vssd1 vssd1 vccd1 vccd1 sky130_fd_sc_hd__fill_8
XANTENNA_fanout587_A net592 vssd1 vssd1 vccd1 vccd1 sky130_fd_sc_hd__diode_2
XFILLER_130_587 vssd1 vssd1 vccd1 vccd1 sky130_fd_sc_hd__fill_1
XFILLER_102_256 vssd1 vssd1 vccd1 vccd1 sky130_fd_sc_hd__fill_1
XFILLER_69_671 vssd1 vssd1 vccd1 vccd1 sky130_fd_sc_hd__fill_1
X_08966_ cell1.CB_0.config_dataA\[18\] _03991_ _03993_ _03997_ vssd1 vssd1 vccd1 vccd1
+ _03998_ sky130_fd_sc_hd__and4_1
XFILLER_29_513 vssd1 vssd1 vccd1 vccd1 sky130_fd_sc_hd__fill_2
X_07917_ bus2_0\[4\] _02951_ _02952_ bus2_0\[5\] cell0.CB_0.config_dataA\[13\] vssd1
+ vssd1 vccd1 vccd1 _02961_ sky130_fd_sc_hd__a221o_1
X_08897_ net473 _03885_ vssd1 vssd1 vccd1 vccd1 _03929_ sky130_fd_sc_hd__or2_1
XANTENNA_fanout754_A net132 vssd1 vssd1 vccd1 vccd1 sky130_fd_sc_hd__diode_2
Xclkbuf_leaf_95_clk clknet_4_11_0_clk vssd1 vssd1 vccd1 vccd1 clknet_leaf_95_clk sky130_fd_sc_hd__clkbuf_8
XTAP_TAPCELL_ROW_67_1306 vssd1 vccd1 sky130_fd_sc_hd__tapvpwrvgnd_1
X_07848_ cell0.SB0.route_sel\[19\] cell0.SB0.route_sel\[18\] vssd1 vssd1 vccd1 vccd1
+ _02892_ sky130_fd_sc_hd__nor2_1
XFILLER_29_568 vssd1 vssd1 vccd1 vccd1 sky130_fd_sc_hd__fill_2
XFILLER_84_696 vssd1 vssd1 vccd1 vccd1 sky130_fd_sc_hd__fill_2
XFILLER_72_847 vssd1 vssd1 vccd1 vccd1 sky130_fd_sc_hd__fill_1
XTAP_TAPCELL_ROW_67_1317 vssd1 vccd1 sky130_fd_sc_hd__tapvpwrvgnd_1
XFILLER_16_229 vssd1 vssd1 vccd1 vccd1 sky130_fd_sc_hd__fill_1
XFILLER_17_55 vssd1 vssd1 vccd1 vccd1 sky130_fd_sc_hd__fill_1
XTAP_TAPCELL_ROW_27_714 vssd1 vccd1 sky130_fd_sc_hd__tapvpwrvgnd_1
X_09518_ _04207_ _04537_ vssd1 vssd1 vccd1 vccd1 _04538_ sky130_fd_sc_hd__nor2_1
X_07779_ net339 net360 _02110_ _02109_ _01849_ vssd1 vssd1 vccd1 vccd1 _02824_ sky130_fd_sc_hd__o32a_1
XANTENNA__08907__B _03885_ vssd1 vssd1 vccd1 vccd1 sky130_fd_sc_hd__diode_2
X_10790_ _01779_ _05741_ _05742_ _05745_ vssd1 vssd1 vccd1 vccd1 _05746_ sky130_fd_sc_hd__a22o_1
XTAP_TAPCELL_ROW_80_1506 vssd1 vccd1 sky130_fd_sc_hd__tapvpwrvgnd_1
X_09449_ _01611_ cell2.SB0.route_sel\[49\] cell2.SB0.route_sel\[54\] _01613_ _04470_
+ vssd1 vssd1 vccd1 vccd1 _04471_ sky130_fd_sc_hd__a221o_2
XANTENNA_fanout807_X net807 vssd1 vssd1 vccd1 vccd1 sky130_fd_sc_hd__diode_2
XFILLER_40_755 vssd1 vssd1 vccd1 vccd1 sky130_fd_sc_hd__fill_1
X_12460_ net1480 net549 _06382_ vssd1 vssd1 vccd1 vccd1 _00891_ sky130_fd_sc_hd__a21bo_1
XFILLER_138_643 vssd1 vssd1 vccd1 vccd1 sky130_fd_sc_hd__fill_1
X_12391_ net408 cell2.CB_1.config_dataB\[0\] net836 vssd1 vssd1 vccd1 vccd1 _00824_
+ sky130_fd_sc_hd__mux2_1
X_11411_ _02274_ _06274_ vssd1 vssd1 vccd1 vccd1 net200 sky130_fd_sc_hd__and2b_1
X_14130_ clknet_leaf_65_clk net1160 net745 vssd1 vssd1 vccd1 vccd1 cell3.LE_1B.config_data\[10\]
+ sky130_fd_sc_hd__dfrtp_1
X_11342_ _06236_ net282 _04515_ vssd1 vssd1 vccd1 vccd1 net181 sky130_fd_sc_hd__mux2_1
XANTENNA__10517__X _05475_ vssd1 vssd1 vccd1 vccd1 sky130_fd_sc_hd__diode_2
XANTENNA__07968__A2 _03011_ vssd1 vssd1 vccd1 vccd1 sky130_fd_sc_hd__diode_2
XFILLER_4_601 vccd1 vssd1 vccd1 vssd1 sky130_ef_sc_hd__decap_40_12
XANTENNA__07098__X bus1_0\[9\] vssd1 vssd1 vccd1 vccd1 sky130_fd_sc_hd__diode_2
XTAP_TAPCELL_ROW_78_1479 vssd1 vccd1 sky130_fd_sc_hd__tapvpwrvgnd_1
XFILLER_3_111 vssd1 vssd1 vccd1 vccd1 sky130_fd_sc_hd__fill_1
XANTENNA__06443__A cell1.SB0.route_sel\[35\] vssd1 vssd1 vccd1 vccd1 sky130_fd_sc_hd__diode_2
X_11273_ _05088_ net308 _02248_ vssd1 vssd1 vccd1 vccd1 _06205_ sky130_fd_sc_hd__mux2_1
X_14061_ clknet_leaf_83_clk _01033_ net670 vssd1 vssd1 vccd1 vccd1 cell3.SB0.route_sel\[69\]
+ sky130_fd_sc_hd__dfstp_2
XFILLER_4_645 vccd1 vssd1 vccd1 vssd1 sky130_ef_sc_hd__decap_40_12
XANTENNA_input50_A CBnorth_in[25] vssd1 vssd1 vccd1 vccd1 sky130_fd_sc_hd__diode_2
X_13012_ cell3.LEI0.config_data\[33\] net1282 net957 vssd1 vssd1 vccd1 vccd1 _01440_
+ sky130_fd_sc_hd__mux2_1
X_10224_ net33 net44 net55 net58 cell2.CB_0.config_dataA\[10\] net414 vssd1 vssd1
+ vccd1 vccd1 _05225_ sky130_fd_sc_hd__mux4_1
XANTENNA__11348__X net184 vssd1 vssd1 vccd1 vccd1 sky130_fd_sc_hd__diode_2
XTAP_TAPCELL_ROW_91_1679 vssd1 vccd1 sky130_fd_sc_hd__tapvpwrvgnd_1
XTAP_TAPCELL_ROW_91_1668 vssd1 vccd1 sky130_fd_sc_hd__tapvpwrvgnd_1
X_10155_ _05155_ _04194_ vssd1 vssd1 vccd1 vccd1 _05156_ sky130_fd_sc_hd__and2b_4
X_10086_ cell2.SB0.route_sel\[87\] _01632_ cell2.SB0.route_sel\[84\] _01633_ _05086_
+ vssd1 vssd1 vccd1 vccd1 _05087_ sky130_fd_sc_hd__a221o_1
Xhold6 _00533_ vssd1 vssd1 vccd1 vccd1 net965 sky130_fd_sc_hd__dlygate4sd3_1
Xclkbuf_leaf_86_clk clknet_4_11_0_clk vssd1 vssd1 vccd1 vccd1 clknet_leaf_86_clk sky130_fd_sc_hd__clkbuf_8
X_13914_ clknet_leaf_35_clk net1139 net637 vssd1 vssd1 vccd1 vccd1 cell2.LE_0B.config_data\[15\]
+ sky130_fd_sc_hd__dfrtp_1
XTAP_TAPCELL_ROW_122_2134 vssd1 vccd1 sky130_fd_sc_hd__tapvpwrvgnd_1
XANTENNA__09893__A2 _04498_ vssd1 vssd1 vccd1 vccd1 sky130_fd_sc_hd__diode_2
XFILLER_74_162 vssd1 vssd1 vccd1 vccd1 sky130_fd_sc_hd__fill_4
X_13845_ clknet_leaf_115_clk _00817_ net665 vssd1 vssd1 vccd1 vccd1 cell1.SB0.route_sel\[122\]
+ sky130_fd_sc_hd__dfstp_1
XANTENNA__10839__S _05758_ vssd1 vssd1 vccd1 vccd1 sky130_fd_sc_hd__diode_2
XTAP_TAPCELL_ROW_122_2145 vssd1 vccd1 sky130_fd_sc_hd__tapvpwrvgnd_1
XFILLER_74_195 vssd1 vssd1 vccd1 vccd1 sky130_fd_sc_hd__fill_1
X_10988_ _05879_ _05934_ _05935_ _05884_ vssd1 vssd1 vccd1 vccd1 _05942_ sky130_fd_sc_hd__a2bb2o_1
XFILLER_90_699 vssd1 vssd1 vccd1 vccd1 sky130_fd_sc_hd__fill_1
XFILLER_90_677 vssd1 vssd1 vccd1 vccd1 sky130_fd_sc_hd__fill_1
XANTENNA__13058__SET_B net584 vssd1 vssd1 vccd1 vccd1 sky130_fd_sc_hd__diode_2
X_13776_ clknet_leaf_107_clk _00748_ net653 vssd1 vssd1 vccd1 vccd1 cell1.SB0.route_sel\[53\]
+ sky130_fd_sc_hd__dfstp_1
X_12727_ cell3.CB_0.config_dataB\[19\] cell3.CB_0.config_dataB\[18\] net931 vssd1
+ vssd1 vccd1 vccd1 _01156_ sky130_fd_sc_hd__mux2_1
X_12658_ cell3.SB0.route_sel\[123\] cell3.SB0.route_sel\[122\] net914 vssd1 vssd1
+ vccd1 vccd1 _01087_ sky130_fd_sc_hd__mux2_1
XANTENNA__10900__A_N cell3.SB0.route_sel\[101\] vssd1 vssd1 vccd1 vccd1 sky130_fd_sc_hd__diode_2
X_11609_ net531 cell0.CB_0.config_dataB\[4\] net779 vssd1 vssd1 vccd1 vccd1 _00050_
+ sky130_fd_sc_hd__mux2_1
XFILLER_128_153 vssd1 vssd1 vccd1 vccd1 sky130_fd_sc_hd__fill_1
X_12589_ cell3.SB0.route_sel\[54\] cell3.SB0.route_sel\[53\] net914 vssd1 vssd1 vccd1
+ vccd1 _01018_ sky130_fd_sc_hd__mux2_1
Xclkbuf_leaf_10_clk clknet_4_1_0_clk vssd1 vssd1 vccd1 vccd1 clknet_leaf_10_clk sky130_fd_sc_hd__clkbuf_8
XFILLER_11_490 vccd1 vssd1 vccd1 vssd1 sky130_ef_sc_hd__decap_40_12
XTAP_TAPCELL_ROW_13_496 vssd1 vccd1 sky130_fd_sc_hd__tapvpwrvgnd_1
XANTENNA__10963__A1 _04354_ vssd1 vssd1 vccd1 vccd1 sky130_fd_sc_hd__diode_2
X_14328_ clknet_leaf_26_clk _01300_ net607 vssd1 vssd1 vccd1 vccd1 cell2.SB0.route_sel\[113\]
+ sky130_fd_sc_hd__dfstp_2
Xhold417 _00553_ vssd1 vssd1 vccd1 vccd1 net1376 sky130_fd_sc_hd__dlygate4sd3_1
Xhold406 _00579_ vssd1 vssd1 vccd1 vccd1 net1365 sky130_fd_sc_hd__dlygate4sd3_1
XFILLER_7_472 vssd1 vssd1 vccd1 vccd1 sky130_fd_sc_hd__fill_1
XFILLER_132_819 vssd1 vssd1 vccd1 vccd1 sky130_fd_sc_hd__fill_1
XTAP_TAPCELL_ROW_133_2296 vssd1 vccd1 sky130_fd_sc_hd__tapvpwrvgnd_1
Xhold439 _01417_ vssd1 vssd1 vccd1 vccd1 net1398 sky130_fd_sc_hd__dlygate4sd3_1
X_14259_ clknet_leaf_26_clk _01231_ net607 vssd1 vssd1 vccd1 vccd1 cell2.SB0.route_sel\[44\]
+ sky130_fd_sc_hd__dfstp_1
Xhold428 cell1.LE_0A.config_data\[5\] vssd1 vssd1 vccd1 vccd1 net1387 sky130_fd_sc_hd__dlygate4sd3_1
XANTENNA__07736__X bus1_0\[3\] vssd1 vssd1 vccd1 vccd1 sky130_fd_sc_hd__diode_2
XANTENNA__11258__X net191 vssd1 vssd1 vccd1 vccd1 sky130_fd_sc_hd__diode_2
Xfanout919 net920 vssd1 vssd1 vccd1 vccd1 net919 sky130_fd_sc_hd__clkbuf_4
XANTENNA__07041__C1 net551 vssd1 vssd1 vccd1 vccd1 sky130_fd_sc_hd__diode_2
Xfanout908 net959 vssd1 vssd1 vccd1 vccd1 net908 sky130_fd_sc_hd__buf_2
X_08820_ cell1.SB0.route_sel\[69\] cell1.SB0.route_sel\[68\] vssd1 vssd1 vccd1 vccd1
+ _03852_ sky130_fd_sc_hd__nand2b_1
XANTENNA__07184__A net314 vssd1 vssd1 vccd1 vccd1 sky130_fd_sc_hd__diode_2
Xclkbuf_leaf_77_clk clknet_4_14_0_clk vssd1 vssd1 vccd1 vccd1 clknet_leaf_77_clk sky130_fd_sc_hd__clkbuf_8
X_08751_ _03517_ _03772_ _03773_ _03514_ cell1.CB_1.config_dataB\[17\] vssd1 vssd1
+ vccd1 vccd1 _03785_ sky130_fd_sc_hd__a221o_1
XTAP_TAPCELL_ROW_107_1907 vssd1 vccd1 sky130_fd_sc_hd__tapvpwrvgnd_1
X_07702_ cell0.SB0.route_sel\[31\] cell0.SB0.route_sel\[30\] vssd1 vssd1 vccd1 vccd1
+ _02749_ sky130_fd_sc_hd__nand2_1
XANTENNA__08136__A2 _02560_ vssd1 vssd1 vccd1 vccd1 sky130_fd_sc_hd__diode_2
X_08682_ _03706_ _03713_ cell1.CB_1.config_dataB\[2\] vssd1 vssd1 vccd1 vccd1 _03716_
+ sky130_fd_sc_hd__mux2_1
XANTENNA__11140__B2 _05898_ vssd1 vssd1 vccd1 vccd1 sky130_fd_sc_hd__diode_2
XTAP_TAPCELL_ROW_107_1918 vssd1 vccd1 sky130_fd_sc_hd__tapvpwrvgnd_1
XANTENNA__08687__A3 net26 vssd1 vssd1 vccd1 vccd1 sky130_fd_sc_hd__diode_2
X_07633_ _02658_ _02679_ _02681_ vssd1 vssd1 vccd1 vccd1 _02682_ sky130_fd_sc_hd__a21o_1
XTAP_TAPCELL_ROW_49_1047 vssd1 vccd1 sky130_fd_sc_hd__tapvpwrvgnd_1
XTAP_TAPCELL_ROW_49_1036 vssd1 vccd1 sky130_fd_sc_hd__tapvpwrvgnd_1
XFILLER_81_699 vssd1 vssd1 vccd1 vccd1 sky130_fd_sc_hd__fill_2
XFILLER_0_91 vssd1 vssd1 vccd1 vccd1 sky130_fd_sc_hd__fill_2
X_07564_ _02608_ _02611_ _02613_ _02612_ vssd1 vssd1 vccd1 vccd1 _02614_ sky130_fd_sc_hd__a31o_1
X_09303_ _01993_ _04176_ vssd1 vssd1 vccd1 vccd1 _04328_ sky130_fd_sc_hd__nor2_1
XTAP_TAPCELL_ROW_62_1236 vssd1 vccd1 sky130_fd_sc_hd__tapvpwrvgnd_1
X_07495_ cell0.SB0.route_sel\[125\] cell0.SB0.route_sel\[124\] net71 vssd1 vssd1 vccd1
+ vccd1 _02547_ sky130_fd_sc_hd__a21boi_1
X_06515_ cell0.SB0.route_sel\[12\] vssd1 vssd1 vccd1 vccd1 _01585_ sky130_fd_sc_hd__inv_2
XFILLER_139_418 vssd1 vssd1 vccd1 vccd1 sky130_fd_sc_hd__fill_1
XFILLER_139_407 vssd1 vssd1 vccd1 vccd1 sky130_fd_sc_hd__fill_1
XANTENNA__09398__X bus3_1\[4\] vssd1 vssd1 vccd1 vccd1 sky130_fd_sc_hd__diode_2
X_09234_ _02164_ _04176_ _04257_ _04259_ vssd1 vssd1 vccd1 vccd1 _04261_ sky130_fd_sc_hd__o211ai_1
XANTENNA_fanout335_A net337 vssd1 vssd1 vccd1 vccd1 sky130_fd_sc_hd__diode_2
XPHY_EDGE_ROW_3_Right_3 vssd1 vssd1 vccd1 vccd1 sky130_fd_sc_hd__decap_3
X_06446_ cell1.SB0.route_sel\[43\] vssd1 vssd1 vccd1 vccd1 _01516_ sky130_fd_sc_hd__inv_2
X_09165_ cell2.SB0.route_sel\[0\] cell2.SB0.route_sel\[1\] _04192_ vssd1 vssd1 vccd1
+ vccd1 _04193_ sky130_fd_sc_hd__a21oi_1
XFILLER_21_265 vssd1 vssd1 vccd1 vccd1 sky130_fd_sc_hd__fill_1
XTAP_TAPCELL_ROW_32_783 vssd1 vccd1 sky130_fd_sc_hd__tapvpwrvgnd_1
XTAP_TAPCELL_ROW_32_794 vssd1 vccd1 sky130_fd_sc_hd__tapvpwrvgnd_1
XANTENNA__09939__A3 bus3_2\[11\] vssd1 vssd1 vccd1 vccd1 sky130_fd_sc_hd__diode_2
X_08116_ _03157_ _03156_ _03057_ vssd1 vssd1 vccd1 vccd1 _03158_ sky130_fd_sc_hd__mux2_1
XFILLER_119_57 vssd1 vssd1 vccd1 vccd1 sky130_fd_sc_hd__fill_1
XANTENNA__10954__A1 net41 vssd1 vssd1 vccd1 vccd1 sky130_fd_sc_hd__diode_2
X_09096_ _04125_ _04124_ _04051_ vssd1 vssd1 vccd1 vccd1 _04126_ sky130_fd_sc_hd__mux2_1
XANTENNA__08072__A1 bus2_0\[1\] vssd1 vssd1 vccd1 vccd1 sky130_fd_sc_hd__diode_2
X_08047_ net527 _02301_ vssd1 vssd1 vccd1 vccd1 _03089_ sky130_fd_sc_hd__nand2_1
XFILLER_1_615 vssd1 vssd1 vccd1 vccd1 sky130_fd_sc_hd__fill_1
XANTENNA__08375__A2 net349 vssd1 vssd1 vccd1 vccd1 sky130_fd_sc_hd__diode_2
XANTENNA_fanout871_A net884 vssd1 vssd1 vccd1 vccd1 sky130_fd_sc_hd__diode_2
XANTENNA__10182__A2 _05107_ vssd1 vssd1 vccd1 vccd1 sky130_fd_sc_hd__diode_2
X_09998_ bus3_2\[8\] bus3_2\[9\] bus3_2\[10\] bus3_2\[11\] net403 cell2.CB_1.config_dataB\[11\]
+ vssd1 vssd1 vccd1 vccd1 _05002_ sky130_fd_sc_hd__mux4_1
XFILLER_95_27 vccd1 vssd1 vccd1 vssd1 sky130_ef_sc_hd__decap_40_12
XTAP_TAPCELL_ROW_73_1398 vssd1 vccd1 sky130_fd_sc_hd__tapvpwrvgnd_1
XFILLER_0_158 vssd1 vssd1 vccd1 vccd1 sky130_fd_sc_hd__fill_8
XANTENNA__10232__B _05144_ vssd1 vssd1 vccd1 vccd1 sky130_fd_sc_hd__diode_2
X_08949_ _03871_ _03972_ _03973_ _03868_ cell1.CB_0.config_dataA\[17\] vssd1 vssd1
+ vccd1 vccd1 _03981_ sky130_fd_sc_hd__a221o_1
XANTENNA__13697__SET_B net621 vssd1 vssd1 vccd1 vccd1 sky130_fd_sc_hd__diode_2
Xclkbuf_leaf_68_clk clknet_4_15_0_clk vssd1 vssd1 vccd1 vccd1 clknet_leaf_68_clk sky130_fd_sc_hd__clkbuf_8
X_11960_ cell0.SB0.route_sel\[66\] cell0.SB0.route_sel\[65\] net764 vssd1 vssd1 vccd1
+ vccd1 _00397_ sky130_fd_sc_hd__mux2_1
XANTENNA__11131__A1 net54 vssd1 vssd1 vccd1 vccd1 sky130_fd_sc_hd__diode_2
X_10911_ cell3.CB_0.config_dataA\[2\] _05864_ vssd1 vssd1 vccd1 vccd1 _05865_ sky130_fd_sc_hd__nand2_1
XANTENNA__07335__B1 _01639_ vssd1 vssd1 vccd1 vccd1 sky130_fd_sc_hd__diode_2
XFILLER_17_505 vssd1 vssd1 vccd1 vccd1 sky130_fd_sc_hd__fill_2
X_11891_ cell1.CB_0.config_dataA\[22\] cell1.CB_0.config_dataA\[21\] net875 vssd1
+ vssd1 vccd1 vccd1 _00328_ sky130_fd_sc_hd__mux2_1
XANTENNA__08637__B net458 vssd1 vssd1 vccd1 vccd1 sky130_fd_sc_hd__diode_2
X_13630_ clknet_leaf_39_clk _00602_ net645 vssd1 vssd1 vccd1 vccd1 cell2.LE_1B.config_data\[2\]
+ sky130_fd_sc_hd__dfrtp_1
X_10842_ net364 net365 vssd1 vssd1 vccd1 vccd1 _05798_ sky130_fd_sc_hd__and2b_1
XFILLER_72_688 vssd1 vssd1 vccd1 vccd1 sky130_fd_sc_hd__fill_1
XFILLER_13_711 vssd1 vssd1 vccd1 vccd1 sky130_fd_sc_hd__fill_1
X_10773_ net368 _05723_ _05728_ vssd1 vssd1 vccd1 vccd1 _05729_ sky130_fd_sc_hd__a21o_1
XANTENNA__10923__A_N cell3.SB0.route_sel\[69\] vssd1 vssd1 vccd1 vccd1 sky130_fd_sc_hd__diode_2
X_13561_ clknet_leaf_118_clk net965 net669 vssd1 vssd1 vccd1 vccd1 cell1.LE_0A.config_data\[4\]
+ sky130_fd_sc_hd__dfrtp_1
X_12512_ net1316 cell2.LEI0.config_data\[25\] net843 vssd1 vssd1 vccd1 vccd1 _00941_
+ sky130_fd_sc_hd__mux2_1
XFILLER_12_243 vssd1 vssd1 vccd1 vccd1 sky130_fd_sc_hd__fill_1
XANTENNA__11350__Y net185 vssd1 vssd1 vccd1 vccd1 sky130_fd_sc_hd__diode_2
X_13492_ clknet_leaf_94_clk _00464_ net693 vssd1 vssd1 vccd1 vccd1 cell1.CB_1.config_dataB\[5\]
+ sky130_fd_sc_hd__dfstp_1
XFILLER_9_737 vssd1 vssd1 vccd1 vccd1 sky130_fd_sc_hd__fill_1
XANTENNA_input98_A SBwest_in[10] vssd1 vssd1 vccd1 vccd1 sky130_fd_sc_hd__diode_2
X_12443_ net1161 cell2.LE_0B.config_data\[2\] net844 vssd1 vssd1 vccd1 vccd1 _00874_
+ sky130_fd_sc_hd__mux2_1
XANTENNA__12934__A2 net550 vssd1 vssd1 vccd1 vccd1 sky130_fd_sc_hd__diode_2
XTAP_TAPCELL_ROW_93_1708 vssd1 vccd1 sky130_fd_sc_hd__tapvpwrvgnd_1
X_12374_ cell1.SB0.route_sel\[112\] cell1.SB0.route_sel\[111\] net874 vssd1 vssd1
+ vccd1 vccd1 _00807_ sky130_fd_sc_hd__mux2_1
XTAP_TAPCELL_ROW_10_455 vssd1 vccd1 sky130_fd_sc_hd__tapvpwrvgnd_1
X_14113_ clknet_leaf_47_clk _01085_ net705 vssd1 vssd1 vccd1 vccd1 cell3.SB0.route_sel\[121\]
+ sky130_fd_sc_hd__dfstp_1
X_11325_ _05522_ net288 _04728_ vssd1 vssd1 vccd1 vccd1 _06228_ sky130_fd_sc_hd__mux2_1
XANTENNA_input53_X net53 vssd1 vssd1 vccd1 vccd1 sky130_fd_sc_hd__diode_2
X_11256_ _06195_ net309 _04291_ vssd1 vssd1 vccd1 vccd1 net188 sky130_fd_sc_hd__mux2_2
X_14044_ clknet_leaf_49_clk _01016_ net706 vssd1 vssd1 vccd1 vccd1 cell3.SB0.route_sel\[52\]
+ sky130_fd_sc_hd__dfstp_1
XFILLER_5_69 vccd1 vssd1 vccd1 vssd1 sky130_ef_sc_hd__decap_40_12
XFILLER_4_475 vssd1 vssd1 vccd1 vccd1 sky130_fd_sc_hd__fill_1
XANTENNA_output254_A net254 vssd1 vssd1 vccd1 vccd1 sky130_fd_sc_hd__diode_2
X_11187_ _06138_ vssd1 vssd1 vccd1 vccd1 _06139_ sky130_fd_sc_hd__inv_2
X_10207_ net63 net64 net34 net35 net416 cell2.CB_0.config_dataA\[11\] vssd1 vssd1
+ vccd1 vccd1 _05208_ sky130_fd_sc_hd__mux4_1
XFILLER_79_276 vssd1 vssd1 vccd1 vccd1 sky130_fd_sc_hd__fill_4
XFILLER_79_254 vssd1 vssd1 vccd1 vccd1 sky130_fd_sc_hd__fill_1
XANTENNA__12114__S net905 vssd1 vssd1 vccd1 vccd1 sky130_fd_sc_hd__diode_2
X_10138_ _05137_ _05138_ _04396_ vssd1 vssd1 vccd1 vccd1 _05139_ sky130_fd_sc_hd__a21bo_4
XFILLER_67_449 vssd1 vssd1 vccd1 vccd1 sky130_fd_sc_hd__fill_2
XFILLER_39_129 vssd1 vssd1 vccd1 vccd1 sky130_fd_sc_hd__fill_1
X_10069_ _05071_ _05072_ _04992_ vssd1 vssd1 vccd1 vccd1 _05073_ sky130_fd_sc_hd__mux2_1
Xclkbuf_leaf_59_clk clknet_4_15_0_clk vssd1 vssd1 vccd1 vccd1 clknet_leaf_59_clk sky130_fd_sc_hd__clkbuf_8
XANTENNA__07326__A0 net317 vssd1 vssd1 vccd1 vccd1 sky130_fd_sc_hd__diode_2
XANTENNA__11122__A1 net279 vssd1 vssd1 vccd1 vccd1 sky130_fd_sc_hd__diode_2
XFILLER_85_93 vccd1 vssd1 vccd1 vssd1 sky130_ef_sc_hd__decap_40_12
XFILLER_82_419 vssd1 vssd1 vccd1 vccd1 sky130_fd_sc_hd__fill_1
XFILLER_75_471 vssd1 vssd1 vccd1 vccd1 sky130_fd_sc_hd__fill_8
XFILLER_62_110 vssd1 vssd1 vccd1 vccd1 sky130_fd_sc_hd__fill_1
XFILLER_90_474 vssd1 vssd1 vccd1 vccd1 sky130_fd_sc_hd__fill_2
X_13828_ clknet_leaf_114_clk _00800_ net666 vssd1 vssd1 vccd1 vccd1 cell1.SB0.route_sel\[105\]
+ sky130_fd_sc_hd__dfstp_1
XTAP_TAPCELL_ROW_18_577 vssd1 vccd1 sky130_fd_sc_hd__tapvpwrvgnd_1
XTAP_TAPCELL_ROW_102_1837 vssd1 vccd1 sky130_fd_sc_hd__tapvpwrvgnd_1
XFILLER_90_485 vssd1 vssd1 vccd1 vccd1 sky130_fd_sc_hd__fill_4
X_13759_ clknet_leaf_111_clk _00731_ net655 vssd1 vssd1 vccd1 vccd1 cell1.SB0.route_sel\[36\]
+ sky130_fd_sc_hd__dfstp_1
XANTENNA__10633__B1 _04370_ vssd1 vssd1 vccd1 vccd1 sky130_fd_sc_hd__diode_2
XFILLER_93_3 vccd1 vssd1 vccd1 vssd1 sky130_ef_sc_hd__decap_40_12
X_07280_ net343 _02026_ _02336_ vssd1 vssd1 vccd1 vccd1 _02338_ sky130_fd_sc_hd__or3_1
XTAP_TAPCELL_ROW_135_2336 vssd1 vccd1 sky130_fd_sc_hd__tapvpwrvgnd_1
XANTENNA__08054__A1 _02388_ vssd1 vssd1 vccd1 vccd1 sky130_fd_sc_hd__diode_2
XANTENNA__08054__B2 _02456_ vssd1 vssd1 vccd1 vccd1 sky130_fd_sc_hd__diode_2
Xhold203 _00874_ vssd1 vssd1 vccd1 vccd1 net1162 sky130_fd_sc_hd__dlygate4sd3_1
Xhold214 _00606_ vssd1 vssd1 vccd1 vccd1 net1173 sky130_fd_sc_hd__dlygate4sd3_1
XANTENNA__10317__B _05144_ vssd1 vssd1 vccd1 vccd1 sky130_fd_sc_hd__diode_2
Xhold225 cell1.LEI0.config_data\[33\] vssd1 vssd1 vccd1 vccd1 net1184 sky130_fd_sc_hd__dlygate4sd3_1
Xhold247 cell3.LE_0A.config_data\[13\] vssd1 vssd1 vccd1 vccd1 net1206 sky130_fd_sc_hd__dlygate4sd3_1
Xhold258 _01387_ vssd1 vssd1 vccd1 vccd1 net1217 sky130_fd_sc_hd__dlygate4sd3_1
XANTENNA__10400__A3 _05139_ vssd1 vssd1 vccd1 vccd1 sky130_fd_sc_hd__diode_2
Xhold269 cell3.LE_1A.config_data\[9\] vssd1 vssd1 vccd1 vccd1 net1228 sky130_fd_sc_hd__dlygate4sd3_1
X_09921_ bus3_2\[0\] bus3_2\[2\] bus3_2\[1\] bus3_2\[3\] cell2.CB_1.config_dataB\[1\]
+ net409 vssd1 vssd1 vccd1 vccd1 _04925_ sky130_fd_sc_hd__mux4_1
Xhold236 _00508_ vssd1 vssd1 vccd1 vccd1 net1195 sky130_fd_sc_hd__dlygate4sd3_1
XFILLER_113_841 vssd1 vssd1 vccd1 vccd1 sky130_fd_sc_hd__fill_1
Xfanout705 net706 vssd1 vssd1 vccd1 vccd1 net705 sky130_fd_sc_hd__clkbuf_4
Xfanout749 net750 vssd1 vssd1 vccd1 vccd1 net749 sky130_fd_sc_hd__buf_2
Xfanout738 net741 vssd1 vssd1 vccd1 vccd1 net738 sky130_fd_sc_hd__clkbuf_4
Xfanout716 net724 vssd1 vssd1 vccd1 vccd1 net716 sky130_fd_sc_hd__clkbuf_2
XTAP_TAPCELL_ROW_113_1999 vssd1 vccd1 sky130_fd_sc_hd__tapvpwrvgnd_1
Xfanout727 net749 vssd1 vssd1 vccd1 vccd1 net727 sky130_fd_sc_hd__clkbuf_4
XFILLER_105_15 vssd1 vssd1 vccd1 vccd1 sky130_fd_sc_hd__fill_4
X_09852_ net441 _04472_ _04857_ net440 vssd1 vssd1 vccd1 vccd1 _04858_ sky130_fd_sc_hd__o211a_1
X_09783_ cell2.LEI0.config_data\[20\] _04788_ vssd1 vssd1 vccd1 vccd1 _04789_ sky130_fd_sc_hd__nor2_1
X_08803_ bus3_1\[8\] bus3_1\[9\] bus3_1\[10\] bus3_1\[11\] net471 net469 vssd1 vssd1
+ vccd1 vccd1 _03835_ sky130_fd_sc_hd__mux4_1
XFILLER_58_427 vssd1 vssd1 vccd1 vccd1 sky130_fd_sc_hd__fill_1
XANTENNA_fanout285_A net286 vssd1 vssd1 vccd1 vccd1 sky130_fd_sc_hd__diode_2
X_06995_ cell1.CB_0.config_dataB\[24\] cell1.CB_0.config_dataB\[21\] cell1.CB_0.config_dataB\[20\]
+ vssd1 vssd1 vccd1 vccd1 _02061_ sky130_fd_sc_hd__nor3_1
X_08734_ cell1.LE_1B.config_data\[7\] cell1.LE_1B.config_data\[6\] _03735_ vssd1 vssd1
+ vccd1 vccd1 _03768_ sky130_fd_sc_hd__mux2_1
XANTENNA__11863__S net898 vssd1 vssd1 vccd1 vccd1 sky130_fd_sc_hd__diode_2
XANTENNA__11113__B2 net46 vssd1 vssd1 vccd1 vccd1 sky130_fd_sc_hd__diode_2
XANTENNA__11113__A1 net45 vssd1 vssd1 vccd1 vccd1 sky130_fd_sc_hd__diode_2
XANTENNA__07868__A1 bus2_0\[1\] vssd1 vssd1 vccd1 vccd1 sky130_fd_sc_hd__diode_2
X_08665_ cell1.LEI0.config_data\[21\] _01821_ _03698_ cell1.LEI0.config_data\[22\]
+ vssd1 vssd1 vccd1 vccd1 _03699_ sky130_fd_sc_hd__o211a_1
XFILLER_27_847 vssd1 vssd1 vccd1 vccd1 sky130_fd_sc_hd__fill_1
XFILLER_81_474 vccd1 vssd1 vccd1 vssd1 sky130_ef_sc_hd__decap_40_12
X_07616_ cell0.SB0.route_sel\[15\] cell0.SB0.route_sel\[14\] vssd1 vssd1 vccd1 vccd1
+ _02665_ sky130_fd_sc_hd__nand2_1
X_08596_ net488 _03529_ vssd1 vssd1 vccd1 vccd1 _03632_ sky130_fd_sc_hd__nand2_1
XTAP_TAPCELL_ROW_37_864 vssd1 vccd1 sky130_fd_sc_hd__tapvpwrvgnd_1
X_07547_ cell2.CB_0.config_dataB\[22\] cell2.CB_0.config_dataB\[23\] _02000_ net39
+ vssd1 vssd1 vccd1 vccd1 _02598_ sky130_fd_sc_hd__a31o_1
XFILLER_41_327 vssd1 vssd1 vccd1 vccd1 sky130_fd_sc_hd__fill_1
XANTENNA_fanout338_X net338 vssd1 vssd1 vccd1 vccd1 sky130_fd_sc_hd__diode_2
X_07478_ cell2.SB0.route_sel\[115\] cell2.SB0.route_sel\[114\] _02529_ _02530_ _02523_
+ vssd1 vssd1 vccd1 vccd1 _02531_ sky130_fd_sc_hd__a41o_1
XFILLER_10_725 vssd1 vssd1 vccd1 vccd1 sky130_fd_sc_hd__fill_2
XANTENNA__08293__A1 bus1_0\[1\] vssd1 vssd1 vccd1 vccd1 sky130_fd_sc_hd__diode_2
XFILLER_22_585 vssd1 vssd1 vccd1 vccd1 sky130_fd_sc_hd__fill_2
XPHY_EDGE_ROW_101_Left_244 vssd1 vssd1 vccd1 vccd1 sky130_fd_sc_hd__decap_3
X_09217_ cell2.SB0.route_sel\[15\] cell2.SB0.route_sel\[14\] _04243_ vssd1 vssd1 vccd1
+ vccd1 _04244_ sky130_fd_sc_hd__a21bo_1
X_06429_ cell0.CB_1.config_dataA\[7\] vssd1 vssd1 vccd1 vccd1 _01499_ sky130_fd_sc_hd__inv_2
XFILLER_108_613 vssd1 vssd1 vccd1 vccd1 sky130_fd_sc_hd__fill_1
X_09148_ cell2.CB_1.config_dataB\[23\] cell2.CB_1.config_dataB\[22\] vssd1 vssd1 vccd1
+ vccd1 _04176_ sky130_fd_sc_hd__or2_1
XFILLER_30_22 vssd1 vssd1 vccd1 vccd1 sky130_fd_sc_hd__fill_4
XTAP_TAPCELL_ROW_75_1427 vssd1 vccd1 sky130_fd_sc_hd__tapvpwrvgnd_1
X_09079_ bus3_1\[4\] _04090_ _04091_ bus3_1\[5\] cell1.CB_0.config_dataB\[13\] vssd1
+ vssd1 vccd1 vccd1 _04109_ sky130_fd_sc_hd__a221o_1
X_11110_ _05898_ _06048_ _05901_ _06047_ vssd1 vssd1 vccd1 vccd1 _06062_ sky130_fd_sc_hd__o2bb2a_1
XTAP_TAPCELL_ROW_75_1438 vssd1 vccd1 sky130_fd_sc_hd__tapvpwrvgnd_1
XANTENNA__12129__A0 cell1.LEI0.config_data\[11\] vssd1 vssd1 vccd1 vccd1 sky130_fd_sc_hd__diode_2
X_12090_ cell1.LE_0B.reset_val cell1.LE_0B.edge_mode net906 vssd1 vssd1 vccd1 vccd1
+ _00525_ sky130_fd_sc_hd__mux2_1
X_11041_ net373 _05850_ vssd1 vssd1 vccd1 vccd1 _05995_ sky130_fd_sc_hd__nand2_1
XFILLER_1_445 vssd1 vssd1 vccd1 vccd1 sky130_fd_sc_hd__fill_2
XPHY_EDGE_ROW_110_Left_253 vssd1 vssd1 vccd1 vccd1 sky130_fd_sc_hd__decap_3
XANTENNA__09591__X _04608_ vssd1 vssd1 vccd1 vccd1 sky130_fd_sc_hd__diode_2
XFILLER_49_449 vssd1 vssd1 vccd1 vccd1 sky130_fd_sc_hd__fill_2
X_12992_ net1433 cell3.LEI0.config_data\[12\] net946 vssd1 vssd1 vccd1 vccd1 _01420_
+ sky130_fd_sc_hd__mux2_1
XANTENNA__11104__A1 net274 vssd1 vssd1 vccd1 vccd1 sky130_fd_sc_hd__diode_2
XANTENNA_input13_A CBeast_in[20] vssd1 vssd1 vccd1 vccd1 sky130_fd_sc_hd__diode_2
XANTENNA__12852__A1 cell2.SB0.route_sel\[93\] vssd1 vssd1 vccd1 vccd1 sky130_fd_sc_hd__diode_2
XFILLER_17_335 vssd1 vssd1 vccd1 vccd1 sky130_fd_sc_hd__fill_1
X_11943_ cell0.SB0.route_sel\[49\] cell0.SB0.route_sel\[48\] net759 vssd1 vssd1 vccd1
+ vccd1 _00380_ sky130_fd_sc_hd__mux2_1
X_11874_ net470 cell1.CB_0.config_dataA\[4\] net883 vssd1 vssd1 vccd1 vccd1 _00311_
+ sky130_fd_sc_hd__mux2_1
X_10825_ net21 net22 net24 net25 net367 net366 vssd1 vssd1 vccd1 vccd1 _05781_ sky130_fd_sc_hd__mux4_1
X_13613_ clknet_leaf_92_clk _00585_ net695 vssd1 vssd1 vccd1 vccd1 cell1.LEI0.config_data\[34\]
+ sky130_fd_sc_hd__dfrtp_1
XANTENNA__06914__B1_N _01979_ vssd1 vssd1 vccd1 vccd1 sky130_fd_sc_hd__diode_2
XANTENNA__10615__A0 net21 vssd1 vssd1 vccd1 vccd1 sky130_fd_sc_hd__diode_2
XFILLER_13_530 vssd1 vssd1 vccd1 vccd1 sky130_fd_sc_hd__fill_2
XTAP_TAPCELL_ROW_15_536 vssd1 vccd1 sky130_fd_sc_hd__tapvpwrvgnd_1
X_10756_ _05711_ vssd1 vssd1 vccd1 vccd1 _05712_ sky130_fd_sc_hd__inv_2
X_13544_ clknet_leaf_72_clk net1021 net728 vssd1 vssd1 vccd1 vccd1 cell1.LE_0B.config_data\[9\]
+ sky130_fd_sc_hd__dfrtp_1
X_10687_ net390 net391 vssd1 vssd1 vccd1 vccd1 _05645_ sky130_fd_sc_hd__nand2b_1
X_13475_ clknet_leaf_2_clk _00447_ net561 vssd1 vssd1 vccd1 vccd1 cell0.SB0.route_sel\[116\]
+ sky130_fd_sc_hd__dfstp_1
XTAP_TAPCELL_ROW_117_2066 vssd1 vccd1 sky130_fd_sc_hd__tapvpwrvgnd_1
X_12426_ net1126 net1167 net924 vssd1 vssd1 vccd1 vccd1 _00858_ sky130_fd_sc_hd__mux2_1
XANTENNA__10394__A2 net38 vssd1 vssd1 vccd1 vccd1 sky130_fd_sc_hd__diode_2
XANTENNA__07795__B1 _02834_ vssd1 vssd1 vccd1 vccd1 sky130_fd_sc_hd__diode_2
XANTENNA__08830__B _03861_ vssd1 vssd1 vccd1 vccd1 sky130_fd_sc_hd__diode_2
X_12357_ cell1.SB0.route_sel\[95\] cell1.SB0.route_sel\[94\] net870 vssd1 vssd1 vccd1
+ vccd1 _00790_ sky130_fd_sc_hd__mux2_1
XTAP_TAPCELL_ROW_130_2255 vssd1 vccd1 sky130_fd_sc_hd__tapvpwrvgnd_1
XFILLER_99_349 vssd1 vssd1 vccd1 vccd1 sky130_fd_sc_hd__fill_1
X_11308_ _04509_ _05475_ _04510_ vssd1 vssd1 vccd1 vccd1 _06219_ sky130_fd_sc_hd__a21oi_1
X_12288_ cell1.SB0.route_sel\[26\] cell1.SB0.route_sel\[25\] net857 vssd1 vssd1 vccd1
+ vccd1 _00721_ sky130_fd_sc_hd__mux2_1
X_11239_ _06190_ _06189_ _06182_ _06175_ vssd1 vssd1 vccd1 vccd1 _06191_ sky130_fd_sc_hd__a2bb2o_1
X_14027_ clknet_leaf_47_clk _00999_ net703 vssd1 vssd1 vccd1 vccd1 cell3.SB0.route_sel\[35\]
+ sky130_fd_sc_hd__dfstp_1
XANTENNA__07547__B1 net39 vssd1 vssd1 vccd1 vccd1 sky130_fd_sc_hd__diode_2
XFILLER_110_811 vssd1 vssd1 vccd1 vccd1 sky130_fd_sc_hd__fill_1
XANTENNA__08829__Y _03861_ vssd1 vssd1 vccd1 vccd1 sky130_fd_sc_hd__diode_2
XANTENNA__09839__A2 _04583_ vssd1 vssd1 vccd1 vccd1 sky130_fd_sc_hd__diode_2
XANTENNA__07733__Y _02780_ vssd1 vssd1 vccd1 vccd1 sky130_fd_sc_hd__diode_2
X_06780_ cell0.CB_1.config_dataB\[24\] cell0.CB_1.config_dataB\[20\] cell0.CB_1.config_dataB\[21\]
+ vssd1 vssd1 vccd1 vccd1 _01850_ sky130_fd_sc_hd__or3b_2
XANTENNA__10854__A0 _05478_ vssd1 vssd1 vccd1 vccd1 sky130_fd_sc_hd__diode_2
X_08450_ _02515_ _03485_ vssd1 vssd1 vccd1 vccd1 _03486_ sky130_fd_sc_hd__or2_4
X_07401_ _02422_ _02454_ vssd1 vssd1 vccd1 vccd1 _02456_ sky130_fd_sc_hd__nor2_4
X_08381_ net501 _02560_ _03418_ vssd1 vssd1 vccd1 vccd1 _03419_ sky130_fd_sc_hd__a21o_1
XTAP_TAPCELL_ROW_34_812 vssd1 vccd1 sky130_fd_sc_hd__tapvpwrvgnd_1
XTAP_TAPCELL_ROW_34_823 vssd1 vccd1 sky130_fd_sc_hd__tapvpwrvgnd_1
X_07332_ _02341_ _02346_ _02387_ _02343_ vssd1 vssd1 vccd1 vccd1 _02389_ sky130_fd_sc_hd__a31o_1
XANTENNA__12071__A2 _01820_ vssd1 vssd1 vccd1 vccd1 sky130_fd_sc_hd__diode_2
X_07263_ _01634_ cell2.SB0.route_sel\[90\] cell2.SB0.route_sel\[94\] cell2.SB0.route_sel\[95\]
+ _02321_ vssd1 vssd1 vccd1 vccd1 _02322_ sky130_fd_sc_hd__o221a_1
XANTENNA__09676__X bus3_1\[13\] vssd1 vssd1 vccd1 vccd1 sky130_fd_sc_hd__diode_2
X_07194_ _01629_ cell2.SB0.route_sel\[81\] _01630_ cell2.SB0.route_sel\[82\] vssd1
+ vssd1 vccd1 vccd1 _02255_ sky130_fd_sc_hd__o22a_1
X_09002_ net482 _03885_ vssd1 vssd1 vccd1 vccd1 _04032_ sky130_fd_sc_hd__or2_1
XANTENNA__10909__A1 _05856_ vssd1 vssd1 vccd1 vccd1 sky130_fd_sc_hd__diode_2
XANTENNA__11858__S net897 vssd1 vssd1 vccd1 vccd1 sky130_fd_sc_hd__diode_2
XANTENNA__10385__A2 _05107_ vssd1 vssd1 vccd1 vccd1 sky130_fd_sc_hd__diode_2
XFILLER_2_209 vccd1 vssd1 vccd1 vssd1 sky130_ef_sc_hd__decap_40_12
XTAP_TAPCELL_ROW_57_1168 vssd1 vccd1 sky130_fd_sc_hd__tapvpwrvgnd_1
XTAP_TAPCELL_ROW_57_1157 vssd1 vccd1 sky130_fd_sc_hd__tapvpwrvgnd_1
X_09904_ cell2.LE_1A.config_data\[1\] cell2.LE_1A.config_data\[0\] _04831_ vssd1 vssd1
+ vccd1 vccd1 _04910_ sky130_fd_sc_hd__mux2_1
XFILLER_116_25 vssd1 vssd1 vccd1 vccd1 sky130_fd_sc_hd__fill_2
XFILLER_104_148 vssd1 vssd1 vccd1 vccd1 sky130_fd_sc_hd__fill_1
Xfanout513 cell0.CB_0.config_dataA\[15\] vssd1 vssd1 vccd1 vccd1 net513 sky130_fd_sc_hd__clkbuf_2
Xfanout524 cell0.CB_0.config_dataB\[15\] vssd1 vssd1 vccd1 vccd1 net524 sky130_fd_sc_hd__clkbuf_2
Xfanout502 cell0.CB_1.config_dataB\[11\] vssd1 vssd1 vccd1 vccd1 net502 sky130_fd_sc_hd__clkbuf_2
XANTENNA_input5_A CBeast_in[13] vssd1 vssd1 vccd1 vccd1 sky130_fd_sc_hd__diode_2
X_09835_ bus3_2\[12\] bus3_2\[14\] bus3_2\[13\] bus3_2\[15\] net440 net442 vssd1 vssd1
+ vccd1 vccd1 _04841_ sky130_fd_sc_hd__mux4_1
XTAP_TAPCELL_ROW_70_1357 vssd1 vccd1 sky130_fd_sc_hd__tapvpwrvgnd_1
Xfanout546 net547 vssd1 vssd1 vccd1 vccd1 net546 sky130_fd_sc_hd__buf_2
Xfanout557 net559 vssd1 vssd1 vccd1 vccd1 net557 sky130_fd_sc_hd__clkbuf_2
Xfanout535 cell0.CB_1.config_dataA\[16\] vssd1 vssd1 vccd1 vccd1 net535 sky130_fd_sc_hd__clkbuf_2
Xfanout568 net575 vssd1 vssd1 vccd1 vccd1 net568 sky130_fd_sc_hd__buf_2
XANTENNA_fanout667_A net672 vssd1 vssd1 vccd1 vccd1 sky130_fd_sc_hd__diode_2
Xfanout579 net581 vssd1 vssd1 vccd1 vccd1 net579 sky130_fd_sc_hd__clkbuf_4
X_09766_ _04260_ _04757_ _04758_ _04197_ cell2.CB_1.config_dataA\[7\] vssd1 vssd1
+ vccd1 vccd1 _04772_ sky130_fd_sc_hd__a221o_1
XFILLER_100_354 vssd1 vssd1 vccd1 vccd1 sky130_fd_sc_hd__fill_1
XFILLER_86_577 vssd1 vssd1 vccd1 vccd1 sky130_fd_sc_hd__fill_1
X_06978_ _02017_ _02041_ _02043_ vssd1 vssd1 vccd1 vccd1 _02044_ sky130_fd_sc_hd__a21o_1
XANTENNA__08750__A2 _03504_ vssd1 vssd1 vccd1 vccd1 sky130_fd_sc_hd__diode_2
XANTENNA__11098__A0 net49 vssd1 vssd1 vccd1 vccd1 sky130_fd_sc_hd__diode_2
X_09697_ cell3.SB0.route_sel\[112\] cell3.SB0.route_sel\[113\] net282 _04709_ vssd1
+ vssd1 vccd1 vccd1 _04711_ sky130_fd_sc_hd__a22o_1
X_08717_ net455 _03468_ vssd1 vssd1 vccd1 vccd1 _03751_ sky130_fd_sc_hd__nand2_1
XFILLER_26_110 vssd1 vssd1 vccd1 vccd1 sky130_fd_sc_hd__fill_2
XFILLER_26_154 vssd1 vssd1 vccd1 vccd1 sky130_fd_sc_hd__fill_1
X_08648_ net457 _03679_ _03680_ _03681_ vssd1 vssd1 vccd1 vccd1 _03682_ sky130_fd_sc_hd__a31o_1
XANTENNA_fanout622_X net622 vssd1 vssd1 vccd1 vccd1 sky130_fd_sc_hd__diode_2
X_08579_ net331 net326 net336 net323 cell1.LEI0.config_data\[30\] cell1.LEI0.config_data\[31\]
+ vssd1 vssd1 vccd1 vccd1 _03615_ sky130_fd_sc_hd__mux4_1
XFILLER_25_55 vssd1 vssd1 vccd1 vccd1 sky130_fd_sc_hd__fill_1
XFILLER_25_77 vssd1 vssd1 vccd1 vccd1 sky130_fd_sc_hd__fill_8
X_10610_ _01785_ net396 vssd1 vssd1 vccd1 vccd1 _05568_ sky130_fd_sc_hd__nor2_1
X_11590_ net538 net540 net790 vssd1 vssd1 vccd1 vccd1 _00031_ sky130_fd_sc_hd__mux2_1
X_10541_ cell3.SB0.route_sel\[22\] _01692_ vssd1 vssd1 vccd1 vccd1 _05499_ sky130_fd_sc_hd__nand2_1
XFILLER_127_207 vssd1 vssd1 vccd1 vccd1 sky130_fd_sc_hd__fill_1
X_13260_ clknet_leaf_121_clk _00232_ net580 vssd1 vssd1 vccd1 vccd1 cell0.LEI0.config_data\[45\]
+ sky130_fd_sc_hd__dfrtp_1
XANTENNA__11022__A0 _05893_ vssd1 vssd1 vccd1 vccd1 sky130_fd_sc_hd__diode_2
XFILLER_108_421 vssd1 vssd1 vccd1 vccd1 sky130_fd_sc_hd__fill_4
XANTENNA__09766__A1 _04260_ vssd1 vssd1 vccd1 vccd1 sky130_fd_sc_hd__diode_2
X_10472_ cell3.SB0.route_sel\[120\] cell3.SB0.route_sel\[121\] vssd1 vssd1 vccd1 vccd1
+ _05455_ sky130_fd_sc_hd__nor2_1
X_12211_ cell2.CB_1.config_dataA\[24\] cell2.CB_1.config_dataA\[23\] net836 vssd1
+ vssd1 vccd1 vccd1 _00644_ sky130_fd_sc_hd__mux2_1
XANTENNA__08569__A2 net6 vssd1 vssd1 vccd1 vccd1 sky130_fd_sc_hd__diode_2
XFILLER_123_402 vssd1 vssd1 vccd1 vccd1 sky130_fd_sc_hd__fill_1
XANTENNA__09766__B2 _04197_ vssd1 vssd1 vccd1 vccd1 sky130_fd_sc_hd__diode_2
XANTENNA__10525__X _05483_ vssd1 vssd1 vccd1 vccd1 sky130_fd_sc_hd__diode_2
X_13191_ clknet_1_1__leaf_cell0.LE_1A.sel_clk _00163_ net751 vssd1 vssd1 vccd1 vccd1
+ cell0.LE_1A.dff1_out sky130_fd_sc_hd__dfstp_1
XFILLER_108_498 vssd1 vssd1 vccd1 vccd1 sky130_fd_sc_hd__fill_4
X_12142_ net1400 net1338 net893 vssd1 vssd1 vccd1 vccd1 _00575_ sky130_fd_sc_hd__mux2_1
X_12073_ net1194 cell1.LE_0B.config_data\[0\] net903 vssd1 vssd1 vccd1 vccd1 _00508_
+ sky130_fd_sc_hd__mux2_1
X_11024_ _05901_ _05964_ cell3.CB_0.config_dataA\[12\] vssd1 vssd1 vccd1 vccd1 _05978_
+ sky130_fd_sc_hd__o21ai_1
XFILLER_2_15 vccd1 vssd1 vccd1 vssd1 sky130_ef_sc_hd__decap_40_12
XANTENNA__11356__X net189 vssd1 vssd1 vccd1 vccd1 sky130_fd_sc_hd__diode_2
XFILLER_89_393 vssd1 vssd1 vccd1 vccd1 sky130_fd_sc_hd__fill_1
XTAP_TAPCELL_ROW_88_1629 vssd1 vccd1 sky130_fd_sc_hd__tapvpwrvgnd_1
XFILLER_49_279 vssd1 vssd1 vccd1 vccd1 sky130_fd_sc_hd__fill_1
XANTENNA__08741__A2 net6 vssd1 vssd1 vccd1 vccd1 sky130_fd_sc_hd__diode_2
XANTENNA_input16_X net16 vssd1 vssd1 vccd1 vccd1 sky130_fd_sc_hd__diode_2
X_12975_ cell3.LE_0A.reset_val cell3.LE_0A.edge_mode net929 vssd1 vssd1 vccd1 vccd1
+ _01403_ sky130_fd_sc_hd__mux2_1
XFILLER_92_558 vssd1 vssd1 vccd1 vccd1 sky130_fd_sc_hd__fill_4
XFILLER_80_709 vssd1 vssd1 vccd1 vccd1 sky130_fd_sc_hd__fill_2
XFILLER_45_452 vssd1 vssd1 vccd1 vccd1 sky130_fd_sc_hd__fill_1
XANTENNA__08097__B _02585_ vssd1 vssd1 vccd1 vccd1 sky130_fd_sc_hd__diode_2
XANTENNA_output217_A net217 vssd1 vssd1 vccd1 vccd1 sky130_fd_sc_hd__diode_2
X_11926_ cell0.SB0.route_sel\[32\] cell0.SB0.route_sel\[31\] net760 vssd1 vssd1 vccd1
+ vccd1 _00363_ sky130_fd_sc_hd__mux2_1
XFILLER_73_783 vssd1 vssd1 vccd1 vccd1 sky130_fd_sc_hd__fill_1
XFILLER_32_113 vssd1 vssd1 vccd1 vccd1 sky130_fd_sc_hd__fill_1
XANTENNA__11091__X cell3.CB_0.le_outA vssd1 vssd1 vccd1 vccd1 sky130_fd_sc_hd__diode_2
X_11857_ cell1.CB_0.config_dataB\[13\] cell1.CB_0.config_dataB\[12\] net895 vssd1
+ vssd1 vccd1 vccd1 _00294_ sky130_fd_sc_hd__mux2_1
XFILLER_60_444 vssd1 vssd1 vccd1 vccd1 sky130_fd_sc_hd__fill_4
X_10808_ _05763_ _05489_ _05484_ _05761_ vssd1 vssd1 vccd1 vccd1 _05764_ sky130_fd_sc_hd__a2bb2o_1
XFILLER_82_94 vssd1 vssd1 vccd1 vccd1 sky130_fd_sc_hd__fill_1
X_11788_ cell0.LEI0.config_data\[38\] net1471 net793 vssd1 vssd1 vccd1 vccd1 _00225_
+ sky130_fd_sc_hd__mux2_1
XANTENNA__08257__A1 net347 vssd1 vssd1 vccd1 vccd1 sky130_fd_sc_hd__diode_2
XANTENNA__11261__A0 _05136_ vssd1 vssd1 vccd1 vccd1 sky130_fd_sc_hd__diode_2
X_10739_ net17 net18 net19 net20 net371 cell3.CB_1.config_dataB\[1\] vssd1 vssd1 vccd1
+ vccd1 _05695_ sky130_fd_sc_hd__mux4_1
X_13527_ clknet_leaf_101_clk _00499_ net682 vssd1 vssd1 vccd1 vccd1 cell1.LE_1A.config_data\[14\]
+ sky130_fd_sc_hd__dfrtp_1
XANTENNA__08009__A1 bus2_0\[1\] vssd1 vssd1 vccd1 vccd1 sky130_fd_sc_hd__diode_2
XANTENNA__09757__A1 bus3_2\[9\] vssd1 vssd1 vccd1 vccd1 sky130_fd_sc_hd__diode_2
X_13458_ clknet_leaf_2_clk _00430_ net569 vssd1 vssd1 vccd1 vccd1 cell0.SB0.route_sel\[99\]
+ sky130_fd_sc_hd__dfstp_1
X_12409_ cell2.CB_1.config_dataB\[19\] cell2.CB_1.config_dataB\[18\] net837 vssd1
+ vssd1 vccd1 vccd1 _00842_ sky130_fd_sc_hd__mux2_1
XANTENNA__09656__B _04670_ vssd1 vssd1 vccd1 vccd1 sky130_fd_sc_hd__diode_2
XANTENNA__10435__X bus3_2\[2\] vssd1 vssd1 vccd1 vccd1 sky130_fd_sc_hd__diode_2
X_13389_ clknet_leaf_133_clk _00361_ net556 vssd1 vssd1 vccd1 vccd1 cell0.SB0.route_sel\[30\]
+ sky130_fd_sc_hd__dfstp_1
XFILLER_99_113 vssd1 vssd1 vccd1 vccd1 sky130_fd_sc_hd__fill_2
Xoutput149 net149 vssd1 vssd1 vccd1 vccd1 CBeast_out[23] sky130_fd_sc_hd__buf_2
Xoutput138 net138 vssd1 vssd1 vccd1 vccd1 CBeast_out[13] sky130_fd_sc_hd__buf_2
XFILLER_88_809 vssd1 vssd1 vccd1 vccd1 sky130_fd_sc_hd__fill_1
X_07950_ _02982_ _02992_ _02993_ _02990_ vssd1 vssd1 vccd1 vccd1 _02994_ sky130_fd_sc_hd__o22a_1
XTAP_TAPCELL_ROW_110_1958 vssd1 vccd1 sky130_fd_sc_hd__tapvpwrvgnd_1
XFILLER_101_107 vssd1 vssd1 vccd1 vccd1 sky130_fd_sc_hd__fill_2
X_06901_ cell1.SB0.route_sel\[58\] cell1.SB0.route_sel\[59\] _01960_ _01961_ _01968_
+ vssd1 vssd1 vccd1 vccd1 _01969_ sky130_fd_sc_hd__a41o_1
XFILLER_96_842 vssd1 vssd1 vccd1 vccd1 sky130_fd_sc_hd__fill_2
X_07881_ _02905_ _02920_ _02921_ _02902_ cell0.CB_0.config_dataA\[2\] vssd1 vssd1
+ vccd1 vccd1 _02925_ sky130_fd_sc_hd__a221o_1
X_06832_ cell2.CB_1.config_dataA\[23\] cell2.CB_1.config_dataA\[22\] vssd1 vssd1 vccd1
+ vccd1 _01901_ sky130_fd_sc_hd__nand2b_1
X_09620_ cell1.CB_0.le_outA _02366_ cell3.SB0.route_sel\[101\] cell3.SB0.route_sel\[100\]
+ vssd1 vssd1 vccd1 vccd1 _04636_ sky130_fd_sc_hd__a2bb2o_1
XTAP_TAPCELL_ROW_52_1087 vssd1 vccd1 sky130_fd_sc_hd__tapvpwrvgnd_1
XFILLER_28_419 vssd1 vssd1 vccd1 vccd1 sky130_fd_sc_hd__fill_1
X_09551_ _04265_ _04543_ vssd1 vssd1 vccd1 vccd1 _04570_ sky130_fd_sc_hd__nor2_1
X_06763_ net303 vssd1 vssd1 vccd1 vccd1 _01833_ sky130_fd_sc_hd__inv_2
XFILLER_102_27 vssd1 vssd1 vccd1 vccd1 sky130_fd_sc_hd__fill_1
XANTENNA__10827__A0 _05540_ vssd1 vssd1 vccd1 vccd1 sky130_fd_sc_hd__diode_2
XFILLER_70_208 vssd1 vssd1 vccd1 vccd1 sky130_fd_sc_hd__fill_2
X_08502_ cell1.SB0.route_sel\[32\] cell1.SB0.route_sel\[33\] vssd1 vssd1 vccd1 vccd1
+ _03538_ sky130_fd_sc_hd__nand2b_1
X_06694_ cell2.LEI0.config_data\[2\] vssd1 vssd1 vccd1 vccd1 _01764_ sky130_fd_sc_hd__inv_2
X_09482_ _01974_ _01979_ _03880_ vssd1 vssd1 vccd1 vccd1 _04503_ sky130_fd_sc_hd__and3_1
XFILLER_51_444 vssd1 vssd1 vccd1 vccd1 sky130_fd_sc_hd__fill_4
X_08433_ net497 _03468_ vssd1 vssd1 vccd1 vccd1 _03469_ sky130_fd_sc_hd__nand2_1
X_08364_ _03401_ vssd1 vssd1 vccd1 vccd1 _03402_ sky130_fd_sc_hd__inv_2
XANTENNA__09996__A1 _04671_ vssd1 vssd1 vccd1 vccd1 sky130_fd_sc_hd__diode_2
XFILLER_32_680 vssd1 vssd1 vccd1 vccd1 sky130_fd_sc_hd__fill_1
X_07315_ cell1.SB0.route_sel\[97\] cell1.SB0.route_sel\[96\] _02364_ _02372_ net869
+ vssd1 vssd1 vccd1 vccd1 _02373_ sky130_fd_sc_hd__a311oi_4
XFILLER_137_538 vssd1 vssd1 vccd1 vccd1 sky130_fd_sc_hd__fill_1
X_08295_ bus1_0\[6\] bus1_0\[7\] net507 vssd1 vssd1 vccd1 vccd1 _03333_ sky130_fd_sc_hd__mux2_1
X_07246_ net116 cell2.SB0.route_sel\[92\] cell2.SB0.route_sel\[93\] vssd1 vssd1 vccd1
+ vccd1 _02305_ sky130_fd_sc_hd__and3_1
XFILLER_133_700 vssd1 vssd1 vccd1 vccd1 sky130_fd_sc_hd__fill_1
XFILLER_105_402 vssd1 vssd1 vccd1 vccd1 sky130_fd_sc_hd__fill_1
X_07177_ _02202_ _02236_ _02237_ vssd1 vssd1 vccd1 vccd1 _02238_ sky130_fd_sc_hd__a21oi_1
XFILLER_11_57 vccd1 vssd1 vccd1 vssd1 sky130_ef_sc_hd__decap_40_12
XANTENNA__08470__B _03504_ vssd1 vssd1 vccd1 vccd1 sky130_fd_sc_hd__diode_2
XFILLER_127_57 vccd1 vssd1 vccd1 vssd1 sky130_ef_sc_hd__decap_40_12
XFILLER_87_39 vccd1 vssd1 vccd1 vssd1 sky130_ef_sc_hd__decap_40_12
XANTENNA__08971__A2 _01821_ vssd1 vssd1 vccd1 vccd1 sky130_fd_sc_hd__diode_2
XFILLER_133_799 vccd1 vssd1 vccd1 vssd1 sky130_ef_sc_hd__decap_40_12
Xfanout310 net313 vssd1 vssd1 vccd1 vccd1 net310 sky130_fd_sc_hd__clkbuf_2
Xfanout332 cell1.CB_0.le_outA vssd1 vssd1 vccd1 vccd1 net332 sky130_fd_sc_hd__clkbuf_2
Xfanout321 net322 vssd1 vssd1 vccd1 vccd1 net321 sky130_fd_sc_hd__dlymetal6s2s_1
XANTENNA_fanout951_A net952 vssd1 vssd1 vccd1 vccd1 sky130_fd_sc_hd__diode_2
XANTENNA_input8_X net8 vssd1 vssd1 vccd1 vccd1 sky130_fd_sc_hd__diode_2
Xfanout365 cell3.CB_1.config_dataB\[15\] vssd1 vssd1 vccd1 vccd1 net365 sky130_fd_sc_hd__buf_2
Xfanout343 cell0.CB_0.le_outA vssd1 vssd1 vccd1 vccd1 net343 sky130_fd_sc_hd__buf_2
Xfanout354 _02125_ vssd1 vssd1 vccd1 vccd1 net354 sky130_fd_sc_hd__buf_2
Xfanout387 cell3.CB_0.config_dataB\[5\] vssd1 vssd1 vccd1 vccd1 net387 sky130_fd_sc_hd__buf_2
Xfanout376 cell3.CB_0.config_dataA\[6\] vssd1 vssd1 vccd1 vccd1 net376 sky130_fd_sc_hd__clkbuf_2
X_09818_ cell2.CB_1.config_dataA\[4\] _04808_ _04823_ vssd1 vssd1 vccd1 vccd1 _04824_
+ sky130_fd_sc_hd__or3_1
Xfanout398 cell3.CB_1.config_dataA\[0\] vssd1 vssd1 vccd1 vccd1 net398 sky130_fd_sc_hd__clkbuf_4
XANTENNA__10080__X bus3_2\[0\] vssd1 vssd1 vccd1 vccd1 sky130_fd_sc_hd__diode_2
X_09749_ net445 _04583_ net443 vssd1 vssd1 vccd1 vccd1 _04755_ sky130_fd_sc_hd__o21ai_1
XFILLER_100_173 vssd1 vssd1 vccd1 vccd1 sky130_fd_sc_hd__fill_4
XFILLER_36_10 vccd1 vssd1 vccd1 vssd1 sky130_ef_sc_hd__decap_40_12
XANTENNA_fanout837_X net837 vssd1 vssd1 vccd1 vccd1 sky130_fd_sc_hd__diode_2
XANTENNA__09684__B1 net316 vssd1 vssd1 vccd1 vccd1 sky130_fd_sc_hd__diode_2
X_12760_ cell2.SB0.route_sel\[2\] cell2.SB0.route_sel\[1\] net830 vssd1 vssd1 vccd1
+ vccd1 _01189_ sky130_fd_sc_hd__mux2_1
XANTENNA_input115_A SBwest_in[26] vssd1 vssd1 vccd1 vccd1 sky130_fd_sc_hd__diode_2
XFILLER_36_65 vssd1 vssd1 vccd1 vccd1 sky130_fd_sc_hd__fill_8
XANTENNA__10294__A1 net44 vssd1 vssd1 vccd1 vccd1 sky130_fd_sc_hd__diode_2
X_12691_ cell3.CB_1.config_dataA\[8\] cell3.CB_1.config_dataA\[7\] net944 vssd1 vssd1
+ vccd1 vccd1 _01120_ sky130_fd_sc_hd__mux2_1
XTAP_TAPCELL_ROW_83_1559 vssd1 vccd1 sky130_fd_sc_hd__tapvpwrvgnd_1
XTAP_TAPCELL_ROW_83_1548 vssd1 vccd1 sky130_fd_sc_hd__tapvpwrvgnd_1
X_11711_ net1210 cell0.LE_0B.config_data\[6\] net805 vssd1 vssd1 vccd1 vccd1 _00150_
+ sky130_fd_sc_hd__mux2_1
X_14430_ clknet_leaf_55_clk _01402_ net718 vssd1 vssd1 vccd1 vccd1 cell3.LE_0A.edge_mode
+ sky130_fd_sc_hd__dfstp_1
X_11642_ cell0.CB_0.config_dataA\[13\] cell0.CB_0.config_dataA\[12\] net771 vssd1
+ vssd1 vccd1 vccd1 _00083_ sky130_fd_sc_hd__mux2_1
XANTENNA__08645__B _03509_ vssd1 vssd1 vccd1 vccd1 sky130_fd_sc_hd__diode_2
XANTENNA__08239__A1 bus1_0\[9\] vssd1 vssd1 vccd1 vccd1 sky130_fd_sc_hd__diode_2
X_14361_ clknet_leaf_73_clk _01333_ net733 vssd1 vssd1 vccd1 vccd1 cell3.CB_1.config_dataB\[18\]
+ sky130_fd_sc_hd__dfstp_1
XTAP_TAPCELL_ROW_25_686 vssd1 vccd1 sky130_fd_sc_hd__tapvpwrvgnd_1
Xinput18 CBeast_in[25] vssd1 vssd1 vccd1 vccd1 net18 sky130_fd_sc_hd__clkbuf_4
XANTENNA__10597__A2 _05553_ vssd1 vssd1 vccd1 vccd1 sky130_fd_sc_hd__diode_2
X_13312_ clknet_leaf_75_clk _00284_ net690 vssd1 vssd1 vccd1 vccd1 cell1.CB_0.config_dataB\[3\]
+ sky130_fd_sc_hd__dfstp_1
X_11573_ net1332 net1262 net799 vssd1 vssd1 vccd1 vccd1 _00014_ sky130_fd_sc_hd__mux2_1
XANTENNA_input80_A SBsouth_in[23] vssd1 vssd1 vccd1 vccd1 sky130_fd_sc_hd__diode_2
XFILLER_128_549 vssd1 vssd1 vccd1 vccd1 sky130_fd_sc_hd__fill_1
XTAP_TAPCELL_ROW_114_2014 vssd1 vccd1 sky130_fd_sc_hd__tapvpwrvgnd_1
X_10524_ _01707_ cell3.SB0.route_sel\[47\] _05481_ vssd1 vssd1 vccd1 vccd1 _05482_
+ sky130_fd_sc_hd__o21ai_2
Xinput29 CBeast_in[6] vssd1 vssd1 vccd1 vccd1 net29 sky130_fd_sc_hd__clkbuf_4
X_14292_ clknet_leaf_8_clk _01264_ net573 vssd1 vssd1 vccd1 vccd1 cell2.SB0.route_sel\[77\]
+ sky130_fd_sc_hd__dfstp_1
XFILLER_7_835 vssd1 vssd1 vccd1 vccd1 sky130_fd_sc_hd__fill_1
XFILLER_6_334 vssd1 vssd1 vccd1 vccd1 sky130_fd_sc_hd__fill_2
XTAP_TAPCELL_ROW_114_2025 vssd1 vccd1 sky130_fd_sc_hd__tapvpwrvgnd_1
XTAP_TAPCELL_ROW_98_1780 vssd1 vccd1 sky130_fd_sc_hd__tapvpwrvgnd_1
X_10455_ cell3.SB0.route_sel\[72\] cell3.SB0.route_sel\[73\] _01727_ cell3.SB0.route_sel\[76\]
+ _05443_ vssd1 vssd1 vccd1 vccd1 _05444_ sky130_fd_sc_hd__o221a_1
X_13243_ clknet_leaf_11_clk net1418 net586 vssd1 vssd1 vccd1 vccd1 cell0.LEI0.config_data\[28\]
+ sky130_fd_sc_hd__dfrtp_1
X_13174_ clknet_leaf_118_clk _00146_ net598 vssd1 vssd1 vccd1 vccd1 cell0.LE_0B.config_data\[3\]
+ sky130_fd_sc_hd__dfrtp_1
XANTENNA_output167_A net167 vssd1 vssd1 vccd1 vccd1 sky130_fd_sc_hd__diode_2
X_10386_ cell2.CB_0.config_dataB\[16\] net425 vssd1 vssd1 vccd1 vccd1 _05385_ sky130_fd_sc_hd__and2b_1
XFILLER_97_617 vssd1 vssd1 vccd1 vccd1 sky130_fd_sc_hd__fill_1
XFILLER_97_606 vssd1 vssd1 vccd1 vccd1 sky130_fd_sc_hd__fill_1
X_12125_ net1354 cell1.LEI0.config_data\[6\] net899 vssd1 vssd1 vccd1 vccd1 _00558_
+ sky130_fd_sc_hd__mux2_1
X_12056_ net1115 net1031 net889 vssd1 vssd1 vccd1 vccd1 _00492_ sky130_fd_sc_hd__mux2_1
X_11007_ cell3.CB_0.config_dataA\[9\] _05944_ _05958_ _05960_ vssd1 vssd1 vccd1 vccd1
+ _05961_ sky130_fd_sc_hd__o31a_2
XTAP_TAPCELL_ROW_125_2176 vssd1 vccd1 sky130_fd_sc_hd__tapvpwrvgnd_1
XTAP_TAPCELL_ROW_125_2187 vssd1 vccd1 sky130_fd_sc_hd__tapvpwrvgnd_1
X_12958_ net1233 cell3.LE_0A.config_data\[0\] net927 vssd1 vssd1 vccd1 vccd1 _01386_
+ sky130_fd_sc_hd__mux2_1
XFILLER_46_794 vssd1 vssd1 vccd1 vccd1 sky130_fd_sc_hd__fill_1
X_12889_ cell3.CB_1.config_dataB\[3\] cell3.CB_1.config_dataB\[2\] net943 vssd1 vssd1
+ vccd1 vccd1 _01318_ sky130_fd_sc_hd__mux2_1
XANTENNA__10824__A3 net20 vssd1 vssd1 vccd1 vccd1 sky130_fd_sc_hd__diode_2
X_11909_ cell0.SB0.route_sel\[15\] cell0.SB0.route_sel\[14\] net762 vssd1 vssd1 vccd1
+ vccd1 _00346_ sky130_fd_sc_hd__mux2_1
XANTENNA__07150__A1 net361 vssd1 vssd1 vccd1 vccd1 sky130_fd_sc_hd__diode_2
XTAP_TAPCELL_ROW_44_973 vssd1 vccd1 sky130_fd_sc_hd__tapvpwrvgnd_1
XTAP_TAPCELL_ROW_44_962 vssd1 vccd1 sky130_fd_sc_hd__tapvpwrvgnd_1
XANTENNA__10588__A2 _05540_ vssd1 vssd1 vccd1 vccd1 sky130_fd_sc_hd__diode_2
X_07100_ _02088_ _02162_ vssd1 vssd1 vccd1 vccd1 _02163_ sky130_fd_sc_hd__nor2_1
X_08080_ _03121_ _03088_ _03057_ vssd1 vssd1 vccd1 vccd1 _03122_ sky130_fd_sc_hd__mux2_1
X_07031_ cell2.CB_0.config_dataB\[22\] cell2.CB_0.config_dataB\[23\] vssd1 vssd1 vccd1
+ vccd1 _02096_ sky130_fd_sc_hd__and2b_1
XANTENNA__09386__B _04409_ vssd1 vssd1 vccd1 vccd1 sky130_fd_sc_hd__diode_2
XANTENNA__12093__A net756 vssd1 vssd1 vccd1 vccd1 sky130_fd_sc_hd__diode_2
XTAP_TAPCELL_ROW_54_1116 vssd1 vccd1 sky130_fd_sc_hd__tapvpwrvgnd_1
X_08982_ cell1.LE_0A.config_data\[9\] cell1.LE_0A.config_data\[8\] _03936_ vssd1 vssd1
+ vccd1 vccd1 _04014_ sky130_fd_sc_hd__mux2_1
X_07933_ cell0.LEI0.config_data\[26\] _02976_ vssd1 vssd1 vccd1 vccd1 _02977_ sky130_fd_sc_hd__nor2_1
X_07864_ cell0.CB_0.config_dataA\[8\] cell0.CB_0.config_dataA\[7\] vssd1 vssd1 vccd1
+ vccd1 _02908_ sky130_fd_sc_hd__or2_1
XANTENNA__08705__A2 net23 vssd1 vssd1 vccd1 vccd1 sky130_fd_sc_hd__diode_2
XFILLER_113_15 vccd1 vssd1 vccd1 vssd1 sky130_ef_sc_hd__decap_40_12
X_09603_ net363 net362 _04358_ vssd1 vssd1 vccd1 vccd1 _04620_ sky130_fd_sc_hd__nand3b_1
X_06815_ cell1.CB_0.config_dataA\[23\] cell1.CB_0.config_dataA\[22\] vssd1 vssd1 vccd1
+ vccd1 _01885_ sky130_fd_sc_hd__nand2b_1
XTAP_TAPCELL_ROW_3_359 vssd1 vccd1 sky130_fd_sc_hd__tapvpwrvgnd_1
XTAP_TAPCELL_ROW_3_348 vssd1 vccd1 sky130_fd_sc_hd__tapvpwrvgnd_1
XANTENNA__08181__A3 bus1_0\[15\] vssd1 vssd1 vccd1 vccd1 sky130_fd_sc_hd__diode_2
XANTENNA__11871__S net883 vssd1 vssd1 vccd1 vccd1 sky130_fd_sc_hd__diode_2
X_07795_ _02833_ _02837_ _02838_ _02834_ vssd1 vssd1 vccd1 vccd1 _02840_ sky130_fd_sc_hd__o31a_1
X_09534_ cell2.SB0.route_sel\[72\] _01624_ cell2.SB0.route_sel\[77\] cell2.SB0.route_sel\[76\]
+ vssd1 vssd1 vccd1 vccd1 _04553_ sky130_fd_sc_hd__o22a_1
X_06746_ cell0.SB0.route_sel\[9\] vssd1 vssd1 vccd1 vccd1 _01816_ sky130_fd_sc_hd__inv_2
X_09465_ _04315_ _04414_ vssd1 vssd1 vccd1 vccd1 _04487_ sky130_fd_sc_hd__nor2_1
X_06677_ cell3.SB0.route_sel\[121\] vssd1 vssd1 vccd1 vccd1 _01747_ sky130_fd_sc_hd__inv_2
XTAP_TAPCELL_ROW_65_1289 vssd1 vccd1 sky130_fd_sc_hd__tapvpwrvgnd_1
XTAP_TAPCELL_ROW_65_1278 vssd1 vccd1 sky130_fd_sc_hd__tapvpwrvgnd_1
X_08416_ cell0.LE_1B.config_data\[11\] cell0.LE_1B.config_data\[10\] _03380_ vssd1
+ vssd1 vccd1 vccd1 _03454_ sky130_fd_sc_hd__mux2_1
XANTENNA__09418__B1 net551 vssd1 vssd1 vccd1 vccd1 sky130_fd_sc_hd__diode_2
X_09396_ cell3.SB0.route_sel\[38\] cell3.SB0.route_sel\[39\] vssd1 vssd1 vccd1 vccd1
+ _04420_ sky130_fd_sc_hd__nor2_1
XTAP_TAPCELL_ROW_22_634 vssd1 vccd1 sky130_fd_sc_hd__tapvpwrvgnd_1
XFILLER_138_825 vccd1 vssd1 vccd1 vssd1 sky130_ef_sc_hd__decap_40_12
XFILLER_132_7 vccd1 vssd1 vccd1 vssd1 sky130_ef_sc_hd__decap_40_12
XFILLER_7_109 vssd1 vssd1 vccd1 vccd1 sky130_fd_sc_hd__fill_2
X_08347_ _02422_ _02424_ _03384_ vssd1 vssd1 vccd1 vccd1 _03385_ sky130_fd_sc_hd__o21ai_1
XFILLER_22_23 vssd1 vssd1 vccd1 vccd1 sky130_fd_sc_hd__fill_4
XTAP_TAPCELL_ROW_22_645 vssd1 vccd1 sky130_fd_sc_hd__tapvpwrvgnd_1
X_08278_ net505 net506 vssd1 vssd1 vccd1 vccd1 _03316_ sky130_fd_sc_hd__nor2_1
XFILLER_118_560 vssd1 vssd1 vccd1 vccd1 sky130_fd_sc_hd__fill_1
XANTENNA__07995__A3 bus2_0\[11\] vssd1 vssd1 vccd1 vccd1 sky130_fd_sc_hd__diode_2
X_07229_ _01970_ _02058_ vssd1 vssd1 vccd1 vccd1 _02289_ sky130_fd_sc_hd__or2_1
X_10240_ net412 net411 _05139_ cell2.CB_0.config_dataA\[17\] vssd1 vssd1 vccd1 vccd1
+ _05241_ sky130_fd_sc_hd__o31ai_1
XFILLER_98_27 vssd1 vssd1 vccd1 vccd1 sky130_fd_sc_hd__fill_1
XFILLER_133_541 vssd1 vssd1 vccd1 vccd1 sky130_fd_sc_hd__fill_1
XFILLER_3_337 vccd1 vssd1 vccd1 vssd1 sky130_ef_sc_hd__decap_40_12
XANTENNA_fanout787_X net787 vssd1 vssd1 vccd1 vccd1 sky130_fd_sc_hd__diode_2
X_10171_ net422 _05148_ vssd1 vssd1 vccd1 vccd1 _05172_ sky130_fd_sc_hd__or2_1
XANTENNA_hold198_X net1157 vssd1 vssd1 vccd1 vccd1 sky130_fd_sc_hd__diode_2
XPHY_EDGE_ROW_110_Right_110 vssd1 vssd1 vccd1 vccd1 sky130_fd_sc_hd__decap_3
X_13930_ clknet_leaf_25_clk _00902_ net609 vssd1 vssd1 vccd1 vccd1 cell2.LE_0A.config_data\[9\]
+ sky130_fd_sc_hd__dfrtp_1
XANTENNA__07544__B _02592_ vssd1 vssd1 vccd1 vccd1 sky130_fd_sc_hd__diode_2
X_13861_ clknet_leaf_42_clk _00833_ net641 vssd1 vssd1 vccd1 vccd1 cell2.CB_1.config_dataB\[10\]
+ sky130_fd_sc_hd__dfstp_1
XFILLER_90_804 vssd1 vssd1 vccd1 vccd1 sky130_fd_sc_hd__fill_1
XANTENNA__11059__A3 net43 vssd1 vssd1 vccd1 vccd1 sky130_fd_sc_hd__diode_2
X_12812_ cell2.SB0.route_sel\[54\] cell2.SB0.route_sel\[53\] net811 vssd1 vssd1 vccd1
+ vccd1 _01241_ sky130_fd_sc_hd__mux2_1
X_13792_ clknet_leaf_104_clk _00764_ net662 vssd1 vssd1 vccd1 vccd1 cell1.SB0.route_sel\[69\]
+ sky130_fd_sc_hd__dfstp_1
XANTENNA_clkbuf_leaf_70_clk_A clknet_4_14_0_clk vssd1 vssd1 vccd1 vccd1 sky130_fd_sc_hd__diode_2
X_12743_ net375 cell3.CB_0.config_dataA\[9\] net927 vssd1 vssd1 vccd1 vccd1 _01172_
+ sky130_fd_sc_hd__mux2_1
XANTENNA__07560__A net358 vssd1 vssd1 vccd1 vccd1 sky130_fd_sc_hd__diode_2
XFILLER_15_444 vssd1 vssd1 vccd1 vccd1 sky130_fd_sc_hd__fill_1
XANTENNA__07132__A1 net361 vssd1 vssd1 vccd1 vccd1 sky130_fd_sc_hd__diode_2
X_12674_ net1229 net1344 net955 vssd1 vssd1 vccd1 vccd1 _01103_ sky130_fd_sc_hd__mux2_1
X_14413_ clknet_leaf_40_clk _01385_ net643 vssd1 vssd1 vccd1 vccd1 cell3.LE_0A.config_data\[0\]
+ sky130_fd_sc_hd__dfrtp_1
XTAP_TAPCELL_ROW_41_921 vssd1 vccd1 sky130_fd_sc_hd__tapvpwrvgnd_1
X_11625_ cell0.CB_0.config_dataB\[21\] cell0.CB_0.config_dataB\[20\] net795 vssd1
+ vssd1 vccd1 vccd1 _00066_ sky130_fd_sc_hd__mux2_1
XFILLER_11_650 vccd1 vssd1 vccd1 vssd1 sky130_ef_sc_hd__decap_40_12
XANTENNA_clkbuf_leaf_85_clk_A clknet_4_11_0_clk vssd1 vssd1 vccd1 vccd1 sky130_fd_sc_hd__diode_2
X_14344_ clknet_leaf_76_clk _01316_ net726 vssd1 vssd1 vccd1 vccd1 cell3.CB_1.config_dataB\[1\]
+ sky130_fd_sc_hd__dfstp_1
XANTENNA_input83_X net83 vssd1 vssd1 vccd1 vccd1 sky130_fd_sc_hd__diode_2
X_11556_ cell0.SB0.route_sel\[28\] cell0.SB0.route_sel\[29\] vssd1 vssd1 vccd1 vccd1
+ _06371_ sky130_fd_sc_hd__nand2b_1
XFILLER_11_694 vccd1 vssd1 vccd1 vssd1 sky130_ef_sc_hd__decap_40_12
XANTENNA__07559__X _02609_ vssd1 vssd1 vccd1 vccd1 sky130_fd_sc_hd__diode_2
X_14275_ clknet_leaf_22_clk _01247_ net604 vssd1 vssd1 vccd1 vccd1 cell2.SB0.route_sel\[60\]
+ sky130_fd_sc_hd__dfstp_1
XFILLER_7_665 vssd1 vssd1 vccd1 vccd1 sky130_fd_sc_hd__fill_4
XFILLER_10_193 vssd1 vssd1 vccd1 vccd1 sky130_fd_sc_hd__fill_1
X_10507_ _02357_ _03498_ _02361_ _02360_ vssd1 vssd1 vccd1 vccd1 _05469_ sky130_fd_sc_hd__o211a_1
X_11487_ cell2.SB0.route_sel\[4\] cell2.SB0.route_sel\[5\] vssd1 vssd1 vccd1 vccd1
+ _06325_ sky130_fd_sc_hd__nand2b_1
X_13226_ clknet_leaf_121_clk _00198_ net593 vssd1 vssd1 vccd1 vccd1 cell0.LEI0.config_data\[11\]
+ sky130_fd_sc_hd__dfrtp_2
X_10438_ _05432_ _04371_ vssd1 vssd1 vccd1 vccd1 bus3_2\[3\] sky130_fd_sc_hd__and2b_2
XFILLER_6_197 vssd1 vssd1 vccd1 vccd1 sky130_fd_sc_hd__fill_1
X_10369_ net429 _05088_ _05367_ net427 vssd1 vssd1 vccd1 vccd1 _05368_ sky130_fd_sc_hd__o211a_1
X_13157_ clknet_leaf_115_clk _00129_ net665 vssd1 vssd1 vccd1 vccd1 cell0.LE_1A.config_data\[8\]
+ sky130_fd_sc_hd__dfrtp_1
XFILLER_97_447 vssd1 vssd1 vccd1 vccd1 sky130_fd_sc_hd__fill_1
XANTENNA__11528__Y net251 vssd1 vssd1 vccd1 vccd1 sky130_fd_sc_hd__diode_2
X_12108_ net1037 cell1.LE_0A.config_data\[12\] net878 vssd1 vssd1 vccd1 vccd1 _00542_
+ sky130_fd_sc_hd__mux2_1
X_13088_ clknet_leaf_4_clk _00060_ net564 vssd1 vssd1 vccd1 vccd1 cell0.CB_0.config_dataB\[15\]
+ sky130_fd_sc_hd__dfstp_1
XANTENNA__08148__A0 bus1_0\[0\] vssd1 vssd1 vccd1 vccd1 sky130_fd_sc_hd__diode_2
XTAP_TAPCELL_ROW_127_2216 vssd1 vccd1 sky130_fd_sc_hd__tapvpwrvgnd_1
XFILLER_84_119 vssd1 vssd1 vccd1 vccd1 sky130_fd_sc_hd__fill_1
XANTENNA_clkbuf_leaf_23_clk_A clknet_4_4_0_clk vssd1 vssd1 vccd1 vccd1 sky130_fd_sc_hd__diode_2
X_12039_ cell1.CB_1.config_dataB\[17\] net451 net892 vssd1 vssd1 vccd1 vccd1 _00476_
+ sky130_fd_sc_hd__mux2_1
XFILLER_66_834 vssd1 vssd1 vccd1 vccd1 sky130_fd_sc_hd__fill_1
XFILLER_19_3 vccd1 vssd1 vccd1 vssd1 sky130_ef_sc_hd__decap_40_12
XTAP_TAPCELL_ROW_140_2405 vssd1 vccd1 sky130_fd_sc_hd__tapvpwrvgnd_1
XFILLER_93_675 vssd1 vssd1 vccd1 vccd1 sky130_fd_sc_hd__fill_1
Xclkbuf_4_1_0_clk clknet_0_clk vssd1 vssd1 vccd1 vccd1 clknet_4_1_0_clk sky130_fd_sc_hd__clkbuf_8
XTAP_TAPCELL_ROW_0_307 vssd1 vccd1 sky130_fd_sc_hd__tapvpwrvgnd_1
XANTENNA_clkbuf_leaf_38_clk_A clknet_4_7_0_clk vssd1 vssd1 vccd1 vccd1 sky130_fd_sc_hd__diode_2
XFILLER_93_686 vssd1 vssd1 vccd1 vccd1 sky130_fd_sc_hd__fill_1
XFILLER_92_185 vssd1 vssd1 vccd1 vccd1 sky130_fd_sc_hd__fill_1
X_06600_ cell1.CB_0.config_dataB\[7\] vssd1 vssd1 vccd1 vccd1 _01670_ sky130_fd_sc_hd__inv_2
X_07580_ cell0.SB0.route_sel\[1\] cell0.SB0.route_sel\[0\] _02619_ _02629_ net781
+ vssd1 vssd1 vccd1 vccd1 _02630_ sky130_fd_sc_hd__a311o_4
XFILLER_19_783 vssd1 vssd1 vccd1 vccd1 sky130_fd_sc_hd__fill_1
XANTENNA__10258__A1 net37 vssd1 vssd1 vccd1 vccd1 sky130_fd_sc_hd__diode_2
X_06531_ cell2.SB0.route_sel\[39\] vssd1 vssd1 vccd1 vccd1 _01601_ sky130_fd_sc_hd__inv_2
XTAP_TAPCELL_ROW_105_1879 vssd1 vccd1 sky130_fd_sc_hd__tapvpwrvgnd_1
X_09250_ _01887_ _02649_ _02738_ _03857_ vssd1 vssd1 vccd1 vccd1 _04276_ sky130_fd_sc_hd__a211o_1
XANTENNA__08853__X _03885_ vssd1 vssd1 vccd1 vccd1 sky130_fd_sc_hd__diode_2
X_08201_ _02136_ _03233_ _03239_ _03240_ cell0.CB_1.config_dataA\[12\] vssd1 vssd1
+ vccd1 vccd1 _03241_ sky130_fd_sc_hd__a2111o_1
X_06462_ cell1.SB0.route_sel\[79\] vssd1 vssd1 vccd1 vccd1 _01532_ sky130_fd_sc_hd__inv_2
X_09181_ _04207_ _04208_ vssd1 vssd1 vccd1 vccd1 _04209_ sky130_fd_sc_hd__or2_1
X_06393_ cell0.SB0.route_sel\[62\] vssd1 vssd1 vccd1 vccd1 _01463_ sky130_fd_sc_hd__inv_2
XTAP_TAPCELL_ROW_138_2378 vssd1 vccd1 sky130_fd_sc_hd__tapvpwrvgnd_1
X_08132_ bus1_0\[12\] bus1_0\[13\] bus1_0\[14\] bus1_0\[15\] net547 net544 vssd1 vssd1
+ vccd1 vccd1 _03172_ sky130_fd_sc_hd__mux4_1
X_08063_ net526 _03102_ _03103_ _03104_ vssd1 vssd1 vccd1 vccd1 _03105_ sky130_fd_sc_hd__a31o_1
XFILLER_135_839 vssd1 vssd1 vccd1 vccd1 sky130_fd_sc_hd__fill_1
X_07014_ _02077_ _02078_ cell2.SB0.route_sel\[67\] cell2.SB0.route_sel\[66\] vssd1
+ vssd1 vccd1 vccd1 _02079_ sky130_fd_sc_hd__o211a_1
XFILLER_115_530 vssd1 vssd1 vccd1 vccd1 sky130_fd_sc_hd__fill_1
XANTENNA__08387__A0 bus1_0\[8\] vssd1 vssd1 vccd1 vccd1 sky130_fd_sc_hd__diode_2
XANTENNA__08926__A2 bus3_1\[10\] vssd1 vssd1 vccd1 vccd1 sky130_fd_sc_hd__diode_2
XTAP_TAPCELL_ROW_8_429 vssd1 vccd1 sky130_fd_sc_hd__tapvpwrvgnd_1
XFILLER_1_819 vccd1 vssd1 vccd1 vssd1 sky130_ef_sc_hd__decap_40_12
XFILLER_142_393 vssd1 vssd1 vccd1 vccd1 sky130_fd_sc_hd__fill_1
X_08965_ _03988_ _03989_ _03995_ _03996_ vssd1 vssd1 vccd1 vccd1 _03997_ sky130_fd_sc_hd__o22a_1
XANTENNA__07645__A net327 vssd1 vssd1 vccd1 vccd1 sky130_fd_sc_hd__diode_2
XANTENNA__11438__Y net236 vssd1 vssd1 vccd1 vccd1 sky130_fd_sc_hd__diode_2
X_07916_ bus2_0\[6\] bus2_0\[7\] net515 vssd1 vssd1 vccd1 vccd1 _02960_ sky130_fd_sc_hd__mux2_1
XFILLER_124_69 vssd1 vssd1 vccd1 vccd1 sky130_fd_sc_hd__fill_2
XFILLER_84_29 vccd1 vssd1 vccd1 vssd1 sky130_ef_sc_hd__decap_40_12
X_08896_ net473 _03881_ vssd1 vssd1 vccd1 vccd1 _03928_ sky130_fd_sc_hd__nand2_1
XFILLER_68_193 vssd1 vssd1 vccd1 vccd1 sky130_fd_sc_hd__fill_1
XTAP_TAPCELL_ROW_67_1307 vssd1 vccd1 sky130_fd_sc_hd__tapvpwrvgnd_1
X_07847_ _02869_ _02887_ _02890_ _02870_ _01571_ vssd1 vssd1 vccd1 vccd1 _02891_ sky130_fd_sc_hd__a221o_1
XANTENNA__10497__A1 _03529_ vssd1 vssd1 vccd1 vccd1 sky130_fd_sc_hd__diode_2
XTAP_TAPCELL_ROW_67_1318 vssd1 vccd1 sky130_fd_sc_hd__tapvpwrvgnd_1
X_07778_ net360 net355 vssd1 vssd1 vccd1 vccd1 _02823_ sky130_fd_sc_hd__nor2_1
XTAP_TAPCELL_ROW_27_715 vssd1 vccd1 sky130_fd_sc_hd__tapvpwrvgnd_1
X_06729_ cell3.CB_0.config_dataB\[7\] vssd1 vssd1 vccd1 vccd1 _01799_ sky130_fd_sc_hd__inv_2
X_09517_ cell3.CB_1.config_dataA\[22\] cell3.CB_1.config_dataA\[23\] vssd1 vssd1 vccd1
+ vccd1 _04537_ sky130_fd_sc_hd__nand2b_1
XANTENNA__09103__A2 _03858_ vssd1 vssd1 vccd1 vccd1 sky130_fd_sc_hd__diode_2
XFILLER_37_580 vssd1 vssd1 vccd1 vccd1 sky130_fd_sc_hd__fill_1
XTAP_TAPCELL_ROW_80_1507 vssd1 vccd1 sky130_fd_sc_hd__tapvpwrvgnd_1
X_09448_ cell2.SB0.route_sel\[52\] cell2.SB0.route_sel\[53\] vssd1 vssd1 vccd1 vccd1
+ _04470_ sky130_fd_sc_hd__nor2_1
XFILLER_12_436 vssd1 vssd1 vccd1 vccd1 sky130_fd_sc_hd__fill_4
X_09379_ net362 cell3.CB_1.config_dataB\[22\] vssd1 vssd1 vccd1 vccd1 _04403_ sky130_fd_sc_hd__nand2b_1
XFILLER_33_55 vssd1 vssd1 vccd1 vccd1 sky130_fd_sc_hd__fill_1
X_12390_ cell2.CB_1.config_dataB\[0\] cell2.CB_1.config_dataA\[24\] net835 vssd1 vssd1
+ vccd1 vccd1 _00823_ sky130_fd_sc_hd__mux2_1
XANTENNA__07379__X _02435_ vssd1 vssd1 vccd1 vccd1 sky130_fd_sc_hd__diode_2
X_11410_ cell0.SB0.route_sel\[88\] _01474_ cell0.SB0.route_sel\[91\] _01475_ _06273_
+ vssd1 vssd1 vccd1 vccd1 _06274_ sky130_fd_sc_hd__a221o_1
XFILLER_138_688 vssd1 vssd1 vccd1 vccd1 sky130_fd_sc_hd__fill_1
XFILLER_123_3 vccd1 vssd1 vccd1 vssd1 sky130_ef_sc_hd__decap_40_12
X_11341_ _04514_ _05890_ _04516_ vssd1 vssd1 vccd1 vccd1 _06236_ sky130_fd_sc_hd__a21oi_1
XANTENNA__10972__A2 _05921_ vssd1 vssd1 vccd1 vccd1 sky130_fd_sc_hd__diode_2
XANTENNA__09594__X _04611_ vssd1 vssd1 vccd1 vccd1 sky130_fd_sc_hd__diode_2
XFILLER_4_613 vccd1 vssd1 vccd1 vssd1 sky130_ef_sc_hd__decap_40_12
XFILLER_141_809 vccd1 vssd1 vccd1 vssd1 sky130_ef_sc_hd__decap_40_12
X_11272_ net310 _02181_ _02182_ _06204_ vssd1 vssd1 vccd1 vccd1 net197 sky130_fd_sc_hd__a22o_1
X_14060_ clknet_leaf_81_clk _01032_ net702 vssd1 vssd1 vccd1 vccd1 cell3.SB0.route_sel\[68\]
+ sky130_fd_sc_hd__dfstp_2
XFILLER_4_657 vccd1 vssd1 vccd1 vssd1 sky130_ef_sc_hd__decap_40_12
XANTENNA__12461__A net755 vssd1 vssd1 vccd1 vccd1 sky130_fd_sc_hd__diode_2
X_13011_ net1282 cell3.LEI0.config_data\[31\] net957 vssd1 vssd1 vccd1 vccd1 _01439_
+ sky130_fd_sc_hd__mux2_1
X_10223_ _05220_ _05223_ vssd1 vssd1 vccd1 vccd1 _05224_ sky130_fd_sc_hd__nor2_1
XFILLER_3_167 vssd1 vssd1 vccd1 vccd1 sky130_fd_sc_hd__fill_1
XANTENNA_input43_A CBnorth_in[19] vssd1 vssd1 vccd1 vccd1 sky130_fd_sc_hd__diode_2
XTAP_TAPCELL_ROW_91_1669 vssd1 vccd1 sky130_fd_sc_hd__tapvpwrvgnd_1
X_10154_ cell2.SB0.route_sel\[3\] cell2.SB0.route_sel\[2\] _01566_ cell2.SB0.route_sel\[6\]
+ _05154_ vssd1 vssd1 vccd1 vccd1 _05155_ sky130_fd_sc_hd__o221a_1
XANTENNA__07050__B1 bus1_0\[9\] vssd1 vssd1 vccd1 vccd1 sky130_fd_sc_hd__diode_2
Xhold7 cell2.LE_0A.dff0_out vssd1 vssd1 vccd1 vccd1 net966 sky130_fd_sc_hd__dlygate4sd3_1
X_10085_ cell2.SB0.route_sel\[83\] cell2.SB0.route_sel\[82\] vssd1 vssd1 vccd1 vccd1
+ _05086_ sky130_fd_sc_hd__nor2_1
X_13913_ clknet_leaf_35_clk net1246 net637 vssd1 vssd1 vccd1 vccd1 cell2.LE_0B.config_data\[14\]
+ sky130_fd_sc_hd__dfrtp_1
XFILLER_74_130 vssd1 vssd1 vccd1 vccd1 sky130_fd_sc_hd__fill_1
X_13844_ clknet_leaf_115_clk _00816_ net665 vssd1 vssd1 vccd1 vccd1 cell1.SB0.route_sel\[121\]
+ sky130_fd_sc_hd__dfstp_2
XTAP_TAPCELL_ROW_122_2135 vssd1 vccd1 sky130_fd_sc_hd__tapvpwrvgnd_1
X_10987_ _05874_ _05871_ net377 vssd1 vssd1 vccd1 vccd1 _05941_ sky130_fd_sc_hd__mux2_1
XANTENNA__07105__A1 net314 vssd1 vssd1 vccd1 vccd1 sky130_fd_sc_hd__diode_2
XFILLER_43_561 vssd1 vssd1 vccd1 vccd1 sky130_fd_sc_hd__fill_1
X_13775_ clknet_leaf_107_clk _00747_ net653 vssd1 vssd1 vccd1 vccd1 cell1.SB0.route_sel\[52\]
+ sky130_fd_sc_hd__dfstp_1
X_12726_ cell3.CB_0.config_dataB\[18\] cell3.CB_0.config_dataB\[17\] net931 vssd1
+ vssd1 vccd1 vccd1 _01155_ sky130_fd_sc_hd__mux2_1
XFILLER_129_611 vssd1 vssd1 vccd1 vccd1 sky130_fd_sc_hd__fill_1
X_12657_ cell3.SB0.route_sel\[122\] cell3.SB0.route_sel\[121\] net914 vssd1 vssd1
+ vccd1 vccd1 _01086_ sky130_fd_sc_hd__mux2_1
XFILLER_90_83 vssd1 vssd1 vccd1 vccd1 sky130_fd_sc_hd__fill_1
X_11608_ cell0.CB_0.config_dataB\[4\] cell0.CB_0.config_dataB\[3\] net777 vssd1 vssd1
+ vccd1 vccd1 _00049_ sky130_fd_sc_hd__mux2_1
X_12588_ cell3.SB0.route_sel\[53\] cell3.SB0.route_sel\[52\] net914 vssd1 vssd1 vccd1
+ vccd1 _01017_ sky130_fd_sc_hd__mux2_1
X_14327_ clknet_leaf_26_clk _01299_ net607 vssd1 vssd1 vccd1 vccd1 cell2.SB0.route_sel\[112\]
+ sky130_fd_sc_hd__dfstp_2
XFILLER_11_480 vssd1 vssd1 vccd1 vccd1 sky130_fd_sc_hd__fill_4
XTAP_TAPCELL_ROW_13_497 vssd1 vccd1 sky130_fd_sc_hd__tapvpwrvgnd_1
Xhold418 cell3.LE_1A.config_data\[4\] vssd1 vssd1 vccd1 vccd1 net1377 sky130_fd_sc_hd__dlygate4sd3_1
XFILLER_117_839 vssd1 vssd1 vccd1 vccd1 sky130_fd_sc_hd__fill_1
XANTENNA__10963__A2 _04362_ vssd1 vssd1 vccd1 vccd1 sky130_fd_sc_hd__diode_2
Xhold407 cell0.LE_0B.config_data\[15\] vssd1 vssd1 vccd1 vccd1 net1366 sky130_fd_sc_hd__dlygate4sd3_1
X_11539_ _01577_ cell0.SB0.route_sel\[2\] _01578_ cell0.SB0.route_sel\[5\] _06359_
+ vssd1 vssd1 vccd1 vccd1 _06360_ sky130_fd_sc_hd__a221o_1
X_14258_ clknet_leaf_26_clk _01230_ net616 vssd1 vssd1 vccd1 vccd1 cell2.SB0.route_sel\[43\]
+ sky130_fd_sc_hd__dfstp_1
Xhold429 _00534_ vssd1 vssd1 vccd1 vccd1 net1388 sky130_fd_sc_hd__dlygate4sd3_1
XTAP_TAPCELL_ROW_133_2297 vssd1 vccd1 sky130_fd_sc_hd__tapvpwrvgnd_1
X_14189_ clknet_leaf_51_clk _01161_ net723 vssd1 vssd1 vccd1 vccd1 cell3.CB_0.config_dataB\[24\]
+ sky130_fd_sc_hd__dfstp_1
X_13209_ clknet_leaf_22_clk _00181_ net604 vssd1 vssd1 vccd1 vccd1 cell0.LE_0A.config_data\[16\]
+ sky130_fd_sc_hd__dfrtp_2
XANTENNA__09030__A1 bus3_1\[5\] vssd1 vssd1 vccd1 vccd1 sky130_fd_sc_hd__diode_2
XFILLER_112_522 vssd1 vssd1 vccd1 vccd1 sky130_fd_sc_hd__fill_1
Xfanout909 net912 vssd1 vssd1 vccd1 vccd1 net909 sky130_fd_sc_hd__clkbuf_4
XANTENNA__07041__B1 _02105_ vssd1 vssd1 vccd1 vccd1 sky130_fd_sc_hd__diode_2
XANTENNA__09030__B2 bus3_1\[4\] vssd1 vssd1 vccd1 vccd1 sky130_fd_sc_hd__diode_2
XANTENNA__07592__A1 net1 vssd1 vssd1 vccd1 vccd1 sky130_fd_sc_hd__diode_2
XANTENNA__08848__X _03880_ vssd1 vssd1 vccd1 vccd1 sky130_fd_sc_hd__diode_2
X_08750_ net452 _03504_ _03783_ cell1.CB_1.config_dataB\[16\] vssd1 vssd1 vccd1 vccd1
+ _03784_ sky130_fd_sc_hd__o211a_1
XTAP_TAPCELL_ROW_107_1908 vssd1 vccd1 sky130_fd_sc_hd__tapvpwrvgnd_1
X_07701_ cell0.SB0.route_sel\[27\] cell0.SB0.route_sel\[26\] vssd1 vssd1 vccd1 vccd1
+ _02748_ sky130_fd_sc_hd__nand2_1
X_08681_ net460 _03710_ _03711_ _03714_ vssd1 vssd1 vccd1 vccd1 _03715_ sky130_fd_sc_hd__a31o_1
XANTENNA__11274__X net167 vssd1 vssd1 vccd1 vccd1 sky130_fd_sc_hd__diode_2
XTAP_TAPCELL_ROW_107_1919 vssd1 vccd1 sky130_fd_sc_hd__tapvpwrvgnd_1
X_07632_ cell1.SB0.route_sel\[14\] cell1.SB0.route_sel\[15\] _02661_ _02680_ vssd1
+ vssd1 vccd1 vccd1 _02681_ sky130_fd_sc_hd__a211o_1
XTAP_TAPCELL_ROW_49_1048 vssd1 vccd1 sky130_fd_sc_hd__tapvpwrvgnd_1
XTAP_TAPCELL_ROW_49_1037 vssd1 vccd1 sky130_fd_sc_hd__tapvpwrvgnd_1
XANTENNA__13983__RESET_B net635 vssd1 vssd1 vccd1 vccd1 sky130_fd_sc_hd__diode_2
X_09302_ _01995_ _04173_ vssd1 vssd1 vccd1 vccd1 _04327_ sky130_fd_sc_hd__or2_1
X_07563_ net358 net353 bus1_0\[0\] vssd1 vssd1 vccd1 vccd1 _02613_ sky130_fd_sc_hd__o21ai_1
XFILLER_110_27 vssd1 vssd1 vccd1 vccd1 sky130_fd_sc_hd__fill_1
XTAP_TAPCELL_ROW_62_1237 vssd1 vccd1 sky130_fd_sc_hd__tapvpwrvgnd_1
X_07494_ cell0.SB0.route_sel\[126\] cell0.SB0.config_data_out vssd1 vssd1 vccd1 vccd1
+ _02546_ sky130_fd_sc_hd__nand2_1
X_06514_ cell0.SB0.route_sel\[11\] vssd1 vssd1 vccd1 vccd1 _01584_ sky130_fd_sc_hd__inv_2
XANTENNA__10651__A1 _05531_ vssd1 vssd1 vccd1 vccd1 sky130_fd_sc_hd__diode_2
X_09233_ _04257_ _04259_ vssd1 vssd1 vccd1 vccd1 _04260_ sky130_fd_sc_hd__nand2_4
XANTENNA__10618__X _05576_ vssd1 vssd1 vccd1 vccd1 sky130_fd_sc_hd__diode_2
XFILLER_61_391 vssd1 vssd1 vccd1 vccd1 sky130_fd_sc_hd__fill_1
X_06445_ cell1.SB0.route_sel\[42\] vssd1 vssd1 vccd1 vccd1 _01515_ sky130_fd_sc_hd__inv_2
X_09164_ _04191_ net311 _04190_ vssd1 vssd1 vccd1 vccd1 _04192_ sky130_fd_sc_hd__mux2_1
XTAP_TAPCELL_ROW_32_784 vssd1 vccd1 sky130_fd_sc_hd__tapvpwrvgnd_1
XANTENNA__10403__A1 _05152_ vssd1 vssd1 vccd1 vccd1 sky130_fd_sc_hd__diode_2
XFILLER_119_143 vssd1 vssd1 vccd1 vccd1 sky130_fd_sc_hd__fill_1
X_08115_ cell0.LE_0B.config_data\[15\] cell0.LE_0B.config_data\[14\] _03087_ vssd1
+ vssd1 vccd1 vccd1 _03157_ sky130_fd_sc_hd__mux2_1
XTAP_TAPCELL_ROW_32_795 vssd1 vccd1 sky130_fd_sc_hd__tapvpwrvgnd_1
XANTENNA__10403__B2 _05156_ vssd1 vssd1 vccd1 vccd1 sky130_fd_sc_hd__diode_2
XFILLER_119_165 vssd1 vssd1 vccd1 vccd1 sky130_fd_sc_hd__fill_1
X_09095_ cell1.LE_0B.config_data\[7\] cell1.LE_0B.config_data\[6\] _04086_ vssd1 vssd1
+ vccd1 vccd1 _04125_ sky130_fd_sc_hd__mux2_1
XANTENNA__08072__A2 bus2_0\[2\] vssd1 vssd1 vccd1 vccd1 sky130_fd_sc_hd__diode_2
XFILLER_135_658 vssd1 vssd1 vccd1 vccd1 sky130_fd_sc_hd__fill_1
XANTENNA__10954__A2 net42 vssd1 vssd1 vccd1 vccd1 sky130_fd_sc_hd__diode_2
X_08046_ cell0.LE_0B.config_data\[5\] cell0.LE_0B.config_data\[4\] _03087_ vssd1 vssd1
+ vccd1 vccd1 _03088_ sky130_fd_sc_hd__mux2_1
XANTENNA_fanout697_A net700 vssd1 vssd1 vccd1 vccd1 sky130_fd_sc_hd__diode_2
XANTENNA__08375__A3 net340 vssd1 vssd1 vccd1 vccd1 sky130_fd_sc_hd__diode_2
XFILLER_0_104 vssd1 vssd1 vccd1 vccd1 sky130_fd_sc_hd__fill_2
XFILLER_135_57 vccd1 vssd1 vccd1 vssd1 sky130_ef_sc_hd__decap_40_12
X_09997_ bus3_2\[12\] bus3_2\[14\] bus3_2\[13\] bus3_2\[15\] net402 net403 vssd1 vssd1
+ vccd1 vccd1 _05001_ sky130_fd_sc_hd__mux4_1
XFILLER_95_39 vccd1 vssd1 vccd1 vssd1 sky130_ef_sc_hd__decap_40_12
XFILLER_89_789 vssd1 vssd1 vccd1 vccd1 sky130_fd_sc_hd__fill_1
XFILLER_76_406 vssd1 vssd1 vccd1 vccd1 sky130_fd_sc_hd__fill_1
XTAP_TAPCELL_ROW_73_1399 vssd1 vccd1 sky130_fd_sc_hd__tapvpwrvgnd_1
X_08948_ net464 _03858_ _03979_ cell1.CB_0.config_dataA\[16\] vssd1 vssd1 vccd1 vccd1
+ _03980_ sky130_fd_sc_hd__o211a_1
X_08879_ _03909_ _03910_ cell1.CB_0.config_dataA\[2\] vssd1 vssd1 vccd1 vccd1 _03911_
+ sky130_fd_sc_hd__mux2_1
XANTENNA__11131__A2 net56 vssd1 vssd1 vccd1 vccd1 sky130_fd_sc_hd__diode_2
X_10910_ net53 net54 net56 net57 net379 net378 vssd1 vssd1 vccd1 vccd1 _05864_ sky130_fd_sc_hd__mux4_1
XFILLER_56_141 vssd1 vssd1 vccd1 vccd1 sky130_fd_sc_hd__fill_1
XFILLER_45_837 vssd1 vssd1 vccd1 vccd1 sky130_fd_sc_hd__fill_1
XANTENNA__08532__A0 net4 vssd1 vssd1 vccd1 vccd1 sky130_fd_sc_hd__diode_2
X_11890_ cell1.CB_0.config_dataA\[21\] cell1.CB_0.config_dataA\[20\] net874 vssd1
+ vssd1 vccd1 vccd1 _00327_ sky130_fd_sc_hd__mux2_1
X_10841_ net365 net364 vssd1 vssd1 vccd1 vccd1 _05797_ sky130_fd_sc_hd__or2_1
XFILLER_25_561 vssd1 vssd1 vccd1 vccd1 sky130_fd_sc_hd__fill_2
X_10772_ _05528_ _05724_ _05726_ _05531_ _01779_ vssd1 vssd1 vccd1 vccd1 _05728_ sky130_fd_sc_hd__a221o_1
XFILLER_71_177 vssd1 vssd1 vccd1 vccd1 sky130_fd_sc_hd__fill_2
X_13560_ clknet_leaf_117_clk _00532_ net669 vssd1 vssd1 vccd1 vccd1 cell1.LE_0A.config_data\[3\]
+ sky130_fd_sc_hd__dfrtp_1
X_12511_ net1353 cell2.LEI0.config_data\[24\] net843 vssd1 vssd1 vccd1 vccd1 _00940_
+ sky130_fd_sc_hd__mux2_1
X_13491_ clknet_leaf_93_clk _00463_ net693 vssd1 vssd1 vccd1 vccd1 cell1.CB_1.config_dataB\[4\]
+ sky130_fd_sc_hd__dfstp_1
XFILLER_9_727 vssd1 vssd1 vccd1 vccd1 sky130_fd_sc_hd__fill_1
X_12442_ net1163 net1105 net844 vssd1 vssd1 vccd1 vccd1 _00873_ sky130_fd_sc_hd__mux2_1
XFILLER_8_237 vssd1 vssd1 vccd1 vccd1 sky130_fd_sc_hd__fill_4
X_12373_ cell1.SB0.route_sel\[111\] cell1.SB0.route_sel\[110\] net860 vssd1 vssd1
+ vccd1 vccd1 _00806_ sky130_fd_sc_hd__mux2_1
XTAP_TAPCELL_ROW_10_456 vssd1 vccd1 sky130_fd_sc_hd__tapvpwrvgnd_1
XTAP_TAPCELL_ROW_93_1709 vssd1 vccd1 sky130_fd_sc_hd__tapvpwrvgnd_1
X_14112_ clknet_leaf_50_clk _01084_ net711 vssd1 vssd1 vccd1 vccd1 cell3.SB0.route_sel\[120\]
+ sky130_fd_sc_hd__dfstp_1
X_11324_ net295 _04702_ _04703_ _06227_ vssd1 vssd1 vccd1 vccd1 net157 sky130_fd_sc_hd__a22o_1
XFILLER_5_15 vccd1 vssd1 vccd1 vssd1 sky130_ef_sc_hd__decap_40_12
XFILLER_4_421 vccd1 vssd1 vccd1 vssd1 sky130_ef_sc_hd__decap_40_12
XANTENNA__07271__B1 bus1_0\[12\] vssd1 vssd1 vccd1 vccd1 sky130_fd_sc_hd__diode_2
X_11255_ net307 _05148_ _04290_ vssd1 vssd1 vccd1 vccd1 _06195_ sky130_fd_sc_hd__mux2_1
XFILLER_125_157 vssd1 vssd1 vccd1 vccd1 sky130_fd_sc_hd__fill_1
XFILLER_109_91 vssd1 vssd1 vccd1 vccd1 sky130_fd_sc_hd__fill_1
X_14043_ clknet_leaf_50_clk _01015_ net711 vssd1 vssd1 vccd1 vccd1 cell3.SB0.route_sel\[51\]
+ sky130_fd_sc_hd__dfstp_1
X_10206_ cell2.CB_0.config_dataA\[12\] _05205_ _05206_ _05203_ vssd1 vssd1 vccd1 vccd1
+ _05207_ sky130_fd_sc_hd__o31a_1
XANTENNA__07285__A net347 vssd1 vssd1 vccd1 vccd1 sky130_fd_sc_hd__diode_2
XANTENNA_input46_X net46 vssd1 vssd1 vccd1 vccd1 sky130_fd_sc_hd__diode_2
X_11186_ net298 net291 cell3.LEI0.config_data\[27\] vssd1 vssd1 vccd1 vccd1 _06138_
+ sky130_fd_sc_hd__mux2_1
XANTENNA_output247_A net247 vssd1 vssd1 vccd1 vccd1 sky130_fd_sc_hd__diode_2
XANTENNA__08771__A0 cell1.LE_1B.config_data\[13\] vssd1 vssd1 vccd1 vccd1 sky130_fd_sc_hd__diode_2
X_10137_ cell2.SB0.route_sel\[35\] cell2.SB0.route_sel\[34\] _01602_ cell2.SB0.route_sel\[37\]
+ vssd1 vssd1 vccd1 vccd1 _05138_ sky130_fd_sc_hd__o22a_1
XFILLER_0_671 vssd1 vssd1 vccd1 vccd1 sky130_fd_sc_hd__fill_1
X_10068_ cell2.LE_1B.config_data\[12\] cell2.LE_1B.config_data\[13\] _04956_ vssd1
+ vssd1 vccd1 vccd1 _05072_ sky130_fd_sc_hd__mux2_1
XPHY_EDGE_ROW_13_Right_13 vssd1 vssd1 vccd1 vccd1 sky130_fd_sc_hd__decap_3
XFILLER_90_464 vssd1 vssd1 vccd1 vccd1 sky130_fd_sc_hd__fill_1
XANTENNA__09079__B2 bus3_1\[5\] vssd1 vssd1 vccd1 vccd1 sky130_fd_sc_hd__diode_2
XANTENNA__09079__A1 bus3_1\[4\] vssd1 vssd1 vccd1 vccd1 sky130_fd_sc_hd__diode_2
X_13827_ clknet_leaf_113_clk _00799_ net673 vssd1 vssd1 vccd1 vccd1 cell1.SB0.route_sel\[104\]
+ sky130_fd_sc_hd__dfstp_2
XTAP_TAPCELL_ROW_102_1838 vssd1 vccd1 sky130_fd_sc_hd__tapvpwrvgnd_1
XANTENNA__10618__D1 net398 vssd1 vssd1 vccd1 vccd1 sky130_fd_sc_hd__diode_2
XTAP_TAPCELL_ROW_18_578 vssd1 vccd1 sky130_fd_sc_hd__tapvpwrvgnd_1
X_13758_ clknet_leaf_104_clk _00730_ net678 vssd1 vssd1 vccd1 vccd1 cell1.SB0.route_sel\[35\]
+ sky130_fd_sc_hd__dfstp_2
X_12709_ net388 net389 net926 vssd1 vssd1 vccd1 vccd1 _01138_ sky130_fd_sc_hd__mux2_1
XANTENNA__10633__A1 _04354_ vssd1 vssd1 vccd1 vccd1 sky130_fd_sc_hd__diode_2
X_13689_ clknet_leaf_29_clk _00661_ net619 vssd1 vssd1 vccd1 vccd1 cell2.CB_0.config_dataB\[16\]
+ sky130_fd_sc_hd__dfstp_1
XANTENNA__10438__X bus3_2\[3\] vssd1 vssd1 vccd1 vccd1 sky130_fd_sc_hd__diode_2
XTAP_TAPCELL_ROW_135_2337 vssd1 vccd1 sky130_fd_sc_hd__tapvpwrvgnd_1
XTAP_TAPCELL_ROW_135_2326 vssd1 vccd1 sky130_fd_sc_hd__tapvpwrvgnd_1
XFILLER_129_441 vssd1 vssd1 vccd1 vccd1 sky130_fd_sc_hd__fill_1
XPHY_EDGE_ROW_22_Right_22 vssd1 vssd1 vccd1 vccd1 sky130_fd_sc_hd__decap_3
Xhold204 cell2.LE_0B.config_data\[2\] vssd1 vssd1 vccd1 vccd1 net1163 sky130_fd_sc_hd__dlygate4sd3_1
Xhold215 cell2.LE_1A.config_data\[3\] vssd1 vssd1 vccd1 vccd1 net1174 sky130_fd_sc_hd__dlygate4sd3_1
Xhold226 cell0.LE_0B.config_data\[11\] vssd1 vssd1 vccd1 vccd1 net1185 sky130_fd_sc_hd__dlygate4sd3_1
XFILLER_7_281 vssd1 vssd1 vccd1 vccd1 sky130_fd_sc_hd__fill_4
Xhold248 cell2.LE_1B.config_data\[0\] vssd1 vssd1 vccd1 vccd1 net1207 sky130_fd_sc_hd__dlygate4sd3_1
XFILLER_116_157 vssd1 vssd1 vccd1 vccd1 sky130_fd_sc_hd__fill_1
X_09920_ net408 net409 vssd1 vssd1 vccd1 vccd1 _04924_ sky130_fd_sc_hd__and2b_1
XANTENNA__09539__C1 _04557_ vssd1 vssd1 vccd1 vccd1 sky130_fd_sc_hd__diode_2
XANTENNA__09003__A1 _03894_ vssd1 vssd1 vccd1 vccd1 sky130_fd_sc_hd__diode_2
Xhold259 cell1.LEI0.config_data\[35\] vssd1 vssd1 vccd1 vccd1 net1218 sky130_fd_sc_hd__dlygate4sd3_1
Xhold237 cell0.LEI0.config_data\[39\] vssd1 vssd1 vccd1 vccd1 net1196 sky130_fd_sc_hd__dlygate4sd3_1
Xfanout706 net724 vssd1 vssd1 vccd1 vccd1 net706 sky130_fd_sc_hd__clkbuf_2
XFILLER_98_531 vssd1 vssd1 vccd1 vccd1 sky130_fd_sc_hd__fill_1
XANTENNA__09003__B2 _03890_ vssd1 vssd1 vccd1 vccd1 sky130_fd_sc_hd__diode_2
Xfanout739 net741 vssd1 vssd1 vccd1 vccd1 net739 sky130_fd_sc_hd__buf_2
Xfanout717 net719 vssd1 vssd1 vccd1 vccd1 net717 sky130_fd_sc_hd__clkbuf_4
X_09851_ net442 _04498_ vssd1 vssd1 vccd1 vccd1 _04857_ sky130_fd_sc_hd__nand2_1
Xfanout728 net729 vssd1 vssd1 vccd1 vccd1 net728 sky130_fd_sc_hd__clkbuf_4
X_09782_ cell2.LEI0.config_data\[18\] net315 _04787_ cell2.LEI0.config_data\[19\]
+ vssd1 vssd1 vccd1 vccd1 _04788_ sky130_fd_sc_hd__o211a_1
XFILLER_86_737 vssd1 vssd1 vccd1 vccd1 sky130_fd_sc_hd__fill_1
XFILLER_85_225 vssd1 vssd1 vccd1 vccd1 sky130_fd_sc_hd__fill_1
X_08802_ cell1.CB_0.config_dataA\[7\] _03833_ vssd1 vssd1 vccd1 vccd1 _03834_ sky130_fd_sc_hd__nand2_1
X_06994_ net328 _02059_ vssd1 vssd1 vccd1 vccd1 _02060_ sky130_fd_sc_hd__nor2_1
XPHY_EDGE_ROW_31_Right_31 vssd1 vssd1 vccd1 vccd1 sky130_fd_sc_hd__decap_3
XANTENNA__07482__X _02535_ vssd1 vssd1 vccd1 vccd1 sky130_fd_sc_hd__diode_2
X_08733_ _03763_ _03764_ _03766_ vssd1 vssd1 vccd1 vccd1 _03767_ sky130_fd_sc_hd__and3_1
XANTENNA__13137__SET_B net581 vssd1 vssd1 vccd1 vccd1 sky130_fd_sc_hd__diode_2
XANTENNA_fanout278_A cell3.CB_0.le_outB vssd1 vssd1 vccd1 vccd1 sky130_fd_sc_hd__diode_2
XFILLER_121_15 vccd1 vssd1 vccd1 vssd1 sky130_ef_sc_hd__decap_40_12
XANTENNA__10949__A2_N _05898_ vssd1 vssd1 vccd1 vccd1 sky130_fd_sc_hd__diode_2
XFILLER_53_111 vssd1 vssd1 vccd1 vccd1 sky130_fd_sc_hd__fill_1
X_08664_ cell1.LEI0.config_data\[21\] net323 vssd1 vssd1 vccd1 vccd1 _03698_ sky130_fd_sc_hd__nand2_1
XANTENNA__07868__A2 bus2_0\[2\] vssd1 vssd1 vccd1 vccd1 sky130_fd_sc_hd__diode_2
XANTENNA__12975__S net929 vssd1 vssd1 vccd1 vccd1 sky130_fd_sc_hd__diode_2
X_07615_ cell0.SB0.route_sel\[11\] cell0.SB0.route_sel\[10\] vssd1 vssd1 vccd1 vccd1
+ _02664_ sky130_fd_sc_hd__nand2_1
X_08595_ cell1.CB_1.config_dataA\[16\] _03629_ _03630_ vssd1 vssd1 vccd1 vccd1 _03631_
+ sky130_fd_sc_hd__a21oi_1
XTAP_TAPCELL_ROW_37_865 vssd1 vccd1 sky130_fd_sc_hd__tapvpwrvgnd_1
X_07546_ _02594_ _02596_ _02590_ vssd1 vssd1 vccd1 vccd1 _02597_ sky130_fd_sc_hd__a21o_1
XFILLER_81_486 vssd1 vssd1 vccd1 vccd1 sky130_fd_sc_hd__fill_2
X_07477_ cell2.SB0.route_sel\[119\] cell2.SB0.route_sel\[118\] _01648_ _02528_ vssd1
+ vssd1 vccd1 vccd1 _02530_ sky130_fd_sc_hd__a211o_1
XANTENNA__09490__A1 net16 vssd1 vssd1 vccd1 vccd1 sky130_fd_sc_hd__diode_2
XANTENNA_fanout612_A net623 vssd1 vssd1 vccd1 vccd1 sky130_fd_sc_hd__diode_2
X_09216_ net105 cell2.SB0.route_sel\[13\] cell2.SB0.route_sel\[12\] vssd1 vssd1 vccd1
+ vccd1 _04243_ sky130_fd_sc_hd__and3_1
XPHY_EDGE_ROW_40_Right_40 vssd1 vssd1 vccd1 vccd1 sky130_fd_sc_hd__decap_3
XANTENNA__08473__B _02780_ vssd1 vssd1 vccd1 vccd1 sky130_fd_sc_hd__diode_2
XANTENNA__08293__A2 bus1_0\[2\] vssd1 vssd1 vccd1 vccd1 sky130_fd_sc_hd__diode_2
XANTENNA__13991__SET_B net752 vssd1 vssd1 vccd1 vccd1 sky130_fd_sc_hd__diode_2
X_06428_ cell1.SB0.route_sel\[6\] vssd1 vssd1 vccd1 vccd1 _01498_ sky130_fd_sc_hd__inv_2
X_09147_ cell2.CB_1.config_dataB\[23\] cell2.CB_1.config_dataB\[22\] vssd1 vssd1 vccd1
+ vccd1 _04175_ sky130_fd_sc_hd__nor2_1
XFILLER_107_113 vssd1 vssd1 vccd1 vccd1 sky130_fd_sc_hd__fill_1
XANTENNA__07253__B1 _02311_ vssd1 vssd1 vccd1 vccd1 sky130_fd_sc_hd__diode_2
X_09078_ bus3_1\[6\] bus3_1\[7\] net479 vssd1 vssd1 vccd1 vccd1 _04108_ sky130_fd_sc_hd__mux2_1
XFILLER_123_617 vssd1 vssd1 vccd1 vccd1 sky130_fd_sc_hd__fill_1
XTAP_TAPCELL_ROW_75_1439 vssd1 vccd1 sky130_fd_sc_hd__tapvpwrvgnd_1
XTAP_TAPCELL_ROW_75_1428 vssd1 vccd1 sky130_fd_sc_hd__tapvpwrvgnd_1
X_08029_ net533 _01986_ vssd1 vssd1 vccd1 vccd1 _03071_ sky130_fd_sc_hd__nand2_1
X_11040_ _05990_ _05993_ vssd1 vssd1 vccd1 vccd1 _05994_ sky130_fd_sc_hd__or2_1
XANTENNA__11339__B _05893_ vssd1 vssd1 vccd1 vccd1 sky130_fd_sc_hd__diode_2
XFILLER_89_575 vssd1 vssd1 vccd1 vccd1 sky130_fd_sc_hd__fill_2
X_12991_ net1509 cell3.LEI0.config_data\[11\] net946 vssd1 vssd1 vccd1 vccd1 _01419_
+ sky130_fd_sc_hd__mux2_1
XANTENNA__07259__B1_N _02309_ vssd1 vssd1 vccd1 vccd1 sky130_fd_sc_hd__diode_2
XANTENNA__08505__B1 _03540_ vssd1 vssd1 vccd1 vccd1 sky130_fd_sc_hd__diode_2
X_11942_ cell0.SB0.route_sel\[48\] cell0.SB0.route_sel\[47\] net759 vssd1 vssd1 vccd1
+ vccd1 _00379_ sky130_fd_sc_hd__mux2_1
X_11873_ cell1.CB_0.config_dataA\[4\] cell1.CB_0.config_dataA\[3\] net883 vssd1 vssd1
+ vccd1 vccd1 _00310_ sky130_fd_sc_hd__mux2_1
X_10824_ net17 net18 net19 net20 cell3.CB_1.config_dataB\[10\] cell3.CB_1.config_dataB\[11\]
+ vssd1 vssd1 vccd1 vccd1 _05780_ sky130_fd_sc_hd__mux4_1
X_13612_ clknet_leaf_94_clk _00584_ net695 vssd1 vssd1 vccd1 vccd1 cell1.LEI0.config_data\[33\]
+ sky130_fd_sc_hd__dfrtp_1
XANTENNA__12065__A0 cell1.LE_1A.config_data\[16\] vssd1 vssd1 vccd1 vccd1 sky130_fd_sc_hd__diode_2
XTAP_TAPCELL_ROW_15_526 vssd1 vccd1 sky130_fd_sc_hd__tapvpwrvgnd_1
XANTENNA_input100_X net100 vssd1 vssd1 vccd1 vccd1 sky130_fd_sc_hd__diode_2
XANTENNA__10615__A1 net22 vssd1 vssd1 vccd1 vccd1 sky130_fd_sc_hd__diode_2
X_13543_ clknet_leaf_72_clk net1026 net728 vssd1 vssd1 vccd1 vccd1 cell1.LE_0B.config_data\[8\]
+ sky130_fd_sc_hd__dfrtp_1
XANTENNA__11812__A0 net1525 vssd1 vssd1 vccd1 vccd1 sky130_fd_sc_hd__diode_2
XTAP_TAPCELL_ROW_15_537 vssd1 vccd1 sky130_fd_sc_hd__tapvpwrvgnd_1
X_10755_ net8 net9 net10 net11 cell3.CB_1.config_dataB\[0\] cell3.CB_1.config_dataB\[1\]
+ vssd1 vssd1 vccd1 vccd1 _05711_ sky130_fd_sc_hd__mux4_1
X_10686_ net390 net391 vssd1 vssd1 vccd1 vccd1 _05644_ sky130_fd_sc_hd__and2b_1
XFILLER_9_557 vssd1 vssd1 vccd1 vccd1 sky130_fd_sc_hd__fill_2
X_13474_ clknet_leaf_1_clk _00446_ net561 vssd1 vssd1 vccd1 vccd1 cell0.SB0.route_sel\[115\]
+ sky130_fd_sc_hd__dfstp_1
XFILLER_139_783 vssd1 vssd1 vccd1 vccd1 sky130_fd_sc_hd__fill_1
XANTENNA_output197_A net197 vssd1 vssd1 vccd1 vccd1 sky130_fd_sc_hd__diode_2
XTAP_TAPCELL_ROW_117_2056 vssd1 vccd1 sky130_fd_sc_hd__tapvpwrvgnd_1
X_12425_ net1167 net1046 net924 vssd1 vssd1 vccd1 vccd1 _00857_ sky130_fd_sc_hd__mux2_1
XTAP_TAPCELL_ROW_117_2067 vssd1 vccd1 sky130_fd_sc_hd__tapvpwrvgnd_1
XFILLER_5_741 vccd1 vssd1 vccd1 vssd1 sky130_ef_sc_hd__decap_40_12
X_12356_ cell1.SB0.route_sel\[94\] cell1.SB0.route_sel\[93\] net869 vssd1 vssd1 vccd1
+ vccd1 _00789_ sky130_fd_sc_hd__mux2_1
XANTENNA__10394__A3 net39 vssd1 vssd1 vccd1 vccd1 sky130_fd_sc_hd__diode_2
X_11307_ _04482_ _06218_ vssd1 vssd1 vccd1 vccd1 net148 sky130_fd_sc_hd__nor2_1
XANTENNA__08992__A0 bus3_1\[0\] vssd1 vssd1 vccd1 vccd1 sky130_fd_sc_hd__diode_2
XTAP_TAPCELL_ROW_130_2256 vssd1 vccd1 sky130_fd_sc_hd__tapvpwrvgnd_1
X_12287_ cell1.SB0.route_sel\[25\] cell1.SB0.route_sel\[24\] net857 vssd1 vssd1 vccd1
+ vccd1 _00720_ sky130_fd_sc_hd__mux2_1
XANTENNA__11546__A_N _02675_ vssd1 vssd1 vccd1 vccd1 sky130_fd_sc_hd__diode_2
X_11238_ _06142_ _06185_ _06175_ vssd1 vssd1 vccd1 vccd1 _06190_ sky130_fd_sc_hd__o21bai_1
X_14026_ clknet_leaf_47_clk _00998_ net703 vssd1 vssd1 vccd1 vccd1 cell3.SB0.route_sel\[34\]
+ sky130_fd_sc_hd__dfstp_1
X_11169_ cell3.CB_0.config_dataB\[13\] _06116_ _06118_ _06120_ vssd1 vssd1 vccd1 vccd1
+ _06121_ sky130_fd_sc_hd__and4_1
XFILLER_83_729 vssd1 vssd1 vccd1 vccd1 sky130_fd_sc_hd__fill_8
XFILLER_76_770 vssd1 vssd1 vccd1 vccd1 sky130_fd_sc_hd__fill_1
XANTENNA__14359__SET_B net733 vssd1 vssd1 vccd1 vccd1 sky130_fd_sc_hd__diode_2
XANTENNA__10854__A1 _05475_ vssd1 vssd1 vccd1 vccd1 sky130_fd_sc_hd__diode_2
XFILLER_63_442 vssd1 vssd1 vccd1 vccd1 sky130_fd_sc_hd__fill_4
XFILLER_51_615 vssd1 vssd1 vccd1 vccd1 sky130_fd_sc_hd__fill_1
X_07400_ _02454_ vssd1 vssd1 vccd1 vccd1 _02455_ sky130_fd_sc_hd__inv_2
X_08380_ net500 _02494_ net499 vssd1 vssd1 vccd1 vccd1 _03418_ sky130_fd_sc_hd__o21ai_1
XANTENNA__11552__X net252 vssd1 vssd1 vccd1 vccd1 sky130_fd_sc_hd__diode_2
XTAP_TAPCELL_ROW_34_813 vssd1 vccd1 sky130_fd_sc_hd__tapvpwrvgnd_1
XTAP_TAPCELL_ROW_34_824 vssd1 vccd1 sky130_fd_sc_hd__tapvpwrvgnd_1
X_07331_ _02346_ _02387_ vssd1 vssd1 vccd1 vccd1 _02388_ sky130_fd_sc_hd__and2_2
XANTENNA_clkbuf_0_clk_X clknet_0_clk vssd1 vssd1 vccd1 vccd1 sky130_fd_sc_hd__diode_2
XANTENNA__08275__A2 _02211_ vssd1 vssd1 vccd1 vccd1 sky130_fd_sc_hd__diode_2
XFILLER_31_361 vssd1 vssd1 vccd1 vccd1 sky130_fd_sc_hd__fill_1
XANTENNA__07483__B1 _02535_ vssd1 vssd1 vccd1 vccd1 sky130_fd_sc_hd__diode_2
X_07262_ cell2.SB0.route_sel\[89\] cell2.SB0.route_sel\[88\] vssd1 vssd1 vccd1 vccd1
+ _02321_ sky130_fd_sc_hd__nand2b_1
X_07193_ cell2.SB0.route_sel\[87\] cell2.SB0.route_sel\[86\] vssd1 vssd1 vccd1 vccd1
+ _02254_ sky130_fd_sc_hd__or2_1
X_09001_ net482 _03881_ vssd1 vssd1 vccd1 vccd1 _04031_ sky130_fd_sc_hd__nand2_1
XANTENNA__09775__A2 _04498_ vssd1 vssd1 vccd1 vccd1 sky130_fd_sc_hd__diode_2
XANTENNA__07786__A1 net92 vssd1 vssd1 vccd1 vccd1 sky130_fd_sc_hd__diode_2
XFILLER_104_116 vssd1 vssd1 vccd1 vccd1 sky130_fd_sc_hd__fill_1
XTAP_TAPCELL_ROW_57_1169 vssd1 vccd1 sky130_fd_sc_hd__tapvpwrvgnd_1
XTAP_TAPCELL_ROW_57_1158 vssd1 vccd1 sky130_fd_sc_hd__tapvpwrvgnd_1
X_09903_ cell2.LE_1A.config_data\[3\] cell2.LE_1A.config_data\[2\] _04831_ vssd1 vssd1
+ vccd1 vccd1 _04909_ sky130_fd_sc_hd__mux2_1
Xfanout514 cell0.CB_0.config_dataA\[11\] vssd1 vssd1 vccd1 vccd1 net514 sky130_fd_sc_hd__buf_2
XANTENNA_clkbuf_4_9_0_clk_X clknet_4_9_0_clk vssd1 vssd1 vccd1 vccd1 sky130_fd_sc_hd__diode_2
Xfanout503 cell0.CB_1.config_dataB\[10\] vssd1 vssd1 vccd1 vccd1 net503 sky130_fd_sc_hd__clkbuf_2
X_09834_ bus3_2\[8\] bus3_2\[9\] bus3_2\[10\] bus3_2\[11\] net442 cell2.CB_1.config_dataA\[11\]
+ vssd1 vssd1 vccd1 vccd1 _04840_ sky130_fd_sc_hd__mux4_1
XANTENNA__11874__S net883 vssd1 vssd1 vccd1 vccd1 sky130_fd_sc_hd__diode_2
Xfanout525 cell0.CB_0.config_dataB\[15\] vssd1 vssd1 vccd1 vccd1 net525 sky130_fd_sc_hd__clkbuf_2
Xfanout547 cell0.CB_1.config_dataA\[0\] vssd1 vssd1 vccd1 vccd1 net547 sky130_fd_sc_hd__buf_2
Xfanout536 cell0.CB_1.config_dataA\[15\] vssd1 vssd1 vccd1 vccd1 net536 sky130_fd_sc_hd__buf_2
XANTENNA__10542__B1 cell3.SB0.route_sel\[21\] vssd1 vssd1 vccd1 vccd1 sky130_fd_sc_hd__diode_2
XTAP_TAPCELL_ROW_70_1358 vssd1 vccd1 sky130_fd_sc_hd__tapvpwrvgnd_1
Xfanout569 net570 vssd1 vssd1 vccd1 vccd1 net569 sky130_fd_sc_hd__clkbuf_4
Xfanout558 net559 vssd1 vssd1 vccd1 vccd1 net558 sky130_fd_sc_hd__clkbuf_4
X_09765_ net444 _04298_ _04770_ net443 vssd1 vssd1 vccd1 vccd1 _04771_ sky130_fd_sc_hd__o211a_1
X_06977_ cell1.SB0.route_sel\[70\] cell1.SB0.route_sel\[71\] _02018_ _02042_ vssd1
+ vssd1 vccd1 vccd1 _02043_ sky130_fd_sc_hd__a211o_1
XANTENNA__11098__A1 net50 vssd1 vssd1 vccd1 vccd1 sky130_fd_sc_hd__diode_2
X_09696_ _01825_ _04707_ _04709_ vssd1 vssd1 vccd1 vccd1 _04710_ sky130_fd_sc_hd__a21oi_1
X_08716_ cell1.CB_1.config_dataB\[12\] _03741_ _03745_ _03749_ vssd1 vssd1 vccd1 vccd1
+ _03750_ sky130_fd_sc_hd__o211a_1
XFILLER_92_29 vccd1 vssd1 vccd1 vssd1 sky130_ef_sc_hd__decap_40_12
XANTENNA_fanout350_X net350 vssd1 vssd1 vccd1 vccd1 sky130_fd_sc_hd__diode_2
X_08647_ _03514_ _03670_ _03671_ _03517_ cell1.CB_1.config_dataB\[7\] vssd1 vssd1
+ vccd1 vccd1 _03681_ sky130_fd_sc_hd__a221o_1
XANTENNA_fanout827_A net828 vssd1 vssd1 vccd1 vccd1 sky130_fd_sc_hd__diode_2
XTAP_TAPCELL_ROW_85_1590 vssd1 vccd1 sky130_fd_sc_hd__tapvpwrvgnd_1
X_08578_ _03596_ _03600_ _03613_ cell1.CB_1.config_dataA\[14\] vssd1 vssd1 vccd1 vccd1
+ _03614_ sky130_fd_sc_hd__a211o_1
XFILLER_25_67 vssd1 vssd1 vccd1 vccd1 sky130_fd_sc_hd__fill_1
X_07529_ cell1.SB0.route_sel\[122\] _01552_ cell1.SB0.route_sel\[125\] _01553_ _02580_
+ vssd1 vssd1 vccd1 vccd1 _02581_ sky130_fd_sc_hd__a221o_1
X_10540_ _05493_ _05496_ _05497_ _01787_ vssd1 vssd1 vccd1 vccd1 _05498_ sky130_fd_sc_hd__a22o_1
XFILLER_10_512 vssd1 vssd1 vccd1 vccd1 sky130_fd_sc_hd__fill_1
XFILLER_10_523 vssd1 vssd1 vccd1 vccd1 sky130_fd_sc_hd__fill_1
XANTENNA__10238__B _05128_ vssd1 vssd1 vccd1 vccd1 sky130_fd_sc_hd__diode_2
X_10471_ _04714_ _05454_ vssd1 vssd1 vccd1 vccd1 bus3_2\[14\] sky130_fd_sc_hd__nor2_2
XANTENNA__09215__A1 net301 vssd1 vssd1 vccd1 vccd1 sky130_fd_sc_hd__diode_2
XANTENNA__11022__A1 _05890_ vssd1 vssd1 vccd1 vccd1 sky130_fd_sc_hd__diode_2
X_12210_ cell2.CB_1.config_dataA\[23\] cell2.CB_1.config_dataA\[22\] net836 vssd1
+ vssd1 vccd1 vccd1 _00643_ sky130_fd_sc_hd__mux2_1
X_13190_ clknet_leaf_119_clk _00162_ net598 vssd1 vssd1 vccd1 vccd1 cell0.LE_0B.reset_mode
+ sky130_fd_sc_hd__dfrtp_1
XANTENNA__08569__A3 net7 vssd1 vssd1 vccd1 vccd1 sky130_fd_sc_hd__diode_2
XANTENNA__08974__B1 _04005_ vssd1 vssd1 vccd1 vccd1 sky130_fd_sc_hd__diode_2
X_12141_ net1338 cell1.LEI0.config_data\[22\] net893 vssd1 vssd1 vccd1 vccd1 _00574_
+ sky130_fd_sc_hd__mux2_1
Xhold590 cell2.LEI0.config_data\[12\] vssd1 vssd1 vccd1 vccd1 net1549 sky130_fd_sc_hd__dlygate4sd3_1
XFILLER_96_309 vssd1 vssd1 vccd1 vccd1 sky130_fd_sc_hd__fill_1
X_12072_ net1492 cell1.LE_1B.reset_mode net905 vssd1 vssd1 vccd1 vccd1 _00507_ sky130_fd_sc_hd__mux2_1
XFILLER_2_755 vssd1 vssd1 vccd1 vccd1 sky130_fd_sc_hd__fill_1
XFILLER_1_221 vssd1 vssd1 vccd1 vccd1 sky130_fd_sc_hd__fill_2
X_11023_ _05898_ _05965_ vssd1 vssd1 vccd1 vccd1 _05977_ sky130_fd_sc_hd__and2_1
XFILLER_110_108 vssd1 vssd1 vccd1 vccd1 sky130_fd_sc_hd__fill_1
XFILLER_104_683 vssd1 vssd1 vccd1 vccd1 sky130_fd_sc_hd__fill_1
XFILLER_131_491 vssd1 vssd1 vccd1 vccd1 sky130_fd_sc_hd__fill_1
XFILLER_2_27 vssd1 vssd1 vccd1 vccd1 sky130_fd_sc_hd__fill_1
XANTENNA__08741__A3 net7 vssd1 vssd1 vccd1 vccd1 sky130_fd_sc_hd__diode_2
X_12974_ cell3.LE_0A.edge_mode cell3.LE_0A.config_data\[16\] net928 vssd1 vssd1 vccd1
+ vccd1 _01402_ sky130_fd_sc_hd__mux2_1
XANTENNA__07850__X _02894_ vssd1 vssd1 vccd1 vccd1 sky130_fd_sc_hd__diode_2
X_11925_ cell0.SB0.route_sel\[31\] cell0.SB0.route_sel\[30\] net760 vssd1 vssd1 vccd1
+ vccd1 _00362_ sky130_fd_sc_hd__mux2_1
XFILLER_60_423 vssd1 vssd1 vccd1 vccd1 sky130_fd_sc_hd__fill_1
XANTENNA__11372__X net256 vssd1 vssd1 vccd1 vccd1 sky130_fd_sc_hd__diode_2
X_11856_ cell1.CB_0.config_dataB\[12\] net478 net895 vssd1 vssd1 vccd1 vccd1 _00293_
+ sky130_fd_sc_hd__mux2_1
XANTENNA__06907__A bus3_1\[7\] vssd1 vssd1 vccd1 vccd1 sky130_fd_sc_hd__diode_2
X_10807_ net367 net366 vssd1 vssd1 vccd1 vccd1 _05763_ sky130_fd_sc_hd__or2_1
X_11787_ net1471 net1455 net793 vssd1 vssd1 vccd1 vccd1 _00224_ sky130_fd_sc_hd__mux2_1
XFILLER_20_309 vccd1 vssd1 vccd1 vssd1 sky130_ef_sc_hd__decap_40_12
XFILLER_32_169 vssd1 vssd1 vccd1 vccd1 sky130_fd_sc_hd__fill_2
XANTENNA__08257__A2 cell0.CB_1.le_outA vssd1 vssd1 vccd1 vccd1 sky130_fd_sc_hd__diode_2
X_10738_ _05528_ _05691_ _05693_ _05531_ _01777_ vssd1 vssd1 vccd1 vccd1 _05694_ sky130_fd_sc_hd__a221o_1
XANTENNA__09002__B _03885_ vssd1 vssd1 vccd1 vccd1 sky130_fd_sc_hd__diode_2
X_13526_ clknet_leaf_100_clk net992 net679 vssd1 vssd1 vccd1 vccd1 cell1.LE_1A.config_data\[13\]
+ sky130_fd_sc_hd__dfrtp_1
XANTENNA__07136__B1_N net66 vssd1 vssd1 vccd1 vccd1 sky130_fd_sc_hd__diode_2
XANTENNA__08009__A2 bus2_0\[2\] vssd1 vssd1 vccd1 vccd1 sky130_fd_sc_hd__diode_2
X_13457_ clknet_leaf_2_clk _00429_ net569 vssd1 vssd1 vccd1 vccd1 cell0.SB0.route_sel\[98\]
+ sky130_fd_sc_hd__dfstp_1
XPHY_EDGE_ROW_124_Right_124 vssd1 vssd1 vccd1 vccd1 sky130_fd_sc_hd__decap_3
X_10669_ _05513_ _05603_ vssd1 vssd1 vccd1 vccd1 _05627_ sky130_fd_sc_hd__and2b_1
X_12408_ cell2.CB_1.config_dataB\[18\] cell2.CB_1.config_dataB\[17\] net833 vssd1
+ vssd1 vccd1 vccd1 _00841_ sky130_fd_sc_hd__mux2_1
XANTENNA__09757__A2 bus3_2\[10\] vssd1 vssd1 vccd1 vccd1 sky130_fd_sc_hd__diode_2
X_13388_ clknet_leaf_133_clk _00360_ net556 vssd1 vssd1 vccd1 vccd1 cell0.SB0.route_sel\[29\]
+ sky130_fd_sc_hd__dfstp_1
XANTENNA__07738__A net27 vssd1 vssd1 vccd1 vccd1 sky130_fd_sc_hd__diode_2
Xoutput139 net139 vssd1 vssd1 vccd1 vccd1 CBeast_out[14] sky130_fd_sc_hd__buf_2
X_12339_ cell1.SB0.route_sel\[77\] cell1.SB0.route_sel\[76\] net865 vssd1 vssd1 vccd1
+ vccd1 _00772_ sky130_fd_sc_hd__mux2_1
X_14009_ clknet_leaf_79_clk _00981_ net708 vssd1 vssd1 vccd1 vccd1 cell3.SB0.route_sel\[17\]
+ sky130_fd_sc_hd__dfstp_1
X_06900_ cell1.SB0.route_sel\[58\] cell1.SB0.route_sel\[59\] _01967_ vssd1 vssd1 vccd1
+ vccd1 _01968_ sky130_fd_sc_hd__a21oi_1
XTAP_TAPCELL_ROW_110_1959 vssd1 vccd1 sky130_fd_sc_hd__tapvpwrvgnd_1
X_07880_ net521 _02894_ _02923_ net520 vssd1 vssd1 vccd1 vccd1 _02924_ sky130_fd_sc_hd__o211a_1
X_06831_ cell2.CB_1.config_dataA\[24\] cell2.CB_1.config_dataA\[20\] cell2.CB_1.config_dataA\[21\]
+ vssd1 vssd1 vccd1 vccd1 _01900_ sky130_fd_sc_hd__or3b_2
XTAP_TAPCELL_ROW_52_1088 vssd1 vccd1 sky130_fd_sc_hd__tapvpwrvgnd_1
X_06762_ net317 vssd1 vssd1 vccd1 vccd1 _01832_ sky130_fd_sc_hd__inv_2
XFILLER_95_397 vssd1 vssd1 vccd1 vccd1 sky130_fd_sc_hd__fill_1
XFILLER_83_526 vssd1 vssd1 vccd1 vccd1 sky130_fd_sc_hd__fill_2
X_09550_ _04562_ _04568_ _04564_ vssd1 vssd1 vccd1 vccd1 _04569_ sky130_fd_sc_hd__a21o_1
X_09481_ _01998_ _04499_ _04501_ vssd1 vssd1 vccd1 vccd1 _04502_ sky130_fd_sc_hd__o21ai_1
X_08501_ _02866_ _03536_ vssd1 vssd1 vccd1 vccd1 _03537_ sky130_fd_sc_hd__or2_4
X_06693_ cell2.LE_0B.config_data\[16\] vssd1 vssd1 vccd1 vccd1 _01763_ sky130_fd_sc_hd__inv_2
XANTENNA__11282__X net171 vssd1 vssd1 vccd1 vccd1 sky130_fd_sc_hd__diode_2
X_08432_ _02295_ _03467_ vssd1 vssd1 vccd1 vccd1 _03468_ sky130_fd_sc_hd__nor2_4
XFILLER_36_475 vssd1 vssd1 vccd1 vccd1 sky130_fd_sc_hd__fill_1
XFILLER_51_423 vssd1 vssd1 vccd1 vccd1 sky130_fd_sc_hd__fill_1
X_08363_ bus1_0\[0\] bus1_0\[1\] bus1_0\[2\] bus1_0\[3\] net504 net502 vssd1 vssd1
+ vccd1 vccd1 _03401_ sky130_fd_sc_hd__mux4_1
X_07314_ cell1.SB0.route_sel\[97\] cell1.SB0.route_sel\[96\] _02371_ vssd1 vssd1 vccd1
+ vccd1 _02372_ sky130_fd_sc_hd__a21oi_1
X_08294_ cell0.CB_1.config_dataB\[8\] cell0.CB_1.config_dataB\[7\] vssd1 vssd1 vccd1
+ vccd1 _03332_ sky130_fd_sc_hd__nor2_1
XFILLER_109_208 vssd1 vssd1 vccd1 vccd1 sky130_fd_sc_hd__fill_1
X_07245_ _02268_ _02271_ _02302_ _02303_ vssd1 vssd1 vccd1 vccd1 _02304_ sky130_fd_sc_hd__a31o_1
XANTENNA_fanout310_A net313 vssd1 vssd1 vccd1 vccd1 sky130_fd_sc_hd__diode_2
Xclkbuf_1_1__f_cell1.LE_1B.sel_clk clknet_0_cell1.LE_1B.sel_clk vssd1 vssd1 vccd1
+ vccd1 clknet_1_1__leaf_cell1.LE_1B.sel_clk sky130_fd_sc_hd__clkbuf_16
X_07176_ cell2.SB0.route_sel\[84\] cell2.SB0.route_sel\[85\] _02203_ vssd1 vssd1 vccd1
+ vccd1 _02237_ sky130_fd_sc_hd__a21o_1
XANTENNA__10763__A0 net286 vssd1 vssd1 vccd1 vccd1 sky130_fd_sc_hd__diode_2
XFILLER_11_69 vccd1 vssd1 vccd1 vssd1 sky130_ef_sc_hd__decap_40_12
XFILLER_127_69 vssd1 vssd1 vccd1 vccd1 sky130_fd_sc_hd__fill_1
Xfanout311 net313 vssd1 vssd1 vccd1 vccd1 net311 sky130_fd_sc_hd__buf_2
XANTENNA_fanout398_X net398 vssd1 vssd1 vccd1 vccd1 sky130_fd_sc_hd__diode_2
XANTENNA__08708__A0 net29 vssd1 vssd1 vccd1 vccd1 sky130_fd_sc_hd__diode_2
Xfanout322 cell1.CB_1.le_outB vssd1 vssd1 vccd1 vccd1 net322 sky130_fd_sc_hd__buf_2
Xfanout366 cell3.CB_1.config_dataB\[11\] vssd1 vssd1 vccd1 vccd1 net366 sky130_fd_sc_hd__buf_2
Xfanout344 cell0.CB_0.le_outA vssd1 vssd1 vccd1 vccd1 net344 sky130_fd_sc_hd__buf_2
Xfanout355 _02110_ vssd1 vssd1 vccd1 vccd1 net355 sky130_fd_sc_hd__clkbuf_4
Xfanout333 net334 vssd1 vssd1 vccd1 vccd1 net333 sky130_fd_sc_hd__buf_2
Xfanout377 cell3.CB_0.config_dataA\[5\] vssd1 vssd1 vccd1 vccd1 net377 sky130_fd_sc_hd__buf_2
Xfanout388 cell3.CB_0.config_dataB\[1\] vssd1 vssd1 vccd1 vccd1 net388 sky130_fd_sc_hd__buf_2
XANTENNA_fanout944_A net959 vssd1 vssd1 vccd1 vccd1 sky130_fd_sc_hd__diode_2
X_09817_ cell2.CB_1.config_dataA\[2\] _04814_ _04818_ _04822_ vssd1 vssd1 vccd1 vccd1
+ _04823_ sky130_fd_sc_hd__o211a_1
Xfanout399 cell2.CB_1.config_dataB\[16\] vssd1 vssd1 vccd1 vccd1 net399 sky130_fd_sc_hd__buf_2
XFILLER_47_729 vssd1 vssd1 vccd1 vccd1 sky130_fd_sc_hd__fill_1
X_09748_ _04754_ _04442_ vssd1 vssd1 vccd1 vccd1 bus2_0\[5\] sky130_fd_sc_hd__and2b_4
XANTENNA__08198__B _02277_ vssd1 vssd1 vccd1 vccd1 sky130_fd_sc_hd__diode_2
XFILLER_36_22 vssd1 vssd1 vccd1 vccd1 sky130_fd_sc_hd__fill_4
XANTENNA__09684__B2 _02518_ vssd1 vssd1 vccd1 vccd1 sky130_fd_sc_hd__diode_2
X_09679_ cell3.SB0.route_sel\[117\] cell3.SB0.route_sel\[116\] _02512_ _04691_ _02509_
+ vssd1 vssd1 vccd1 vccd1 _04693_ sky130_fd_sc_hd__a221o_1
X_11710_ net1264 net1240 net805 vssd1 vssd1 vccd1 vccd1 _00149_ sky130_fd_sc_hd__mux2_1
XANTENNA__10294__A2 net55 vssd1 vssd1 vccd1 vccd1 sky130_fd_sc_hd__diode_2
X_12690_ cell3.CB_1.config_dataA\[7\] cell3.CB_1.config_dataA\[6\] net937 vssd1 vssd1
+ vccd1 vccd1 _01119_ sky130_fd_sc_hd__mux2_1
XTAP_TAPCELL_ROW_83_1549 vssd1 vccd1 sky130_fd_sc_hd__tapvpwrvgnd_1
XANTENNA__08418__S _03347_ vssd1 vssd1 vccd1 vccd1 sky130_fd_sc_hd__diode_2
XANTENNA_input108_A SBwest_in[1] vssd1 vssd1 vccd1 vccd1 sky130_fd_sc_hd__diode_2
X_11641_ cell0.CB_0.config_dataA\[12\] net514 net771 vssd1 vssd1 vccd1 vccd1 _00082_
+ sky130_fd_sc_hd__mux2_1
XTAP_TAPCELL_ROW_25_676 vssd1 vccd1 sky130_fd_sc_hd__tapvpwrvgnd_1
XANTENNA__08239__A2 bus1_0\[10\] vssd1 vssd1 vccd1 vccd1 sky130_fd_sc_hd__diode_2
XFILLER_30_607 vssd1 vssd1 vccd1 vccd1 sky130_fd_sc_hd__fill_1
X_14360_ clknet_leaf_73_clk _01332_ net729 vssd1 vssd1 vccd1 vccd1 cell3.CB_1.config_dataB\[17\]
+ sky130_fd_sc_hd__dfstp_2
X_11572_ net1262 cell0.LE_1B.config_data\[12\] net799 vssd1 vssd1 vccd1 vccd1 _00013_
+ sky130_fd_sc_hd__mux2_1
XFILLER_11_843 vssd1 vssd1 vccd1 vccd1 sky130_fd_sc_hd__fill_1
XTAP_TAPCELL_ROW_25_687 vssd1 vccd1 sky130_fd_sc_hd__tapvpwrvgnd_1
Xinput19 CBeast_in[26] vssd1 vssd1 vccd1 vccd1 net19 sky130_fd_sc_hd__clkbuf_4
X_10523_ cell3.SB0.route_sel\[40\] _01704_ cell3.SB0.route_sel\[44\] cell3.SB0.route_sel\[45\]
+ vssd1 vssd1 vccd1 vccd1 _05481_ sky130_fd_sc_hd__o22a_1
X_13311_ clknet_leaf_79_clk _00283_ net708 vssd1 vssd1 vccd1 vccd1 cell1.CB_0.config_dataB\[2\]
+ sky130_fd_sc_hd__dfstp_1
XFILLER_6_302 vssd1 vssd1 vccd1 vccd1 sky130_fd_sc_hd__fill_4
X_14291_ clknet_leaf_8_clk _01263_ net572 vssd1 vssd1 vccd1 vccd1 cell2.SB0.route_sel\[76\]
+ sky130_fd_sc_hd__dfstp_1
XFILLER_7_847 vssd1 vssd1 vccd1 vccd1 sky130_fd_sc_hd__fill_1
XFILLER_136_561 vssd1 vssd1 vccd1 vccd1 sky130_fd_sc_hd__fill_1
XTAP_TAPCELL_ROW_114_2015 vssd1 vccd1 sky130_fd_sc_hd__tapvpwrvgnd_1
XTAP_TAPCELL_ROW_98_1781 vssd1 vccd1 sky130_fd_sc_hd__tapvpwrvgnd_1
X_10454_ _01724_ cell3.SB0.route_sel\[74\] vssd1 vssd1 vccd1 vccd1 _05443_ sky130_fd_sc_hd__nand2_1
X_13242_ clknet_leaf_11_clk net1442 net586 vssd1 vssd1 vccd1 vccd1 cell0.LEI0.config_data\[27\]
+ sky130_fd_sc_hd__dfrtp_1
XANTENNA_input73_A SBsouth_in[17] vssd1 vssd1 vccd1 vccd1 sky130_fd_sc_hd__diode_2
X_10385_ net425 _05107_ _05383_ net423 vssd1 vssd1 vccd1 vccd1 _05384_ sky130_fd_sc_hd__o211a_1
X_13173_ clknet_leaf_14_clk net1170 net598 vssd1 vssd1 vccd1 vccd1 cell0.LE_0B.config_data\[2\]
+ sky130_fd_sc_hd__dfrtp_1
X_12124_ cell1.LEI0.config_data\[6\] net1129 net904 vssd1 vssd1 vccd1 vccd1 _00557_
+ sky130_fd_sc_hd__mux2_1
XFILLER_124_789 vssd1 vssd1 vccd1 vccd1 sky130_fd_sc_hd__fill_1
XFILLER_111_406 vssd1 vssd1 vccd1 vccd1 sky130_fd_sc_hd__fill_2
XFILLER_78_821 vssd1 vssd1 vccd1 vccd1 sky130_fd_sc_hd__fill_1
XFILLER_2_585 vssd1 vssd1 vccd1 vccd1 sky130_fd_sc_hd__fill_2
X_12055_ net1031 net995 net889 vssd1 vssd1 vccd1 vccd1 _00491_ sky130_fd_sc_hd__mux2_1
XFILLER_28_8 vccd1 vssd1 vccd1 vssd1 sky130_ef_sc_hd__decap_40_12
X_11006_ cell3.CB_0.config_dataA\[9\] _05935_ _05950_ _05959_ _01808_ vssd1 vssd1
+ vccd1 vccd1 _05960_ sky130_fd_sc_hd__a32oi_1
XFILLER_92_323 vssd1 vssd1 vccd1 vccd1 sky130_fd_sc_hd__fill_2
XFILLER_77_386 vssd1 vssd1 vccd1 vccd1 sky130_fd_sc_hd__fill_4
XTAP_TAPCELL_ROW_5_390 vssd1 vccd1 sky130_fd_sc_hd__tapvpwrvgnd_1
XTAP_TAPCELL_ROW_125_2177 vssd1 vccd1 sky130_fd_sc_hd__tapvpwrvgnd_1
XFILLER_92_356 vssd1 vssd1 vccd1 vccd1 sky130_fd_sc_hd__fill_1
XFILLER_65_559 vssd1 vssd1 vccd1 vccd1 sky130_fd_sc_hd__fill_1
XANTENNA__07580__X _02630_ vssd1 vssd1 vccd1 vccd1 sky130_fd_sc_hd__diode_2
XTAP_TAPCELL_ROW_125_2188 vssd1 vccd1 sky130_fd_sc_hd__tapvpwrvgnd_1
X_12957_ net1518 cell2.SB0.config_data_out net848 vssd1 vssd1 vccd1 vccd1 _01385_
+ sky130_fd_sc_hd__mux2_1
XANTENNA__11543__A _02675_ vssd1 vssd1 vccd1 vccd1 sky130_fd_sc_hd__diode_2
XFILLER_18_475 vssd1 vssd1 vccd1 vccd1 sky130_fd_sc_hd__fill_1
X_12888_ cell3.CB_1.config_dataB\[2\] net370 net943 vssd1 vssd1 vccd1 vccd1 _01317_
+ sky130_fd_sc_hd__mux2_1
XANTENNA__07686__B1 bus3_1\[2\] vssd1 vssd1 vccd1 vccd1 sky130_fd_sc_hd__diode_2
X_11908_ cell0.SB0.route_sel\[14\] cell0.SB0.route_sel\[13\] net762 vssd1 vssd1 vccd1
+ vccd1 _00345_ sky130_fd_sc_hd__mux2_1
XTAP_TAPCELL_ROW_44_974 vssd1 vccd1 sky130_fd_sc_hd__tapvpwrvgnd_1
XTAP_TAPCELL_ROW_44_963 vssd1 vccd1 sky130_fd_sc_hd__tapvpwrvgnd_1
X_11839_ cell1.CB_1.config_dataA\[20\] cell1.CB_1.config_dataA\[19\] net886 vssd1
+ vssd1 vccd1 vccd1 _00276_ sky130_fd_sc_hd__mux2_1
XANTENNA__07150__A2 net357 vssd1 vssd1 vccd1 vccd1 sky130_fd_sc_hd__diode_2
XANTENNA__09978__A2 _04583_ vssd1 vssd1 vccd1 vccd1 sky130_fd_sc_hd__diode_2
XANTENNA__10037__A2 _04696_ vssd1 vssd1 vccd1 vccd1 sky130_fd_sc_hd__diode_2
XANTENNA__07989__B2 _02456_ vssd1 vssd1 vccd1 vccd1 sky130_fd_sc_hd__diode_2
XANTENNA__07989__A1 _02388_ vssd1 vssd1 vccd1 vccd1 sky130_fd_sc_hd__diode_2
X_13509_ clknet_leaf_102_clk _00481_ net676 vssd1 vssd1 vccd1 vccd1 cell1.CB_1.config_dataB\[22\]
+ sky130_fd_sc_hd__dfstp_1
X_07030_ cell2.CB_0.config_dataB\[24\] cell2.CB_0.config_dataB\[21\] cell2.CB_0.config_dataB\[20\]
+ vssd1 vssd1 vccd1 vccd1 _02095_ sky130_fd_sc_hd__or3_1
XTAP_TAPCELL_ROW_54_1117 vssd1 vccd1 sky130_fd_sc_hd__tapvpwrvgnd_1
XFILLER_142_575 vssd1 vssd1 vccd1 vccd1 sky130_fd_sc_hd__fill_1
XFILLER_102_417 vssd1 vssd1 vccd1 vccd1 sky130_fd_sc_hd__fill_1
X_08981_ _04012_ _04011_ _03902_ vssd1 vssd1 vccd1 vccd1 _04013_ sky130_fd_sc_hd__mux2_1
X_07932_ net342 net346 net350 net338 cell0.LEI0.config_data\[24\] cell0.LEI0.config_data\[25\]
+ vssd1 vssd1 vccd1 vccd1 _02976_ sky130_fd_sc_hd__mux4_1
XANTENNA__11170__A0 _05893_ vssd1 vssd1 vccd1 vccd1 sky130_fd_sc_hd__diode_2
X_07863_ _02883_ _02891_ _02899_ _02906_ vssd1 vssd1 vccd1 vccd1 _02907_ sky130_fd_sc_hd__o22a_1
XFILLER_3_81 vccd1 vssd1 vccd1 vssd1 sky130_ef_sc_hd__decap_40_12
XANTENNA__08705__A3 net26 vssd1 vssd1 vccd1 vccd1 sky130_fd_sc_hd__diode_2
XFILLER_113_27 vccd1 vssd1 vccd1 vssd1 sky130_ef_sc_hd__decap_40_12
XFILLER_84_835 vssd1 vssd1 vccd1 vccd1 sky130_fd_sc_hd__fill_1
X_09602_ _04356_ _04537_ vssd1 vssd1 vccd1 vccd1 _04619_ sky130_fd_sc_hd__or2_1
XFILLER_68_386 vssd1 vssd1 vccd1 vccd1 sky130_fd_sc_hd__fill_1
X_06814_ cell1.CB_0.config_dataA\[24\] cell1.CB_0.config_dataA\[20\] cell1.CB_0.config_dataA\[21\]
+ vssd1 vssd1 vccd1 vccd1 _01884_ sky130_fd_sc_hd__or3b_2
XTAP_TAPCELL_ROW_3_349 vssd1 vccd1 sky130_fd_sc_hd__tapvpwrvgnd_1
X_09533_ _04550_ _04552_ vssd1 vssd1 vccd1 vccd1 bus3_1\[8\] sky130_fd_sc_hd__and2_2
X_07794_ _02833_ _02838_ vssd1 vssd1 vccd1 vccd1 _02839_ sky130_fd_sc_hd__nor2_1
XFILLER_83_378 vssd1 vssd1 vccd1 vccd1 sky130_fd_sc_hd__fill_1
XFILLER_71_529 vssd1 vssd1 vccd1 vccd1 sky130_fd_sc_hd__fill_1
X_06745_ cell0.SB0.route_sel\[1\] vssd1 vssd1 vccd1 vccd1 _01815_ sky130_fd_sc_hd__inv_2
X_09464_ net47 _04485_ vssd1 vssd1 vccd1 vccd1 _04486_ sky130_fd_sc_hd__or2_1
X_06676_ cell3.SB0.route_sel\[119\] vssd1 vssd1 vccd1 vccd1 _01746_ sky130_fd_sc_hd__inv_2
XFILLER_24_423 vssd1 vssd1 vccd1 vccd1 sky130_fd_sc_hd__fill_1
XFILLER_24_434 vccd1 vssd1 vccd1 vssd1 sky130_ef_sc_hd__decap_40_12
X_09395_ _04374_ _04411_ _04418_ vssd1 vssd1 vccd1 vccd1 _04419_ sky130_fd_sc_hd__a21oi_2
XTAP_TAPCELL_ROW_65_1279 vssd1 vccd1 sky130_fd_sc_hd__tapvpwrvgnd_1
X_08415_ _03417_ _03452_ _03415_ vssd1 vssd1 vccd1 vccd1 _03453_ sky130_fd_sc_hd__mux2_1
X_08346_ net502 net503 vssd1 vssd1 vccd1 vccd1 _03384_ sky130_fd_sc_hd__and2b_1
XFILLER_11_117 vssd1 vssd1 vccd1 vccd1 sky130_fd_sc_hd__fill_2
XTAP_TAPCELL_ROW_22_635 vssd1 vccd1 sky130_fd_sc_hd__tapvpwrvgnd_1
XFILLER_138_837 vssd1 vssd1 vccd1 vccd1 sky130_fd_sc_hd__fill_2
XANTENNA__09969__A2 _04696_ vssd1 vssd1 vccd1 vccd1 sky130_fd_sc_hd__diode_2
XANTENNA__11599__S net790 vssd1 vssd1 vccd1 vccd1 sky130_fd_sc_hd__diode_2
XANTENNA__10984__A0 net49 vssd1 vssd1 vccd1 vccd1 sky130_fd_sc_hd__diode_2
XANTENNA_fanout313_X net313 vssd1 vssd1 vccd1 vccd1 sky130_fd_sc_hd__diode_2
X_08277_ cell0.CB_1.config_dataB\[6\] _01490_ vssd1 vssd1 vccd1 vccd1 _03315_ sky130_fd_sc_hd__nor2_1
XFILLER_4_817 vssd1 vssd1 vccd1 vccd1 sky130_fd_sc_hd__fill_2
X_07228_ cell1.SB0.route_sel\[90\] cell1.SB0.route_sel\[91\] _02281_ _02282_ _02287_
+ vssd1 vssd1 vccd1 vccd1 _02288_ sky130_fd_sc_hd__a41o_1
XANTENNA_fanout894_A net898 vssd1 vssd1 vccd1 vccd1 sky130_fd_sc_hd__diode_2
XFILLER_3_305 vccd1 vssd1 vccd1 vssd1 sky130_ef_sc_hd__decap_40_12
X_07159_ _01821_ _01841_ _02051_ vssd1 vssd1 vccd1 vccd1 _02221_ sky130_fd_sc_hd__or3_1
XFILLER_3_349 vssd1 vssd1 vccd1 vccd1 sky130_fd_sc_hd__fill_4
X_10170_ net422 _05144_ vssd1 vssd1 vccd1 vccd1 _05171_ sky130_fd_sc_hd__nand2_1
XANTENNA__07601__B1 bus3_1\[0\] vssd1 vssd1 vccd1 vccd1 sky130_fd_sc_hd__diode_2
XANTENNA__12223__S net824 vssd1 vssd1 vccd1 vccd1 sky130_fd_sc_hd__diode_2
XANTENNA__11347__B _05874_ vssd1 vssd1 vccd1 vccd1 sky130_fd_sc_hd__diode_2
XFILLER_74_323 vssd1 vssd1 vccd1 vccd1 sky130_fd_sc_hd__fill_2
XFILLER_19_206 vssd1 vssd1 vccd1 vccd1 sky130_fd_sc_hd__fill_1
XFILLER_19_217 vssd1 vssd1 vccd1 vccd1 sky130_fd_sc_hd__fill_1
XFILLER_19_228 vssd1 vssd1 vccd1 vccd1 sky130_fd_sc_hd__fill_1
X_13860_ clknet_leaf_44_clk _00832_ net643 vssd1 vssd1 vccd1 vccd1 cell2.CB_1.config_dataB\[9\]
+ sky130_fd_sc_hd__dfstp_1
XANTENNA__09106__A0 bus3_1\[6\] vssd1 vssd1 vccd1 vccd1 sky130_fd_sc_hd__diode_2
X_12811_ cell2.SB0.route_sel\[53\] cell2.SB0.route_sel\[52\] net811 vssd1 vssd1 vccd1
+ vccd1 _01240_ sky130_fd_sc_hd__mux2_1
X_13791_ clknet_leaf_104_clk _00763_ net662 vssd1 vssd1 vccd1 vccd1 cell1.SB0.route_sel\[68\]
+ sky130_fd_sc_hd__dfstp_1
X_12742_ cell3.CB_0.config_dataA\[9\] cell3.CB_0.config_dataA\[8\] net926 vssd1 vssd1
+ vccd1 vccd1 _01171_ sky130_fd_sc_hd__mux2_1
XFILLER_103_82 vssd1 vssd1 vccd1 vccd1 sky130_fd_sc_hd__fill_1
XANTENNA__07560__B net353 vssd1 vssd1 vccd1 vccd1 sky130_fd_sc_hd__diode_2
X_12673_ cell3.LE_1B.config_data\[10\] net1159 net955 vssd1 vssd1 vccd1 vccd1 _01102_
+ sky130_fd_sc_hd__mux2_1
XPHY_EDGE_ROW_69_Right_69 vssd1 vssd1 vccd1 vccd1 sky130_fd_sc_hd__decap_3
XFILLER_63_53 vssd1 vssd1 vccd1 vccd1 sky130_fd_sc_hd__fill_1
Xclkbuf_0_cell0.LE_1A.sel_clk cell0.LE_1A.sel_clk vssd1 vssd1 vccd1 vccd1 clknet_0_cell0.LE_1A.sel_clk
+ sky130_fd_sc_hd__clkbuf_16
X_14412_ clknet_1_1__leaf_cell3.LE_0B.sel_clk _01384_ net754 vssd1 vssd1 vccd1 vccd1
+ cell3.LE_0B.dff0_out sky130_fd_sc_hd__dfrtp_1
XANTENNA__11216__A1 _05879_ vssd1 vssd1 vccd1 vccd1 sky130_fd_sc_hd__diode_2
X_11624_ cell0.CB_0.config_dataB\[20\] cell0.CB_0.config_dataB\[19\] net776 vssd1
+ vssd1 vccd1 vccd1 _00065_ sky130_fd_sc_hd__mux2_1
XTAP_TAPCELL_ROW_41_922 vssd1 vccd1 sky130_fd_sc_hd__tapvpwrvgnd_1
XFILLER_8_15 vccd1 vssd1 vccd1 vssd1 sky130_ef_sc_hd__decap_40_12
XANTENNA__11216__B2 _05883_ vssd1 vssd1 vccd1 vccd1 sky130_fd_sc_hd__diode_2
X_14343_ clknet_leaf_76_clk _01315_ net732 vssd1 vssd1 vccd1 vccd1 cell3.CB_1.config_dataB\[0\]
+ sky130_fd_sc_hd__dfstp_1
XFILLER_10_150 vssd1 vssd1 vccd1 vccd1 sky130_fd_sc_hd__fill_1
XFILLER_11_662 vssd1 vssd1 vccd1 vccd1 sky130_fd_sc_hd__fill_8
X_11555_ _06370_ net268 vssd1 vssd1 vccd1 vccd1 net223 sky130_fd_sc_hd__and2b_1
XFILLER_128_369 vssd1 vssd1 vccd1 vccd1 sky130_fd_sc_hd__fill_1
X_14274_ clknet_leaf_23_clk _01246_ net604 vssd1 vssd1 vccd1 vccd1 cell2.SB0.route_sel\[59\]
+ sky130_fd_sc_hd__dfstp_1
X_11486_ _02579_ _06324_ vssd1 vssd1 vccd1 vccd1 net222 sky130_fd_sc_hd__and2_1
XFILLER_6_121 vccd1 vssd1 vccd1 vssd1 sky130_ef_sc_hd__decap_40_12
XANTENNA_input76_X net76 vssd1 vssd1 vccd1 vccd1 sky130_fd_sc_hd__diode_2
X_10506_ _05468_ net335 _02284_ vssd1 vssd1 vccd1 vccd1 net136 sky130_fd_sc_hd__mux2_1
X_10437_ cell3.SB0.route_sel\[24\] cell3.SB0.route_sel\[25\] _01697_ cell3.SB0.route_sel\[28\]
+ _05431_ vssd1 vssd1 vccd1 vccd1 _05432_ sky130_fd_sc_hd__o221a_1
X_13225_ clknet_leaf_121_clk _00197_ net593 vssd1 vssd1 vccd1 vccd1 cell0.LEI0.config_data\[10\]
+ sky130_fd_sc_hd__dfrtp_1
XFILLER_136_380 vssd1 vssd1 vccd1 vccd1 sky130_fd_sc_hd__fill_1
XFILLER_124_531 vssd1 vssd1 vccd1 vccd1 sky130_fd_sc_hd__fill_1
XPHY_EDGE_ROW_78_Right_78 vssd1 vssd1 vccd1 vccd1 sky130_fd_sc_hd__decap_3
X_10368_ net429 _05084_ vssd1 vssd1 vccd1 vccd1 _05367_ sky130_fd_sc_hd__nand2_1
X_13156_ clknet_leaf_116_clk _00128_ net665 vssd1 vssd1 vccd1 vccd1 cell0.LE_1A.config_data\[7\]
+ sky130_fd_sc_hd__dfrtp_1
X_10299_ _05114_ _05281_ _05282_ _05111_ vssd1 vssd1 vccd1 vccd1 _05298_ sky130_fd_sc_hd__a2bb2o_1
XFILLER_88_83 vssd1 vssd1 vccd1 vccd1 sky130_fd_sc_hd__fill_1
X_12107_ net1281 net1141 net876 vssd1 vssd1 vccd1 vccd1 _00541_ sky130_fd_sc_hd__mux2_1
X_13087_ clknet_leaf_4_clk _00059_ net564 vssd1 vssd1 vccd1 vccd1 cell0.CB_0.config_dataB\[14\]
+ sky130_fd_sc_hd__dfstp_1
XTAP_TAPCELL_ROW_127_2217 vssd1 vccd1 sky130_fd_sc_hd__tapvpwrvgnd_1
XTAP_TAPCELL_ROW_127_2206 vssd1 vccd1 sky130_fd_sc_hd__tapvpwrvgnd_1
XANTENNA__11257__B _05144_ vssd1 vssd1 vccd1 vccd1 sky130_fd_sc_hd__diode_2
XANTENNA__08148__A1 bus1_0\[1\] vssd1 vssd1 vccd1 vccd1 sky130_fd_sc_hd__diode_2
X_12038_ net451 net452 net887 vssd1 vssd1 vccd1 vccd1 _00475_ sky130_fd_sc_hd__mux2_1
XPHY_EDGE_ROW_69_Left_212 vssd1 vssd1 vccd1 vccd1 sky130_fd_sc_hd__decap_3
XTAP_TAPCELL_ROW_140_2406 vssd1 vccd1 sky130_fd_sc_hd__tapvpwrvgnd_1
XTAP_TAPCELL_ROW_109_1950 vssd1 vccd1 sky130_fd_sc_hd__tapvpwrvgnd_1
XTAP_TAPCELL_ROW_0_308 vssd1 vccd1 sky130_fd_sc_hd__tapvpwrvgnd_1
X_13989_ clknet_leaf_43_clk _00961_ net633 vssd1 vssd1 vccd1 vccd1 cell2.LEI0.config_data\[46\]
+ sky130_fd_sc_hd__dfrtp_1
XANTENNA__10258__A2 net38 vssd1 vssd1 vccd1 vccd1 sky130_fd_sc_hd__diode_2
X_06530_ cell2.SB0.route_sel\[38\] vssd1 vssd1 vccd1 vccd1 _01600_ sky130_fd_sc_hd__inv_2
XPHY_EDGE_ROW_87_Right_87 vssd1 vssd1 vccd1 vccd1 sky130_fd_sc_hd__decap_3
XANTENNA__07659__B1 net119 vssd1 vssd1 vccd1 vccd1 sky130_fd_sc_hd__diode_2
X_06461_ cell1.SB0.route_sel\[76\] vssd1 vssd1 vccd1 vccd1 _01531_ sky130_fd_sc_hd__inv_2
X_08200_ _02037_ _02039_ _03234_ vssd1 vssd1 vccd1 vccd1 _03240_ sky130_fd_sc_hd__o21a_1
X_09180_ cell3.CB_1.config_dataA\[22\] cell3.CB_1.config_dataA\[23\] vssd1 vssd1 vccd1
+ vccd1 _04208_ sky130_fd_sc_hd__or2_1
XPHY_EDGE_ROW_78_Left_221 vssd1 vssd1 vccd1 vccd1 sky130_fd_sc_hd__decap_3
X_06392_ cell0.SB0.route_sel\[61\] vssd1 vssd1 vccd1 vccd1 _01462_ sky130_fd_sc_hd__inv_2
XTAP_TAPCELL_ROW_138_2379 vssd1 vccd1 sky130_fd_sc_hd__tapvpwrvgnd_1
X_08131_ net546 net544 _02040_ _03170_ vssd1 vssd1 vccd1 vccd1 _03171_ sky130_fd_sc_hd__o31a_1
X_08062_ _02902_ _03091_ _03092_ _02905_ cell0.CB_0.config_dataB\[12\] vssd1 vssd1
+ vccd1 vccd1 _03104_ sky130_fd_sc_hd__a221o_1
XANTENNA__07198__A _01933_ vssd1 vssd1 vccd1 vccd1 sky130_fd_sc_hd__diode_2
XPHY_EDGE_ROW_96_Right_96 vssd1 vssd1 vccd1 vccd1 sky130_fd_sc_hd__decap_3
XANTENNA__14092__Q cell3.SB0.route_sel\[100\] vssd1 vssd1 vccd1 vccd1 sky130_fd_sc_hd__diode_2
X_07013_ _01621_ _01622_ net113 cell2.SB0.route_sel\[69\] cell2.SB0.route_sel\[68\]
+ vssd1 vssd1 vccd1 vccd1 _02078_ sky130_fd_sc_hd__o2111a_1
XFILLER_108_27 vssd1 vssd1 vccd1 vccd1 sky130_fd_sc_hd__fill_1
XANTENNA__08387__A1 bus1_0\[9\] vssd1 vssd1 vccd1 vccd1 sky130_fd_sc_hd__diode_2
XANTENNA__08926__A3 bus3_1\[11\] vssd1 vssd1 vccd1 vccd1 sky130_fd_sc_hd__diode_2
X_08964_ _03826_ _03972_ _03973_ _03830_ _01683_ vssd1 vssd1 vccd1 vccd1 _03996_ sky130_fd_sc_hd__a221o_1
XPHY_EDGE_ROW_87_Left_230 vssd1 vssd1 vccd1 vccd1 sky130_fd_sc_hd__decap_3
X_07915_ cell0.CB_0.config_dataA\[13\] cell0.CB_0.config_dataA\[12\] vssd1 vssd1 vccd1
+ vccd1 _02959_ sky130_fd_sc_hd__or2_1
XANTENNA__12978__S net755 vssd1 vssd1 vccd1 vccd1 sky130_fd_sc_hd__diode_2
XANTENNA__11143__A0 net47 vssd1 vssd1 vccd1 vccd1 sky130_fd_sc_hd__diode_2
XFILLER_68_161 vssd1 vssd1 vccd1 vccd1 sky130_fd_sc_hd__fill_1
X_08895_ _01678_ _03922_ _03923_ _03926_ vssd1 vssd1 vccd1 vccd1 _03927_ sky130_fd_sc_hd__o2bb2a_1
XANTENNA__09860__B net303 vssd1 vssd1 vccd1 vccd1 sky130_fd_sc_hd__diode_2
XFILLER_110_291 vssd1 vssd1 vccd1 vccd1 sky130_fd_sc_hd__fill_1
X_07846_ _02842_ _02889_ vssd1 vssd1 vccd1 vccd1 _02890_ sky130_fd_sc_hd__nor2_4
XFILLER_29_559 vssd1 vssd1 vccd1 vccd1 sky130_fd_sc_hd__fill_1
XANTENNA_fanout642_A net649 vssd1 vssd1 vccd1 vccd1 sky130_fd_sc_hd__diode_2
XTAP_TAPCELL_ROW_67_1319 vssd1 vccd1 sky130_fd_sc_hd__tapvpwrvgnd_1
XTAP_TAPCELL_ROW_67_1308 vssd1 vccd1 sky130_fd_sc_hd__tapvpwrvgnd_1
XTAP_TAPCELL_ROW_27_716 vssd1 vccd1 sky130_fd_sc_hd__tapvpwrvgnd_1
X_07777_ _02820_ _02822_ vssd1 vssd1 vccd1 vccd1 bus1_0\[4\] sky130_fd_sc_hd__nor2_4
X_06728_ cell3.LEI0.config_data\[17\] vssd1 vssd1 vccd1 vccd1 _01798_ sky130_fd_sc_hd__inv_2
X_09516_ net17 _04535_ vssd1 vssd1 vccd1 vccd1 _04536_ sky130_fd_sc_hd__or2_1
XFILLER_17_57 vccd1 vssd1 vccd1 vssd1 sky130_ef_sc_hd__decap_40_12
XFILLER_24_220 vssd1 vssd1 vccd1 vccd1 sky130_fd_sc_hd__fill_1
XANTENNA__07380__B _02435_ vssd1 vssd1 vccd1 vccd1 sky130_fd_sc_hd__diode_2
XTAP_TAPCELL_ROW_80_1508 vssd1 vccd1 sky130_fd_sc_hd__tapvpwrvgnd_1
X_09447_ _01893_ _04466_ _04468_ vssd1 vssd1 vccd1 vccd1 _04469_ sky130_fd_sc_hd__a21bo_1
XFILLER_24_231 vssd1 vssd1 vccd1 vccd1 sky130_fd_sc_hd__fill_1
XANTENNA_fanout907_A net908 vssd1 vssd1 vccd1 vccd1 sky130_fd_sc_hd__diode_2
X_06659_ cell3.SB0.route_sel\[83\] vssd1 vssd1 vccd1 vccd1 _01729_ sky130_fd_sc_hd__inv_2
X_09378_ _04380_ _04400_ _04401_ vssd1 vssd1 vccd1 vccd1 _04402_ sky130_fd_sc_hd__a21o_1
XFILLER_40_757 vssd1 vssd1 vccd1 vccd1 sky130_fd_sc_hd__fill_1
XANTENNA__06873__A1 net94 vssd1 vssd1 vccd1 vccd1 sky130_fd_sc_hd__diode_2
XFILLER_138_645 vssd1 vssd1 vccd1 vccd1 sky130_fd_sc_hd__fill_1
XANTENNA__11749__A2 net548 vssd1 vssd1 vccd1 vccd1 sky130_fd_sc_hd__diode_2
XANTENNA__08614__A2 net336 vssd1 vssd1 vccd1 vccd1 sky130_fd_sc_hd__diode_2
X_08329_ net510 net508 _02350_ vssd1 vssd1 vccd1 vccd1 _03367_ sky130_fd_sc_hd__or3_1
XFILLER_33_89 vssd1 vssd1 vccd1 vccd1 sky130_fd_sc_hd__fill_2
X_11340_ net281 _04487_ _04488_ _06235_ vssd1 vssd1 vccd1 vccd1 net180 sky130_fd_sc_hd__a22o_1
XTAP_TAPCELL_ROW_95_1740 vssd1 vccd1 sky130_fd_sc_hd__tapvpwrvgnd_1
XANTENNA_fanout897_X net897 vssd1 vssd1 vccd1 vccd1 sky130_fd_sc_hd__diode_2
XFILLER_4_625 vccd1 vssd1 vccd1 vssd1 sky130_ef_sc_hd__decap_40_12
X_13010_ cell3.LEI0.config_data\[31\] cell3.LEI0.config_data\[30\] net957 vssd1 vssd1
+ vccd1 vccd1 _01438_ sky130_fd_sc_hd__mux2_1
X_11271_ _02179_ _05093_ vssd1 vssd1 vccd1 vccd1 _06204_ sky130_fd_sc_hd__or2_1
XFILLER_106_531 vssd1 vssd1 vccd1 vccd1 sky130_fd_sc_hd__fill_1
XANTENNA__09575__A0 net19 vssd1 vssd1 vccd1 vccd1 sky130_fd_sc_hd__diode_2
XFILLER_3_113 vccd1 vssd1 vccd1 vssd1 sky130_ef_sc_hd__decap_40_12
X_10222_ net414 _05221_ _05222_ vssd1 vssd1 vccd1 vccd1 _05223_ sky130_fd_sc_hd__a21oi_1
XFILLER_4_669 vccd1 vssd1 vccd1 vssd1 sky130_ef_sc_hd__decap_40_12
XFILLER_121_512 vssd1 vssd1 vccd1 vccd1 sky130_fd_sc_hd__fill_1
X_10153_ cell2.SB0.route_sel\[5\] cell2.SB0.route_sel\[4\] vssd1 vssd1 vccd1 vccd1
+ _05154_ sky130_fd_sc_hd__nand2b_1
XFILLER_58_31 vssd1 vssd1 vccd1 vccd1 sky130_fd_sc_hd__fill_1
XANTENNA__07050__A1 net357 vssd1 vssd1 vccd1 vccd1 sky130_fd_sc_hd__diode_2
XFILLER_94_418 vssd1 vssd1 vccd1 vccd1 sky130_fd_sc_hd__fill_2
XFILLER_94_407 vssd1 vssd1 vccd1 vccd1 sky130_fd_sc_hd__fill_1
XANTENNA_input36_A CBnorth_in[12] vssd1 vssd1 vccd1 vccd1 sky130_fd_sc_hd__diode_2
Xhold8 cell2.LE_0B.dff0_out vssd1 vssd1 vccd1 vccd1 net967 sky130_fd_sc_hd__dlygate4sd3_1
X_10084_ net419 _05084_ vssd1 vssd1 vccd1 vccd1 _05085_ sky130_fd_sc_hd__nand2_1
XFILLER_94_429 vssd1 vssd1 vccd1 vccd1 sky130_fd_sc_hd__fill_2
XFILLER_48_813 vssd1 vssd1 vccd1 vccd1 sky130_fd_sc_hd__fill_1
XANTENNA_input130_X net130 vssd1 vssd1 vccd1 vccd1 sky130_fd_sc_hd__diode_2
X_13912_ clknet_leaf_35_clk _00884_ net637 vssd1 vssd1 vccd1 vccd1 cell2.LE_0B.config_data\[13\]
+ sky130_fd_sc_hd__dfrtp_1
XFILLER_114_81 vssd1 vssd1 vccd1 vccd1 sky130_fd_sc_hd__fill_1
X_13843_ clknet_leaf_115_clk _00815_ net665 vssd1 vssd1 vccd1 vccd1 cell1.SB0.route_sel\[120\]
+ sky130_fd_sc_hd__dfstp_2
XTAP_TAPCELL_ROW_122_2136 vssd1 vccd1 sky130_fd_sc_hd__tapvpwrvgnd_1
Xclkbuf_0_cell2.LE_1B.sel_clk cell2.LE_1B.sel_clk vssd1 vssd1 vccd1 vccd1 clknet_0_cell2.LE_1B.sel_clk
+ sky130_fd_sc_hd__clkbuf_16
X_10986_ _01809_ _05938_ _05939_ vssd1 vssd1 vccd1 vccd1 _05940_ sky130_fd_sc_hd__a21oi_1
X_13774_ clknet_leaf_107_clk _00746_ net652 vssd1 vssd1 vccd1 vccd1 cell1.SB0.route_sel\[51\]
+ sky130_fd_sc_hd__dfstp_1
X_12725_ cell3.CB_0.config_dataB\[17\] net382 net931 vssd1 vssd1 vccd1 vccd1 _01154_
+ sky130_fd_sc_hd__mux2_1
XFILLER_31_724 vssd1 vssd1 vccd1 vccd1 sky130_fd_sc_hd__fill_1
X_12656_ cell3.SB0.route_sel\[121\] cell3.SB0.route_sel\[120\] net914 vssd1 vssd1
+ vccd1 vccd1 _01085_ sky130_fd_sc_hd__mux2_1
XFILLER_70_392 vssd1 vssd1 vccd1 vccd1 sky130_fd_sc_hd__fill_2
X_12587_ cell3.SB0.route_sel\[52\] cell3.SB0.route_sel\[51\] net915 vssd1 vssd1 vccd1
+ vccd1 _01016_ sky130_fd_sc_hd__mux2_1
X_11607_ cell0.CB_0.config_dataB\[3\] cell0.CB_0.config_dataB\[2\] net779 vssd1 vssd1
+ vccd1 vccd1 _00048_ sky130_fd_sc_hd__mux2_1
X_14326_ clknet_leaf_24_clk _01298_ net605 vssd1 vssd1 vccd1 vccd1 cell2.SB0.route_sel\[111\]
+ sky130_fd_sc_hd__dfstp_1
XANTENNA__08605__A2 _03489_ vssd1 vssd1 vccd1 vccd1 sky130_fd_sc_hd__diode_2
XTAP_TAPCELL_ROW_13_498 vssd1 vccd1 sky130_fd_sc_hd__tapvpwrvgnd_1
Xhold408 cell2.LE_0B.config_data\[7\] vssd1 vssd1 vccd1 vccd1 net1367 sky130_fd_sc_hd__dlygate4sd3_1
X_11538_ cell0.SB0.route_sel\[1\] cell0.SB0.route_sel\[0\] vssd1 vssd1 vccd1 vccd1
+ _06359_ sky130_fd_sc_hd__nor2_1
Xhold419 _01345_ vssd1 vssd1 vccd1 vccd1 net1378 sky130_fd_sc_hd__dlygate4sd3_1
X_14257_ clknet_leaf_26_clk _01229_ net616 vssd1 vssd1 vccd1 vccd1 cell2.SB0.route_sel\[42\]
+ sky130_fd_sc_hd__dfstp_1
X_11469_ cell1.SB0.route_sel\[81\] cell1.SB0.route_sel\[80\] vssd1 vssd1 vccd1 vccd1
+ _06313_ sky130_fd_sc_hd__nand2b_1
XTAP_TAPCELL_ROW_133_2298 vssd1 vccd1 sky130_fd_sc_hd__tapvpwrvgnd_1
X_14188_ clknet_leaf_59_clk _01160_ net723 vssd1 vssd1 vccd1 vccd1 cell3.CB_0.config_dataB\[23\]
+ sky130_fd_sc_hd__dfstp_1
XANTENNA__10176__A1 net60 vssd1 vssd1 vccd1 vccd1 sky130_fd_sc_hd__diode_2
X_13208_ clknet_leaf_22_clk _00180_ net604 vssd1 vssd1 vccd1 vccd1 cell0.LE_0A.config_data\[15\]
+ sky130_fd_sc_hd__dfrtp_1
XANTENNA__10176__B2 net59 vssd1 vssd1 vccd1 vccd1 sky130_fd_sc_hd__diode_2
X_13139_ clknet_leaf_129_clk _00111_ net579 vssd1 vssd1 vccd1 vccd1 cell0.CB_1.config_dataB\[16\]
+ sky130_fd_sc_hd__dfstp_1
XFILLER_31_3 vccd1 vssd1 vccd1 vssd1 sky130_ef_sc_hd__decap_40_12
XFILLER_112_578 vssd1 vssd1 vccd1 vccd1 sky130_fd_sc_hd__fill_8
XFILLER_97_267 vssd1 vssd1 vccd1 vccd1 sky130_fd_sc_hd__fill_2
XANTENNA__11125__A0 _05847_ vssd1 vssd1 vccd1 vccd1 sky130_fd_sc_hd__diode_2
X_07700_ _02741_ _02742_ _02746_ _02745_ vssd1 vssd1 vccd1 vccd1 _02747_ sky130_fd_sc_hd__a31o_1
XFILLER_66_643 vssd1 vssd1 vccd1 vccd1 sky130_fd_sc_hd__fill_1
X_08680_ _03473_ _03703_ _03705_ _03477_ cell1.CB_1.config_dataB\[2\] vssd1 vssd1
+ vccd1 vccd1 _03714_ sky130_fd_sc_hd__a221o_1
XTAP_TAPCELL_ROW_107_1909 vssd1 vccd1 sky130_fd_sc_hd__tapvpwrvgnd_1
X_07631_ cell1.SB0.route_sel\[13\] cell1.SB0.route_sel\[12\] vssd1 vssd1 vccd1 vccd1
+ _02680_ sky130_fd_sc_hd__nand2_1
XTAP_TAPCELL_ROW_49_1049 vssd1 vccd1 sky130_fd_sc_hd__tapvpwrvgnd_1
XTAP_TAPCELL_ROW_49_1038 vssd1 vccd1 sky130_fd_sc_hd__tapvpwrvgnd_1
X_07562_ _02011_ _02606_ net348 vssd1 vssd1 vccd1 vccd1 _02612_ sky130_fd_sc_hd__and3b_1
X_06513_ cell2.SB0.route_sel\[12\] vssd1 vssd1 vccd1 vccd1 _01583_ sky130_fd_sc_hd__inv_2
X_09301_ _02774_ _04324_ _04325_ vssd1 vssd1 vccd1 vccd1 _04326_ sky130_fd_sc_hd__o21ai_1
XFILLER_0_93 vssd1 vssd1 vccd1 vccd1 sky130_fd_sc_hd__fill_1
X_07493_ cell0.SB0.route_sel\[123\] cell0.SB0.route_sel\[122\] vssd1 vssd1 vccd1 vccd1
+ _02545_ sky130_fd_sc_hd__nand2_1
X_09232_ _01579_ cell2.SB0.route_sel\[9\] _01582_ cell2.SB0.route_sel\[14\] _04258_
+ vssd1 vssd1 vccd1 vccd1 _04259_ sky130_fd_sc_hd__a221o_1
XTAP_TAPCELL_ROW_62_1238 vssd1 vccd1 sky130_fd_sc_hd__tapvpwrvgnd_1
X_06444_ cell1.SB0.route_sel\[38\] vssd1 vssd1 vccd1 vccd1 _01514_ sky130_fd_sc_hd__inv_2
X_09163_ net306 net33 _04188_ vssd1 vssd1 vccd1 vccd1 _04191_ sky130_fd_sc_hd__mux2_1
XANTENNA__08057__A0 bus2_0\[8\] vssd1 vssd1 vccd1 vccd1 sky130_fd_sc_hd__diode_2
XANTENNA__11450__B _02780_ vssd1 vssd1 vccd1 vccd1 sky130_fd_sc_hd__diode_2
XTAP_TAPCELL_ROW_32_785 vssd1 vccd1 sky130_fd_sc_hd__tapvpwrvgnd_1
XFILLER_119_15 vccd1 vssd1 vccd1 vssd1 sky130_ef_sc_hd__decap_40_12
X_08114_ cell0.LE_0B.config_data\[13\] cell0.LE_0B.config_data\[12\] _03087_ vssd1
+ vssd1 vccd1 vccd1 _03156_ sky130_fd_sc_hd__mux2_1
XFILLER_135_615 vssd1 vssd1 vccd1 vccd1 sky130_fd_sc_hd__fill_1
XFILLER_107_317 vssd1 vssd1 vccd1 vccd1 sky130_fd_sc_hd__fill_1
X_09094_ cell1.LE_0B.config_data\[5\] cell1.LE_0B.config_data\[4\] _04086_ vssd1 vssd1
+ vccd1 vccd1 _04124_ sky130_fd_sc_hd__mux2_1
XANTENNA__08072__A3 bus2_0\[3\] vssd1 vssd1 vccd1 vccd1 sky130_fd_sc_hd__diode_2
XANTENNA__10954__A3 net43 vssd1 vssd1 vccd1 vccd1 sky130_fd_sc_hd__diode_2
XFILLER_102_9 vccd1 vssd1 vccd1 vssd1 sky130_ef_sc_hd__decap_40_12
X_08045_ _03084_ _03086_ vssd1 vssd1 vccd1 vccd1 _03087_ sky130_fd_sc_hd__nor2_4
XFILLER_89_724 vssd1 vssd1 vccd1 vccd1 sky130_fd_sc_hd__fill_1
XTAP_TAPCELL_ROW_77_1470 vssd1 vccd1 sky130_fd_sc_hd__tapvpwrvgnd_1
XFILLER_1_617 vccd1 vssd1 vccd1 vssd1 sky130_ef_sc_hd__decap_40_12
XFILLER_131_843 vssd1 vssd1 vccd1 vccd1 sky130_fd_sc_hd__fill_1
XANTENNA_fanout592_A net601 vssd1 vssd1 vccd1 vccd1 sky130_fd_sc_hd__diode_2
XFILLER_135_69 vccd1 vssd1 vccd1 vssd1 sky130_ef_sc_hd__decap_40_12
X_09996_ _04671_ _04996_ _04999_ _04995_ vssd1 vssd1 vccd1 vccd1 _05000_ sky130_fd_sc_hd__a211o_1
XFILLER_0_138 vssd1 vssd1 vccd1 vccd1 sky130_fd_sc_hd__fill_2
X_08947_ net464 _03862_ vssd1 vssd1 vccd1 vccd1 _03979_ sky130_fd_sc_hd__nand2_1
XANTENNA_clkbuf_leaf_84_clk_A clknet_4_9_0_clk vssd1 vssd1 vccd1 vccd1 sky130_fd_sc_hd__diode_2
X_08878_ bus3_1\[12\] bus3_1\[13\] bus3_1\[14\] bus3_1\[15\] net474 net472 vssd1 vssd1
+ vccd1 vccd1 _03910_ sky130_fd_sc_hd__mux4_1
XANTENNA__11131__A3 net57 vssd1 vssd1 vccd1 vccd1 sky130_fd_sc_hd__diode_2
X_07829_ net519 _02526_ _02872_ net517 vssd1 vssd1 vccd1 vccd1 _02873_ sky130_fd_sc_hd__o211a_1
XANTENNA__08532__A1 net5 vssd1 vssd1 vccd1 vccd1 sky130_fd_sc_hd__diode_2
X_10840_ net365 net364 vssd1 vssd1 vccd1 vccd1 _05796_ sky130_fd_sc_hd__nor2_1
X_10771_ _01780_ net368 vssd1 vssd1 vccd1 vccd1 _05727_ sky130_fd_sc_hd__or2_1
XANTENNA_clkbuf_leaf_99_clk_A clknet_4_10_0_clk vssd1 vssd1 vccd1 vccd1 sky130_fd_sc_hd__diode_2
XFILLER_13_735 vssd1 vssd1 vccd1 vccd1 sky130_fd_sc_hd__fill_1
XANTENNA__08493__Y _03529_ vssd1 vssd1 vccd1 vccd1 sky130_fd_sc_hd__diode_2
X_12510_ cell2.LEI0.config_data\[24\] net1341 net850 vssd1 vssd1 vccd1 vccd1 _00939_
+ sky130_fd_sc_hd__mux2_1
X_13490_ clknet_leaf_93_clk _00462_ net693 vssd1 vssd1 vccd1 vccd1 cell1.CB_1.config_dataB\[3\]
+ sky130_fd_sc_hd__dfstp_1
X_12441_ net1105 cell2.LE_0B.config_data\[0\] net843 vssd1 vssd1 vccd1 vccd1 _00872_
+ sky130_fd_sc_hd__mux2_1
XANTENNA_clkbuf_leaf_22_clk_A clknet_4_4_0_clk vssd1 vssd1 vccd1 vccd1 sky130_fd_sc_hd__diode_2
XFILLER_40_598 vssd1 vssd1 vccd1 vccd1 sky130_fd_sc_hd__fill_1
X_12372_ cell1.SB0.route_sel\[110\] cell1.SB0.route_sel\[109\] net860 vssd1 vssd1
+ vccd1 vccd1 _00805_ sky130_fd_sc_hd__mux2_1
XTAP_TAPCELL_ROW_10_457 vssd1 vccd1 sky130_fd_sc_hd__tapvpwrvgnd_1
X_14111_ clknet_leaf_78_clk _01083_ net711 vssd1 vssd1 vccd1 vccd1 cell3.SB0.route_sel\[119\]
+ sky130_fd_sc_hd__dfstp_1
X_11323_ _04700_ _05519_ vssd1 vssd1 vccd1 vccd1 _06227_ sky130_fd_sc_hd__nand2b_1
XFILLER_5_27 vccd1 vssd1 vccd1 vssd1 sky130_ef_sc_hd__decap_40_12
XFILLER_4_433 vccd1 vssd1 vccd1 vssd1 sky130_ef_sc_hd__decap_40_12
XANTENNA__07271__A1 net358 vssd1 vssd1 vccd1 vccd1 sky130_fd_sc_hd__diode_2
Xclkbuf_4_0_0_clk clknet_0_clk vssd1 vssd1 vccd1 vccd1 clknet_4_0_0_clk sky130_fd_sc_hd__clkbuf_8
XANTENNA_clkbuf_leaf_37_clk_A clknet_4_7_0_clk vssd1 vssd1 vccd1 vccd1 sky130_fd_sc_hd__diode_2
X_11254_ _06194_ net310 _04253_ vssd1 vssd1 vccd1 vccd1 net177 sky130_fd_sc_hd__mux2_1
X_14042_ clknet_leaf_49_clk _01014_ net711 vssd1 vssd1 vccd1 vccd1 cell3.SB0.route_sel\[50\]
+ sky130_fd_sc_hd__dfstp_1
XANTENNA__09548__A0 net18 vssd1 vssd1 vccd1 vccd1 sky130_fd_sc_hd__diode_2
XANTENNA__09257__S _04279_ vssd1 vssd1 vccd1 vccd1 sky130_fd_sc_hd__diode_2
XANTENNA__08014__X _03056_ vssd1 vssd1 vccd1 vccd1 sky130_fd_sc_hd__diode_2
XFILLER_4_477 vccd1 vssd1 vccd1 vssd1 sky130_ef_sc_hd__decap_40_12
X_10205_ _02106_ _05096_ _05201_ _05200_ _05093_ vssd1 vssd1 vccd1 vccd1 _05206_ sky130_fd_sc_hd__a32o_1
X_11185_ net285 net280 cell3.LEI0.config_data\[27\] vssd1 vssd1 vccd1 vccd1 _06137_
+ sky130_fd_sc_hd__mux2_1
XANTENNA_input39_X net39 vssd1 vssd1 vccd1 vccd1 sky130_fd_sc_hd__diode_2
X_10136_ _01600_ cell2.SB0.route_sel\[39\] vssd1 vssd1 vccd1 vccd1 _05137_ sky130_fd_sc_hd__nand2_1
XFILLER_67_418 vssd1 vssd1 vccd1 vccd1 sky130_fd_sc_hd__fill_1
XANTENNA_output142_A net142 vssd1 vssd1 vccd1 vccd1 sky130_fd_sc_hd__diode_2
XFILLER_0_661 vssd1 vssd1 vccd1 vccd1 sky130_fd_sc_hd__fill_8
X_10067_ cell2.LE_1B.config_data\[14\] cell2.LE_1B.config_data\[15\] _04956_ vssd1
+ vssd1 vccd1 vccd1 _05071_ sky130_fd_sc_hd__mux2_1
XFILLER_47_186 vssd1 vssd1 vccd1 vccd1 sky130_fd_sc_hd__fill_1
XANTENNA_clkload1_A clknet_4_1_0_clk vssd1 vssd1 vccd1 vccd1 sky130_fd_sc_hd__diode_2
X_13826_ clknet_leaf_113_clk _00798_ net663 vssd1 vssd1 vccd1 vccd1 cell1.SB0.route_sel\[103\]
+ sky130_fd_sc_hd__dfstp_1
X_10969_ _01676_ cell3.SB0.route_sel\[7\] cell3.SB0.route_sel\[4\] _01677_ _05922_
+ vssd1 vssd1 vccd1 vccd1 _05923_ sky130_fd_sc_hd__a221o_1
XTAP_TAPCELL_ROW_18_579 vssd1 vccd1 sky130_fd_sc_hd__tapvpwrvgnd_1
X_13757_ clknet_leaf_112_clk _00729_ net656 vssd1 vssd1 vccd1 vccd1 cell1.SB0.route_sel\[34\]
+ sky130_fd_sc_hd__dfstp_2
X_12708_ net389 cell3.CB_0.config_dataA\[24\] net930 vssd1 vssd1 vccd1 vccd1 _01137_
+ sky130_fd_sc_hd__mux2_1
XTAP_TAPCELL_ROW_102_1839 vssd1 vccd1 sky130_fd_sc_hd__tapvpwrvgnd_1
XANTENNA__10633__A2 _04362_ vssd1 vssd1 vccd1 vccd1 sky130_fd_sc_hd__diode_2
X_13688_ clknet_leaf_29_clk _00660_ net619 vssd1 vssd1 vccd1 vccd1 cell2.CB_0.config_dataB\[15\]
+ sky130_fd_sc_hd__dfstp_1
XTAP_TAPCELL_ROW_135_2338 vssd1 vccd1 sky130_fd_sc_hd__tapvpwrvgnd_1
XTAP_TAPCELL_ROW_135_2327 vssd1 vccd1 sky130_fd_sc_hd__tapvpwrvgnd_1
X_12639_ cell3.SB0.route_sel\[104\] cell3.SB0.route_sel\[103\] net922 vssd1 vssd1
+ vccd1 vccd1 _01068_ sky130_fd_sc_hd__mux2_1
XFILLER_8_783 vssd1 vssd1 vccd1 vccd1 sky130_fd_sc_hd__fill_1
Xhold216 _00853_ vssd1 vssd1 vccd1 vccd1 net1175 sky130_fd_sc_hd__dlygate4sd3_1
X_14309_ clknet_leaf_16_clk _01281_ net624 vssd1 vssd1 vccd1 vccd1 cell2.SB0.route_sel\[94\]
+ sky130_fd_sc_hd__dfstp_1
XANTENNA__07747__Y _02793_ vssd1 vssd1 vccd1 vccd1 sky130_fd_sc_hd__diode_2
Xhold205 cell0.LE_1B.config_data\[10\] vssd1 vssd1 vccd1 vccd1 net1164 sky130_fd_sc_hd__dlygate4sd3_1
Xhold238 cell2.LE_1A.config_data\[0\] vssd1 vssd1 vccd1 vccd1 net1197 sky130_fd_sc_hd__dlygate4sd3_1
XANTENNA__09539__B1 net314 vssd1 vssd1 vccd1 vccd1 sky130_fd_sc_hd__diode_2
Xhold227 _00154_ vssd1 vssd1 vccd1 vccd1 net1186 sky130_fd_sc_hd__dlygate4sd3_1
Xhold249 cell0.LE_0B.config_data\[1\] vssd1 vssd1 vccd1 vccd1 net1208 sky130_fd_sc_hd__dlygate4sd3_1
Xfanout718 net719 vssd1 vssd1 vccd1 vccd1 net718 sky130_fd_sc_hd__buf_2
X_09850_ cell2.CB_1.config_dataA\[13\] cell2.CB_1.config_dataA\[12\] _04855_ vssd1
+ vssd1 vccd1 vccd1 _04856_ sky130_fd_sc_hd__o21ai_1
Xfanout707 net710 vssd1 vssd1 vccd1 vccd1 net707 sky130_fd_sc_hd__clkbuf_4
Xfanout729 net733 vssd1 vssd1 vccd1 vccd1 net729 sky130_fd_sc_hd__clkbuf_4
X_09781_ cell2.LEI0.config_data\[18\] net303 vssd1 vssd1 vccd1 vccd1 _04787_ sky130_fd_sc_hd__nand2_1
XFILLER_98_587 vssd1 vssd1 vccd1 vccd1 sky130_fd_sc_hd__fill_1
X_08801_ bus3_1\[12\] bus3_1\[13\] bus3_1\[14\] bus3_1\[15\] net471 cell1.CB_0.config_dataA\[6\]
+ vssd1 vssd1 vccd1 vccd1 _03833_ sky130_fd_sc_hd__mux4_1
X_06993_ _02057_ _02058_ vssd1 vssd1 vccd1 vccd1 _02059_ sky130_fd_sc_hd__or2_1
X_08732_ cell1.LEI0.config_data\[35\] _03765_ vssd1 vssd1 vccd1 vccd1 _03766_ sky130_fd_sc_hd__nand2b_1
XFILLER_39_632 vssd1 vssd1 vccd1 vccd1 sky130_fd_sc_hd__fill_1
X_08663_ net331 net326 cell1.LEI0.config_data\[21\] vssd1 vssd1 vccd1 vccd1 _03697_
+ sky130_fd_sc_hd__mux2_1
XFILLER_93_281 vssd1 vssd1 vccd1 vccd1 sky130_fd_sc_hd__fill_1
XANTENNA__07868__A3 bus2_0\[3\] vssd1 vssd1 vccd1 vccd1 sky130_fd_sc_hd__diode_2
XFILLER_121_27 vccd1 vssd1 vccd1 vssd1 sky130_ef_sc_hd__decap_40_12
X_07614_ _02658_ _02660_ _02662_ _02661_ vssd1 vssd1 vccd1 vccd1 _02663_ sky130_fd_sc_hd__a31o_1
X_08594_ net27 _03623_ _03624_ net28 cell1.CB_1.config_dataA\[18\] vssd1 vssd1 vccd1
+ vccd1 _03630_ sky130_fd_sc_hd__a221o_1
XTAP_TAPCELL_ROW_37_866 vssd1 vccd1 sky130_fd_sc_hd__tapvpwrvgnd_1
XPHY_EDGE_ROW_138_Right_138 vssd1 vssd1 vccd1 vccd1 sky130_fd_sc_hd__decap_3
X_07545_ cell2.SB0.route_sel\[123\] cell2.SB0.route_sel\[122\] _02595_ vssd1 vssd1
+ vccd1 vccd1 _02596_ sky130_fd_sc_hd__a21oi_1
Xclkbuf_leaf_127_clk clknet_4_2_0_clk vssd1 vssd1 vccd1 vccd1 clknet_leaf_127_clk
+ sky130_fd_sc_hd__clkbuf_8
XANTENNA_clkbuf_4_5_0_clk_X clknet_4_5_0_clk vssd1 vssd1 vccd1 vccd1 sky130_fd_sc_hd__diode_2
X_07476_ _02484_ _02527_ _02528_ _02485_ vssd1 vssd1 vccd1 vccd1 _02529_ sky130_fd_sc_hd__o211ai_2
X_09215_ net301 _02164_ _04176_ _04241_ vssd1 vssd1 vccd1 vccd1 _04242_ sky130_fd_sc_hd__o31a_1
XFILLER_10_727 vssd1 vssd1 vccd1 vccd1 sky130_fd_sc_hd__fill_1
X_06427_ cell1.SB0.route_sel\[4\] vssd1 vssd1 vccd1 vccd1 _01497_ sky130_fd_sc_hd__inv_2
XANTENNA__08293__A3 bus1_0\[3\] vssd1 vssd1 vccd1 vccd1 sky130_fd_sc_hd__diode_2
XFILLER_22_587 vssd1 vssd1 vccd1 vccd1 sky130_fd_sc_hd__fill_1
XFILLER_22_598 vssd1 vssd1 vccd1 vccd1 sky130_fd_sc_hd__fill_8
XANTENNA__10388__A1 net319 vssd1 vssd1 vccd1 vccd1 sky130_fd_sc_hd__diode_2
X_09146_ _02087_ _04173_ vssd1 vssd1 vccd1 vccd1 _04174_ sky130_fd_sc_hd__or2_2
XANTENNA__07253__A1 net301 vssd1 vssd1 vccd1 vccd1 sky130_fd_sc_hd__diode_2
X_09077_ cell1.CB_0.config_dataB\[13\] cell1.CB_0.config_dataB\[12\] vssd1 vssd1 vccd1
+ vccd1 _04107_ sky130_fd_sc_hd__nor2_1
XPHY_EDGE_ROW_15_Left_158 vssd1 vssd1 vccd1 vccd1 sky130_fd_sc_hd__decap_3
XTAP_TAPCELL_ROW_75_1429 vssd1 vccd1 sky130_fd_sc_hd__tapvpwrvgnd_1
X_08028_ _03066_ _03069_ cell0.CB_0.config_dataB\[3\] vssd1 vssd1 vccd1 vccd1 _03070_
+ sky130_fd_sc_hd__or3b_1
XFILLER_30_57 vssd1 vssd1 vccd1 vccd1 sky130_fd_sc_hd__fill_1
XANTENNA__10083__Y _05084_ vssd1 vssd1 vccd1 vccd1 sky130_fd_sc_hd__diode_2
XANTENNA__08202__A0 bus1_0\[8\] vssd1 vssd1 vccd1 vccd1 sky130_fd_sc_hd__diode_2
XFILLER_1_447 vssd1 vssd1 vccd1 vccd1 sky130_fd_sc_hd__fill_1
X_09979_ _04527_ _04957_ vssd1 vssd1 vccd1 vccd1 _04983_ sky130_fd_sc_hd__and2b_1
XFILLER_39_55 vssd1 vssd1 vccd1 vccd1 sky130_fd_sc_hd__fill_1
XANTENNA__07392__Y _02447_ vssd1 vssd1 vccd1 vccd1 sky130_fd_sc_hd__diode_2
X_12990_ cell3.LEI0.config_data\[11\] net1397 net947 vssd1 vssd1 vccd1 vccd1 _01418_
+ sky130_fd_sc_hd__mux2_1
XANTENNA__11355__B _05847_ vssd1 vssd1 vccd1 vccd1 sky130_fd_sc_hd__diode_2
XFILLER_84_281 vccd1 vssd1 vccd1 vssd1 sky130_ef_sc_hd__decap_40_12
XFILLER_57_484 vssd1 vssd1 vccd1 vccd1 sky130_fd_sc_hd__fill_1
XFILLER_17_337 vssd1 vssd1 vccd1 vccd1 sky130_fd_sc_hd__fill_4
X_11941_ cell0.SB0.route_sel\[47\] cell0.SB0.route_sel\[46\] net759 vssd1 vssd1 vccd1
+ vccd1 _00378_ sky130_fd_sc_hd__mux2_1
XPHY_EDGE_ROW_24_Left_167 vssd1 vssd1 vccd1 vccd1 sky130_fd_sc_hd__decap_3
X_11872_ cell1.CB_0.config_dataA\[3\] cell1.CB_0.config_dataA\[2\] net883 vssd1 vssd1
+ vccd1 vccd1 _00309_ sky130_fd_sc_hd__mux2_1
XPHY_EDGE_ROW_105_Right_105 vssd1 vssd1 vccd1 vccd1 sky130_fd_sc_hd__decap_3
X_10823_ net366 _05777_ _05778_ vssd1 vssd1 vccd1 vccd1 _05779_ sky130_fd_sc_hd__a21oi_1
Xclkbuf_leaf_118_clk clknet_4_3_0_clk vssd1 vssd1 vccd1 vccd1 clknet_leaf_118_clk
+ sky130_fd_sc_hd__clkbuf_8
X_13611_ clknet_leaf_94_clk net1075 net695 vssd1 vssd1 vccd1 vccd1 cell1.LEI0.config_data\[32\]
+ sky130_fd_sc_hd__dfrtp_1
XANTENNA__10615__A2 net24 vssd1 vssd1 vccd1 vccd1 sky130_fd_sc_hd__diode_2
X_13542_ clknet_leaf_72_clk net1033 net728 vssd1 vssd1 vccd1 vccd1 cell1.LE_0B.config_data\[7\]
+ sky130_fd_sc_hd__dfrtp_1
XFILLER_41_841 vssd1 vssd1 vccd1 vccd1 sky130_fd_sc_hd__fill_1
XTAP_TAPCELL_ROW_15_527 vssd1 vccd1 sky130_fd_sc_hd__tapvpwrvgnd_1
XTAP_TAPCELL_ROW_15_538 vssd1 vccd1 sky130_fd_sc_hd__tapvpwrvgnd_1
XANTENNA__08664__B net323 vssd1 vssd1 vccd1 vccd1 sky130_fd_sc_hd__diode_2
X_10754_ net370 _05708_ _05709_ vssd1 vssd1 vccd1 vccd1 _05710_ sky130_fd_sc_hd__a21oi_1
XFILLER_139_751 vccd1 vssd1 vccd1 vssd1 sky130_ef_sc_hd__decap_40_12
X_10685_ net390 net391 vssd1 vssd1 vccd1 vccd1 _05643_ sky130_fd_sc_hd__or2_1
XFILLER_71_97 vssd1 vssd1 vccd1 vccd1 sky130_fd_sc_hd__fill_1
XFILLER_71_75 vssd1 vssd1 vccd1 vccd1 sky130_fd_sc_hd__fill_1
X_13473_ clknet_leaf_1_clk _00445_ net561 vssd1 vssd1 vccd1 vccd1 cell0.SB0.route_sel\[114\]
+ sky130_fd_sc_hd__dfstp_1
XTAP_TAPCELL_ROW_117_2057 vssd1 vccd1 sky130_fd_sc_hd__tapvpwrvgnd_1
X_12424_ net1046 cell2.LE_1A.config_data\[6\] net925 vssd1 vssd1 vccd1 vccd1 _00856_
+ sky130_fd_sc_hd__mux2_1
XPHY_EDGE_ROW_33_Left_176 vssd1 vssd1 vccd1 vccd1 sky130_fd_sc_hd__decap_3
XTAP_TAPCELL_ROW_117_2068 vssd1 vccd1 sky130_fd_sc_hd__tapvpwrvgnd_1
XANTENNA__07244__A1 cell2.SB0.route_sel\[92\] vssd1 vssd1 vccd1 vccd1 sky130_fd_sc_hd__diode_2
X_12355_ cell1.SB0.route_sel\[93\] cell1.SB0.route_sel\[92\] net868 vssd1 vssd1 vccd1
+ vccd1 _00788_ sky130_fd_sc_hd__mux2_1
X_11306_ _04480_ _06217_ _04478_ vssd1 vssd1 vccd1 vccd1 _06218_ sky130_fd_sc_hd__o21ba_1
XANTENNA__08992__A1 bus3_1\[1\] vssd1 vssd1 vccd1 vccd1 sky130_fd_sc_hd__diode_2
XFILLER_5_753 vccd1 vssd1 vccd1 vssd1 sky130_ef_sc_hd__decap_40_12
XTAP_TAPCELL_ROW_130_2257 vssd1 vccd1 sky130_fd_sc_hd__tapvpwrvgnd_1
XANTENNA__14190__Q cell3.CB_0.config_dataA\[0\] vssd1 vssd1 vccd1 vccd1 sky130_fd_sc_hd__diode_2
X_12286_ cell1.SB0.route_sel\[24\] cell1.SB0.route_sel\[23\] net864 vssd1 vssd1 vccd1
+ vccd1 _00719_ sky130_fd_sc_hd__mux2_1
X_11237_ _06188_ _06142_ vssd1 vssd1 vccd1 vccd1 _06189_ sky130_fd_sc_hd__and2b_1
X_14025_ clknet_leaf_47_clk _00997_ net702 vssd1 vssd1 vccd1 vccd1 cell3.SB0.route_sel\[33\]
+ sky130_fd_sc_hd__dfstp_1
X_11168_ _06119_ vssd1 vssd1 vccd1 vccd1 _06120_ sky130_fd_sc_hd__inv_2
XTAP_TAPCELL_ROW_112_1990 vssd1 vccd1 sky130_fd_sc_hd__tapvpwrvgnd_1
XANTENNA__09941__A0 bus3_2\[12\] vssd1 vssd1 vccd1 vccd1 sky130_fd_sc_hd__diode_2
X_10119_ _05119_ _05118_ cell2.CB_0.config_dataA\[7\] vssd1 vssd1 vccd1 vccd1 _05120_
+ sky130_fd_sc_hd__mux2_1
XFILLER_96_72 vssd1 vssd1 vccd1 vccd1 sky130_fd_sc_hd__fill_2
XFILLER_95_557 vssd1 vssd1 vccd1 vccd1 sky130_fd_sc_hd__fill_2
X_11099_ net53 net54 net56 net57 net389 net388 vssd1 vssd1 vccd1 vccd1 _06051_ sky130_fd_sc_hd__mux4_1
XPHY_EDGE_ROW_42_Left_185 vssd1 vssd1 vccd1 vccd1 sky130_fd_sc_hd__decap_3
XANTENNA__10303__B2 _05093_ vssd1 vssd1 vccd1 vccd1 sky130_fd_sc_hd__diode_2
XANTENNA__07180__B1 bus3_2\[10\] vssd1 vssd1 vccd1 vccd1 sky130_fd_sc_hd__diode_2
XFILLER_36_657 vssd1 vssd1 vccd1 vccd1 sky130_fd_sc_hd__fill_1
XFILLER_36_679 vssd1 vssd1 vccd1 vccd1 sky130_fd_sc_hd__fill_1
Xclkbuf_leaf_109_clk clknet_4_8_0_clk vssd1 vssd1 vccd1 vccd1 clknet_leaf_109_clk
+ sky130_fd_sc_hd__clkbuf_8
XFILLER_23_329 vssd1 vssd1 vccd1 vccd1 sky130_fd_sc_hd__fill_1
X_13809_ clknet_leaf_112_clk _00781_ net661 vssd1 vssd1 vccd1 vccd1 cell1.SB0.route_sel\[86\]
+ sky130_fd_sc_hd__dfstp_1
XTAP_TAPCELL_ROW_34_814 vssd1 vccd1 sky130_fd_sc_hd__tapvpwrvgnd_1
XTAP_TAPCELL_ROW_34_825 vssd1 vccd1 sky130_fd_sc_hd__tapvpwrvgnd_1
XANTENNA__10606__A2 net272 vssd1 vssd1 vccd1 vccd1 sky130_fd_sc_hd__diode_2
X_07330_ _02386_ vssd1 vssd1 vccd1 vccd1 _02387_ sky130_fd_sc_hd__inv_2
X_07261_ _02308_ _02309_ _02313_ _02319_ net551 vssd1 vssd1 vccd1 vccd1 _02320_ sky130_fd_sc_hd__o311a_2
X_09000_ cell1.CB_0.config_dataB\[8\] cell1.CB_0.config_dataB\[7\] _04029_ vssd1 vssd1
+ vccd1 vccd1 _04030_ sky130_fd_sc_hd__o21ai_1
XPHY_EDGE_ROW_51_Left_194 vssd1 vssd1 vccd1 vccd1 sky130_fd_sc_hd__decap_3
XFILLER_31_384 vssd1 vssd1 vccd1 vccd1 sky130_fd_sc_hd__fill_1
X_07192_ _02240_ _02247_ _02252_ net551 vssd1 vssd1 vccd1 vccd1 _02253_ sky130_fd_sc_hd__o211a_2
XANTENNA__07758__X _02804_ vssd1 vssd1 vccd1 vccd1 sky130_fd_sc_hd__diode_2
XTAP_TAPCELL_ROW_57_1159 vssd1 vccd1 sky130_fd_sc_hd__tapvpwrvgnd_1
XFILLER_6_81 vssd1 vssd1 vccd1 vccd1 sky130_fd_sc_hd__fill_2
XFILLER_116_27 vssd1 vssd1 vccd1 vccd1 sky130_fd_sc_hd__fill_1
XFILLER_99_841 vssd1 vssd1 vccd1 vccd1 sky130_fd_sc_hd__fill_1
X_09902_ cell2.CB_1.config_dataA\[19\] _04875_ _04893_ _04903_ _04907_ vssd1 vssd1
+ vccd1 vccd1 _04908_ sky130_fd_sc_hd__a311o_1
Xfanout515 net516 vssd1 vssd1 vccd1 vccd1 net515 sky130_fd_sc_hd__buf_2
Xfanout504 cell0.CB_1.config_dataB\[10\] vssd1 vssd1 vccd1 vccd1 net504 sky130_fd_sc_hd__buf_2
X_09833_ _04671_ _04835_ _04838_ _04834_ vssd1 vssd1 vccd1 vccd1 _04839_ sky130_fd_sc_hd__a211o_1
XANTENNA__09932__B1 _04399_ vssd1 vssd1 vccd1 vccd1 sky130_fd_sc_hd__diode_2
XANTENNA__07538__A2 _02588_ vssd1 vssd1 vccd1 vccd1 sky130_fd_sc_hd__diode_2
XFILLER_59_727 vssd1 vssd1 vccd1 vccd1 sky130_fd_sc_hd__fill_1
Xfanout548 net550 vssd1 vssd1 vccd1 vccd1 net548 sky130_fd_sc_hd__clkbuf_4
Xfanout526 cell0.CB_0.config_dataB\[11\] vssd1 vssd1 vccd1 vccd1 net526 sky130_fd_sc_hd__buf_2
Xfanout537 cell0.CB_1.config_dataA\[15\] vssd1 vssd1 vccd1 vccd1 net537 sky130_fd_sc_hd__clkbuf_2
XANTENNA_fanout290_A net291 vssd1 vssd1 vccd1 vccd1 sky130_fd_sc_hd__diode_2
XTAP_TAPCELL_ROW_70_1359 vssd1 vccd1 sky130_fd_sc_hd__tapvpwrvgnd_1
Xfanout559 net563 vssd1 vssd1 vccd1 vccd1 net559 sky130_fd_sc_hd__clkbuf_2
XANTENNA__08749__B _03509_ vssd1 vssd1 vccd1 vccd1 sky130_fd_sc_hd__diode_2
X_09764_ net444 _04348_ vssd1 vssd1 vccd1 vccd1 _04770_ sky130_fd_sc_hd__nand2_1
X_06976_ cell1.SB0.route_sel\[69\] cell1.SB0.route_sel\[68\] vssd1 vssd1 vccd1 vccd1
+ _02042_ sky130_fd_sc_hd__nand2_1
XANTENNA__11098__A2 net51 vssd1 vssd1 vccd1 vccd1 sky130_fd_sc_hd__diode_2
X_09695_ _04315_ _04656_ vssd1 vssd1 vccd1 vccd1 _04709_ sky130_fd_sc_hd__nor2_1
XFILLER_26_112 vssd1 vssd1 vccd1 vccd1 sky130_fd_sc_hd__fill_1
X_08715_ _03747_ _03748_ cell1.CB_1.config_dataB\[12\] vssd1 vssd1 vccd1 vccd1 _03749_
+ sky130_fd_sc_hd__or3b_1
XANTENNA_fanout555_A net602 vssd1 vssd1 vccd1 vccd1 sky130_fd_sc_hd__diode_2
X_08646_ net458 _03504_ vssd1 vssd1 vccd1 vccd1 _03680_ sky130_fd_sc_hd__or2_1
XANTENNA_fanout722_A net723 vssd1 vssd1 vccd1 vccd1 sky130_fd_sc_hd__diode_2
XANTENNA__11191__A net47 vssd1 vssd1 vccd1 vccd1 sky130_fd_sc_hd__diode_2
XTAP_TAPCELL_ROW_85_1580 vssd1 vccd1 sky130_fd_sc_hd__tapvpwrvgnd_1
XFILLER_25_57 vssd1 vssd1 vccd1 vccd1 sky130_fd_sc_hd__fill_8
X_08577_ _03602_ _03604_ _03612_ vssd1 vssd1 vccd1 vccd1 _03613_ sky130_fd_sc_hd__a21oi_1
X_07528_ cell1.SB0.route_sel\[121\] cell1.SB0.route_sel\[120\] vssd1 vssd1 vccd1 vccd1
+ _02580_ sky130_fd_sc_hd__nor2_1
X_07459_ _02511_ _02512_ _02509_ vssd1 vssd1 vccd1 vccd1 _02513_ sky130_fd_sc_hd__a21oi_1
X_10470_ cell3.SB0.route_sel\[112\] cell3.SB0.route_sel\[113\] cell3.SB0.route_sel\[115\]
+ _01745_ _05453_ vssd1 vssd1 vccd1 vccd1 _05454_ sky130_fd_sc_hd__o221a_1
XANTENNA__13214__RESET_B net751 vssd1 vssd1 vccd1 vccd1 sky130_fd_sc_hd__diode_2
X_09129_ _04158_ vssd1 vssd1 vccd1 vccd1 _04159_ sky130_fd_sc_hd__inv_2
XANTENNA__07226__A1 net335 vssd1 vssd1 vccd1 vccd1 sky130_fd_sc_hd__diode_2
XANTENNA__12226__S net824 vssd1 vssd1 vccd1 vccd1 sky130_fd_sc_hd__diode_2
XANTENNA__07828__B _02585_ vssd1 vssd1 vccd1 vccd1 sky130_fd_sc_hd__diode_2
X_12140_ net1521 cell1.LEI0.config_data\[21\] net899 vssd1 vssd1 vccd1 vccd1 _00573_
+ sky130_fd_sc_hd__mux2_1
XFILLER_2_701 vccd1 vssd1 vccd1 vssd1 sky130_ef_sc_hd__decap_40_12
Xhold580 cell3.LEI0.config_data\[34\] vssd1 vssd1 vccd1 vccd1 net1539 sky130_fd_sc_hd__dlygate4sd3_1
X_12071_ net969 _01820_ _06378_ vssd1 vssd1 vccd1 vccd1 _00506_ sky130_fd_sc_hd__a21o_1
XFILLER_9_3 vccd1 vssd1 vccd1 vssd1 sky130_ef_sc_hd__decap_40_12
X_11022_ _05893_ _05890_ cell3.CB_0.config_dataA\[10\] vssd1 vssd1 vccd1 vccd1 _05976_
+ sky130_fd_sc_hd__mux2_1
Xhold591 _00927_ vssd1 vssd1 vccd1 vccd1 net1550 sky130_fd_sc_hd__dlygate4sd3_1
XFILLER_89_362 vssd1 vssd1 vccd1 vccd1 sky130_fd_sc_hd__fill_1
XANTENNA_hold388_X net1347 vssd1 vssd1 vccd1 vccd1 sky130_fd_sc_hd__diode_2
XFILLER_1_277 vssd1 vssd1 vccd1 vccd1 sky130_fd_sc_hd__fill_2
XFILLER_77_535 vssd1 vssd1 vccd1 vccd1 sky130_fd_sc_hd__fill_2
XANTENNA__07934__C1 _02977_ vssd1 vssd1 vccd1 vccd1 sky130_fd_sc_hd__diode_2
XFILLER_65_719 vssd1 vssd1 vccd1 vccd1 sky130_fd_sc_hd__fill_1
XANTENNA_hold555_X net1514 vssd1 vssd1 vccd1 vccd1 sky130_fd_sc_hd__diode_2
X_12973_ cell3.LE_0A.config_data\[16\] net1320 net928 vssd1 vssd1 vccd1 vccd1 _01401_
+ sky130_fd_sc_hd__mux2_1
XANTENNA__09151__A1 bus3_2\[0\] vssd1 vssd1 vccd1 vccd1 sky130_fd_sc_hd__diode_2
X_11924_ cell0.SB0.route_sel\[30\] cell0.SB0.route_sel\[29\] net760 vssd1 vssd1 vccd1
+ vccd1 _00361_ sky130_fd_sc_hd__mux2_1
XFILLER_45_476 vssd1 vssd1 vccd1 vccd1 sky130_fd_sc_hd__fill_1
XFILLER_82_74 vssd1 vssd1 vccd1 vccd1 sky130_fd_sc_hd__fill_1
X_11855_ net478 net480 net897 vssd1 vssd1 vccd1 vccd1 _00292_ sky130_fd_sc_hd__mux2_1
X_10806_ net367 net366 vssd1 vssd1 vccd1 vccd1 _05762_ sky130_fd_sc_hd__nor2_1
X_11786_ net1455 net1445 net793 vssd1 vssd1 vccd1 vccd1 _00223_ sky130_fd_sc_hd__mux2_1
XANTENNA__11797__A0 cell0.CB_0.config_data_inA vssd1 vssd1 vccd1 vccd1 sky130_fd_sc_hd__diode_2
XANTENNA__08257__A3 cell0.CB_1.le_outB vssd1 vssd1 vccd1 vccd1 sky130_fd_sc_hd__diode_2
X_10737_ _01778_ net370 vssd1 vssd1 vccd1 vccd1 _05693_ sky130_fd_sc_hd__nor2_1
X_13525_ clknet_leaf_100_clk net1006 net679 vssd1 vssd1 vccd1 vccd1 cell1.LE_1A.config_data\[12\]
+ sky130_fd_sc_hd__dfrtp_1
XANTENNA__11513__A_N _06342_ vssd1 vssd1 vccd1 vccd1 sky130_fd_sc_hd__diode_2
X_13456_ clknet_leaf_2_clk _00428_ net569 vssd1 vssd1 vccd1 vccd1 cell0.SB0.route_sel\[97\]
+ sky130_fd_sc_hd__dfstp_2
X_10668_ net393 _05501_ _05625_ net392 vssd1 vssd1 vccd1 vccd1 _05626_ sky130_fd_sc_hd__o211a_1
X_12407_ cell2.CB_1.config_dataB\[17\] net399 net833 vssd1 vssd1 vccd1 vccd1 _00840_
+ sky130_fd_sc_hd__mux2_1
XANTENNA__08009__A3 bus2_0\[3\] vssd1 vssd1 vccd1 vccd1 sky130_fd_sc_hd__diode_2
X_10599_ _05525_ _05533_ _05556_ vssd1 vssd1 vccd1 vccd1 _05557_ sky130_fd_sc_hd__a21oi_2
XANTENNA__09757__A3 bus3_2\[11\] vssd1 vssd1 vccd1 vccd1 sky130_fd_sc_hd__diode_2
X_13387_ clknet_leaf_132_clk _00359_ net558 vssd1 vssd1 vccd1 vccd1 cell0.SB0.route_sel\[28\]
+ sky130_fd_sc_hd__dfstp_1
XANTENNA__10164__B _05128_ vssd1 vssd1 vccd1 vccd1 sky130_fd_sc_hd__diode_2
XFILLER_5_561 vccd1 vssd1 vccd1 vssd1 sky130_ef_sc_hd__decap_40_12
XANTENNA__13529__Q cell1.LE_1A.config_data\[16\] vssd1 vssd1 vccd1 vccd1 sky130_fd_sc_hd__diode_2
X_12338_ cell1.SB0.route_sel\[76\] cell1.SB0.route_sel\[75\] net865 vssd1 vssd1 vccd1
+ vccd1 _00771_ sky130_fd_sc_hd__mux2_1
XFILLER_141_223 vssd1 vssd1 vccd1 vccd1 sky130_fd_sc_hd__fill_1
XANTENNA__10732__X cell3.CB_1.le_outA vssd1 vssd1 vccd1 vccd1 sky130_fd_sc_hd__diode_2
XANTENNA__10772__B2 _05531_ vssd1 vssd1 vccd1 vccd1 sky130_fd_sc_hd__diode_2
X_12269_ cell1.SB0.route_sel\[7\] cell1.SB0.route_sel\[6\] net866 vssd1 vssd1 vccd1
+ vccd1 _00702_ sky130_fd_sc_hd__mux2_1
X_14008_ clknet_leaf_79_clk _00980_ net709 vssd1 vssd1 vccd1 vccd1 cell3.SB0.route_sel\[16\]
+ sky130_fd_sc_hd__dfstp_1
XFILLER_96_844 vssd1 vssd1 vccd1 vccd1 sky130_fd_sc_hd__fill_1
XTAP_TAPCELL_ROW_52_1089 vssd1 vccd1 sky130_fd_sc_hd__tapvpwrvgnd_1
X_06830_ _01897_ _01899_ vssd1 vssd1 vccd1 vccd1 bus1_0\[6\] sky130_fd_sc_hd__and2b_2
XANTENNA__13264__Q cell1.LE_1B.config_data\[0\] vssd1 vssd1 vccd1 vccd1 sky130_fd_sc_hd__diode_2
X_06761_ net327 vssd1 vssd1 vccd1 vccd1 _01831_ sky130_fd_sc_hd__inv_2
X_06692_ cell2.CB_0.config_dataB\[19\] vssd1 vssd1 vccd1 vccd1 _01762_ sky130_fd_sc_hd__inv_2
X_09480_ cell3.SB0.route_sel\[62\] cell3.SB0.route_sel\[63\] net314 _01997_ _04500_
+ vssd1 vssd1 vccd1 vccd1 _04501_ sky130_fd_sc_hd__a221oi_1
X_08500_ cell1.SB0.route_sel\[45\] cell1.SB0.route_sel\[44\] _01517_ cell1.SB0.route_sel\[47\]
+ _03535_ vssd1 vssd1 vccd1 vccd1 _03536_ sky130_fd_sc_hd__o221a_1
XFILLER_102_29 vssd1 vssd1 vccd1 vccd1 sky130_fd_sc_hd__fill_8
XFILLER_63_273 vssd1 vssd1 vccd1 vccd1 sky130_fd_sc_hd__fill_1
XFILLER_24_616 vssd1 vssd1 vccd1 vccd1 sky130_fd_sc_hd__fill_1
X_08431_ cell1.SB0.route_sel\[93\] cell1.SB0.route_sel\[92\] cell1.SB0.route_sel\[95\]
+ _01538_ _03466_ vssd1 vssd1 vccd1 vccd1 _03467_ sky130_fd_sc_hd__o221a_1
XANTENNA__06900__B1 _01967_ vssd1 vssd1 vccd1 vccd1 sky130_fd_sc_hd__diode_2
X_08362_ _03398_ _03399_ cell0.CB_1.config_dataB\[12\] vssd1 vssd1 vccd1 vccd1 _03400_
+ sky130_fd_sc_hd__or3b_1
XANTENNA__13855__SET_B net632 vssd1 vssd1 vccd1 vccd1 sky130_fd_sc_hd__diode_2
X_07313_ _02370_ _02369_ _02366_ net330 vssd1 vssd1 vccd1 vccd1 _02371_ sky130_fd_sc_hd__o2bb2a_1
XFILLER_20_811 vssd1 vssd1 vccd1 vccd1 sky130_fd_sc_hd__fill_1
X_08293_ bus1_0\[0\] bus1_0\[1\] bus1_0\[2\] bus1_0\[3\] net507 cell0.CB_1.config_dataB\[6\]
+ vssd1 vssd1 vccd1 vccd1 _03331_ sky130_fd_sc_hd__mux4_1
XANTENNA__07488__X bus2_0\[14\] vssd1 vssd1 vccd1 vccd1 sky130_fd_sc_hd__diode_2
X_07244_ cell2.SB0.route_sel\[92\] cell2.SB0.route_sel\[93\] _02269_ vssd1 vssd1 vccd1
+ vccd1 _02303_ sky130_fd_sc_hd__a21o_1
XFILLER_11_15 vccd1 vssd1 vccd1 vssd1 sky130_ef_sc_hd__decap_40_12
XFILLER_127_15 vccd1 vssd1 vccd1 vssd1 sky130_ef_sc_hd__decap_40_12
X_07175_ _02204_ _02208_ _02234_ _02205_ vssd1 vssd1 vccd1 vccd1 _02236_ sky130_fd_sc_hd__a31oi_1
XANTENNA__10763__A1 net279 vssd1 vssd1 vccd1 vccd1 sky130_fd_sc_hd__diode_2
Xfanout312 net313 vssd1 vssd1 vccd1 vccd1 net312 sky130_fd_sc_hd__clkbuf_2
Xfanout301 net302 vssd1 vssd1 vccd1 vccd1 net301 sky130_fd_sc_hd__clkbuf_4
Xfanout323 cell1.CB_1.le_outB vssd1 vssd1 vccd1 vccd1 net323 sky130_fd_sc_hd__buf_2
XANTENNA__08708__A1 net30 vssd1 vssd1 vccd1 vccd1 sky130_fd_sc_hd__diode_2
XANTENNA_fanout672_A net675 vssd1 vssd1 vccd1 vccd1 sky130_fd_sc_hd__diode_2
Xfanout345 net346 vssd1 vssd1 vccd1 vccd1 net345 sky130_fd_sc_hd__buf_2
XANTENNA__08184__A2 _02211_ vssd1 vssd1 vccd1 vccd1 sky130_fd_sc_hd__diode_2
Xfanout334 net335 vssd1 vssd1 vccd1 vccd1 net334 sky130_fd_sc_hd__clkbuf_2
Xfanout389 cell3.CB_0.config_dataB\[0\] vssd1 vssd1 vccd1 vccd1 net389 sky130_fd_sc_hd__buf_2
Xfanout378 cell3.CB_0.config_dataA\[1\] vssd1 vssd1 vccd1 vccd1 net378 sky130_fd_sc_hd__buf_2
X_09816_ _04445_ _04792_ _04820_ _04821_ vssd1 vssd1 vccd1 vccd1 _04822_ sky130_fd_sc_hd__a211o_1
Xfanout367 cell3.CB_1.config_dataB\[10\] vssd1 vssd1 vccd1 vccd1 net367 sky130_fd_sc_hd__buf_2
XFILLER_101_687 vssd1 vssd1 vccd1 vccd1 sky130_fd_sc_hd__fill_1
XFILLER_100_186 vssd1 vssd1 vccd1 vccd1 sky130_fd_sc_hd__fill_8
X_09747_ _01606_ cell2.SB0.route_sel\[41\] cell2.SB0.route_sel\[46\] cell2.SB0.route_sel\[47\]
+ _04753_ vssd1 vssd1 vccd1 vccd1 _04754_ sky130_fd_sc_hd__o221a_1
XTAP_TAPCELL_ROW_87_1620 vssd1 vccd1 sky130_fd_sc_hd__tapvpwrvgnd_1
X_06959_ _02023_ _02024_ _02020_ _02021_ vssd1 vssd1 vccd1 vccd1 _02025_ sky130_fd_sc_hd__a2bb2o_1
XANTENNA_fanout937_A net944 vssd1 vssd1 vccd1 vccd1 sky130_fd_sc_hd__diode_2
XFILLER_39_292 vssd1 vssd1 vccd1 vccd1 sky130_fd_sc_hd__fill_2
X_09678_ cell3.SB0.route_sel\[117\] cell3.SB0.route_sel\[116\] vssd1 vssd1 vccd1 vccd1
+ _04692_ sky130_fd_sc_hd__nand2_1
XANTENNA__10294__A3 net58 vssd1 vssd1 vccd1 vccd1 sky130_fd_sc_hd__diode_2
XANTENNA__08892__A0 bus3_1\[6\] vssd1 vssd1 vccd1 vccd1 sky130_fd_sc_hd__diode_2
X_08629_ _03619_ _03664_ vssd1 vssd1 vccd1 vccd1 _03665_ sky130_fd_sc_hd__nor2_1
X_11640_ net514 net516 net771 vssd1 vssd1 vccd1 vccd1 _00081_ sky130_fd_sc_hd__mux2_1
XANTENNA__08239__A3 bus1_0\[11\] vssd1 vssd1 vccd1 vccd1 sky130_fd_sc_hd__diode_2
XANTENNA__10249__B _05103_ vssd1 vssd1 vccd1 vccd1 sky130_fd_sc_hd__diode_2
X_11571_ cell0.LE_1B.config_data\[12\] net1143 net799 vssd1 vssd1 vccd1 vccd1 _00012_
+ sky130_fd_sc_hd__mux2_1
XTAP_TAPCELL_ROW_25_677 vssd1 vccd1 sky130_fd_sc_hd__tapvpwrvgnd_1
XTAP_TAPCELL_ROW_25_688 vssd1 vccd1 sky130_fd_sc_hd__tapvpwrvgnd_1
X_10522_ net394 _05479_ vssd1 vssd1 vccd1 vccd1 _05480_ sky130_fd_sc_hd__nand2_1
X_13310_ clknet_leaf_79_clk _00282_ net708 vssd1 vssd1 vccd1 vccd1 cell1.CB_0.config_dataB\[1\]
+ sky130_fd_sc_hd__dfstp_1
X_14290_ clknet_leaf_8_clk _01262_ net572 vssd1 vssd1 vccd1 vccd1 cell2.SB0.route_sel\[75\]
+ sky130_fd_sc_hd__dfstp_1
XTAP_TAPCELL_ROW_114_2016 vssd1 vccd1 sky130_fd_sc_hd__tapvpwrvgnd_1
XTAP_TAPCELL_ROW_98_1782 vssd1 vccd1 sky130_fd_sc_hd__tapvpwrvgnd_1
XTAP_TAPCELL_ROW_98_1771 vssd1 vccd1 sky130_fd_sc_hd__tapvpwrvgnd_1
X_10453_ net274 _05442_ vssd1 vssd1 vccd1 vccd1 bus3_2\[8\] sky130_fd_sc_hd__and2_2
X_13241_ clknet_leaf_11_clk _00213_ net586 vssd1 vssd1 vccd1 vccd1 cell0.LEI0.config_data\[26\]
+ sky130_fd_sc_hd__dfrtp_1
XFILLER_6_336 vssd1 vssd1 vccd1 vccd1 sky130_fd_sc_hd__fill_1
XFILLER_10_387 vssd1 vssd1 vccd1 vccd1 sky130_fd_sc_hd__fill_1
X_10384_ net425 _05103_ vssd1 vssd1 vccd1 vccd1 _05383_ sky130_fd_sc_hd__nand2_1
XFILLER_109_798 vssd1 vssd1 vccd1 vccd1 sky130_fd_sc_hd__fill_1
XPHY_EDGE_ROW_107_Left_250 vssd1 vssd1 vccd1 vccd1 sky130_fd_sc_hd__decap_3
X_13172_ clknet_leaf_13_clk net1209 net597 vssd1 vssd1 vccd1 vccd1 cell0.LE_0B.config_data\[1\]
+ sky130_fd_sc_hd__dfrtp_1
XANTENNA_input66_A SBsouth_in[10] vssd1 vssd1 vccd1 vccd1 sky130_fd_sc_hd__diode_2
X_12123_ net1129 cell1.LEI0.config_data\[4\] net896 vssd1 vssd1 vccd1 vccd1 _00556_
+ sky130_fd_sc_hd__mux2_1
XFILLER_2_531 vssd1 vssd1 vccd1 vccd1 sky130_fd_sc_hd__fill_1
X_12054_ net995 cell1.LE_1A.config_data\[4\] net889 vssd1 vssd1 vccd1 vccd1 _00490_
+ sky130_fd_sc_hd__mux2_1
XANTENNA__10506__A1 net335 vssd1 vssd1 vccd1 vccd1 sky130_fd_sc_hd__diode_2
X_11005_ net285 net279 net297 net290 cell3.LEI0.config_data\[12\] cell3.LEI0.config_data\[13\]
+ vssd1 vssd1 vccd1 vccd1 _05959_ sky130_fd_sc_hd__mux4_1
XFILLER_77_343 vssd1 vssd1 vccd1 vccd1 sky130_fd_sc_hd__fill_1
XANTENNA_input21_X net21 vssd1 vssd1 vccd1 vccd1 sky130_fd_sc_hd__diode_2
XTAP_TAPCELL_ROW_5_380 vssd1 vccd1 sky130_fd_sc_hd__tapvpwrvgnd_1
XANTENNA_output222_A net222 vssd1 vssd1 vccd1 vccd1 sky130_fd_sc_hd__diode_2
Xfanout890 net891 vssd1 vssd1 vccd1 vccd1 net890 sky130_fd_sc_hd__clkbuf_4
XANTENNA_clkbuf_4_13_0_clk_X clknet_4_13_0_clk vssd1 vssd1 vccd1 vccd1 sky130_fd_sc_hd__diode_2
XFILLER_92_335 vccd1 vssd1 vccd1 vssd1 sky130_ef_sc_hd__decap_40_12
XFILLER_93_51 vssd1 vssd1 vccd1 vccd1 sky130_fd_sc_hd__fill_4
XANTENNA__11383__X _06256_ vssd1 vssd1 vccd1 vccd1 sky130_fd_sc_hd__diode_2
X_12956_ net974 _06191_ net756 vssd1 vssd1 vccd1 vccd1 _01384_ sky130_fd_sc_hd__mux2_1
XTAP_TAPCELL_ROW_125_2189 vssd1 vccd1 sky130_fd_sc_hd__tapvpwrvgnd_1
XTAP_TAPCELL_ROW_125_2178 vssd1 vccd1 sky130_fd_sc_hd__tapvpwrvgnd_1
XFILLER_93_84 vssd1 vssd1 vccd1 vccd1 sky130_fd_sc_hd__fill_4
XFILLER_46_763 vssd1 vssd1 vccd1 vccd1 sky130_fd_sc_hd__fill_1
X_12887_ net370 net371 net937 vssd1 vssd1 vccd1 vccd1 _01316_ sky130_fd_sc_hd__mux2_1
X_11907_ cell0.SB0.route_sel\[13\] cell0.SB0.route_sel\[12\] net781 vssd1 vssd1 vccd1
+ vccd1 _00344_ sky130_fd_sc_hd__mux2_1
XANTENNA__10690__A0 net17 vssd1 vssd1 vccd1 vccd1 sky130_fd_sc_hd__diode_2
XFILLER_61_777 vssd1 vssd1 vccd1 vccd1 sky130_fd_sc_hd__fill_1
XTAP_TAPCELL_ROW_44_975 vssd1 vccd1 sky130_fd_sc_hd__tapvpwrvgnd_1
XTAP_TAPCELL_ROW_44_964 vssd1 vccd1 sky130_fd_sc_hd__tapvpwrvgnd_1
X_11838_ cell1.CB_1.config_dataA\[19\] cell1.CB_1.config_dataA\[18\] net889 vssd1
+ vssd1 vccd1 vccd1 _00275_ sky130_fd_sc_hd__mux2_1
XFILLER_20_107 vssd1 vssd1 vccd1 vccd1 sky130_fd_sc_hd__fill_1
Xclkbuf_leaf_40_clk clknet_4_7_0_clk vssd1 vssd1 vccd1 vccd1 clknet_leaf_40_clk sky130_fd_sc_hd__clkbuf_8
X_11769_ net1286 cell0.LEI0.config_data\[18\] net791 vssd1 vssd1 vccd1 vccd1 _00206_
+ sky130_fd_sc_hd__mux2_1
X_13508_ clknet_leaf_103_clk _00480_ net678 vssd1 vssd1 vccd1 vccd1 cell1.CB_1.config_dataB\[21\]
+ sky130_fd_sc_hd__dfstp_1
XANTENNA__10993__A1 _05901_ vssd1 vssd1 vccd1 vccd1 sky130_fd_sc_hd__diode_2
X_13439_ clknet_leaf_130_clk _00411_ net562 vssd1 vssd1 vccd1 vccd1 cell0.SB0.route_sel\[80\]
+ sky130_fd_sc_hd__dfstp_2
XTAP_TAPCELL_ROW_54_1118 vssd1 vccd1 sky130_fd_sc_hd__tapvpwrvgnd_1
XANTENNA__11558__X net255 vssd1 vssd1 vccd1 vccd1 sky130_fd_sc_hd__diode_2
XANTENNA__10462__X bus3_2\[11\] vssd1 vssd1 vccd1 vccd1 sky130_fd_sc_hd__diode_2
X_08980_ cell1.LE_0A.config_data\[15\] cell1.LE_0A.config_data\[14\] _03936_ vssd1
+ vssd1 vccd1 vccd1 _04012_ sky130_fd_sc_hd__mux2_1
XFILLER_102_429 vssd1 vssd1 vccd1 vccd1 sky130_fd_sc_hd__fill_2
X_07931_ _01572_ _02971_ _02974_ _01574_ _02964_ vssd1 vssd1 vccd1 vccd1 _02975_ sky130_fd_sc_hd__o311a_1
XANTENNA__11170__A1 _05890_ vssd1 vssd1 vccd1 vccd1 sky130_fd_sc_hd__diode_2
XFILLER_110_451 vssd1 vssd1 vccd1 vccd1 sky130_fd_sc_hd__fill_4
XFILLER_68_365 vssd1 vssd1 vccd1 vccd1 sky130_fd_sc_hd__fill_1
XFILLER_68_332 vssd1 vssd1 vccd1 vccd1 sky130_fd_sc_hd__fill_1
X_07862_ _02869_ _02902_ _02905_ _02870_ cell0.CB_0.config_dataA\[7\] vssd1 vssd1
+ vccd1 vccd1 _02906_ sky130_fd_sc_hd__a221o_1
XFILLER_96_696 vssd1 vssd1 vccd1 vccd1 sky130_fd_sc_hd__fill_1
X_09601_ cell3.SB0.route_sel\[88\] cell3.SB0.route_sel\[89\] vssd1 vssd1 vccd1 vccd1
+ _04618_ sky130_fd_sc_hd__nand2_1
XFILLER_3_93 vccd1 vssd1 vccd1 vssd1 sky130_ef_sc_hd__decap_40_12
X_06813_ _01845_ _01846_ _01881_ _01882_ vssd1 vssd1 vccd1 vccd1 _01883_ sky130_fd_sc_hd__a22o_1
XFILLER_113_39 vccd1 vssd1 vccd1 vssd1 sky130_ef_sc_hd__decap_40_12
XFILLER_95_195 vssd1 vssd1 vccd1 vccd1 sky130_fd_sc_hd__fill_8
X_09532_ cell3.SB0.route_sel\[64\] _01717_ cell3.SB0.route_sel\[67\] _01719_ _04551_
+ vssd1 vssd1 vccd1 vccd1 _04552_ sky130_fd_sc_hd__a221o_1
X_07793_ net345 net359 net354 vssd1 vssd1 vccd1 vccd1 _02838_ sky130_fd_sc_hd__nor3_1
XTAP_TAPCELL_ROW_69_1350 vssd1 vccd1 sky130_fd_sc_hd__tapvpwrvgnd_1
XFILLER_64_571 vssd1 vssd1 vccd1 vccd1 sky130_fd_sc_hd__fill_1
X_06744_ cell0.SB0.route_sel\[32\] vssd1 vssd1 vccd1 vccd1 _01814_ sky130_fd_sc_hd__inv_2
XFILLER_36_262 vssd1 vssd1 vccd1 vccd1 sky130_fd_sc_hd__fill_1
X_09463_ _04313_ _04412_ vssd1 vssd1 vccd1 vccd1 _04485_ sky130_fd_sc_hd__nor2_1
X_06675_ cell3.SB0.route_sel\[114\] vssd1 vssd1 vccd1 vccd1 _01745_ sky130_fd_sc_hd__inv_2
X_09394_ _04374_ _04417_ net552 vssd1 vssd1 vccd1 vccd1 _04418_ sky130_fd_sc_hd__o21ai_1
X_08414_ _03451_ _03450_ _03347_ vssd1 vssd1 vccd1 vccd1 _03452_ sky130_fd_sc_hd__mux2_1
XFILLER_24_446 vssd1 vssd1 vccd1 vccd1 sky130_fd_sc_hd__fill_8
X_08345_ net503 _02560_ _03382_ vssd1 vssd1 vccd1 vccd1 _03383_ sky130_fd_sc_hd__a21o_1
XFILLER_11_129 vssd1 vssd1 vccd1 vccd1 sky130_fd_sc_hd__fill_1
XANTENNA__07429__A1 _02478_ vssd1 vssd1 vccd1 vccd1 sky130_fd_sc_hd__diode_2
Xclkbuf_leaf_31_clk clknet_4_7_0_clk vssd1 vssd1 vccd1 vccd1 clknet_leaf_31_clk sky130_fd_sc_hd__clkbuf_8
XFILLER_138_805 vssd1 vssd1 vccd1 vccd1 sky130_fd_sc_hd__fill_4
XTAP_TAPCELL_ROW_22_636 vssd1 vccd1 sky130_fd_sc_hd__tapvpwrvgnd_1
XFILLER_138_25 vssd1 vssd1 vccd1 vccd1 sky130_fd_sc_hd__fill_2
XFILLER_137_326 vssd1 vssd1 vccd1 vccd1 sky130_fd_sc_hd__fill_1
XANTENNA__10984__A1 net50 vssd1 vssd1 vccd1 vccd1 sky130_fd_sc_hd__diode_2
X_08276_ net506 _02277_ _03313_ vssd1 vssd1 vccd1 vccd1 _03314_ sky130_fd_sc_hd__a21o_1
XFILLER_20_674 vssd1 vssd1 vccd1 vccd1 sky130_fd_sc_hd__fill_1
X_07227_ cell1.SB0.route_sel\[90\] cell1.SB0.route_sel\[91\] _02286_ vssd1 vssd1 vccd1
+ vccd1 _02287_ sky130_fd_sc_hd__a21oi_1
XFILLER_98_29 vccd1 vssd1 vccd1 vssd1 sky130_ef_sc_hd__decap_40_12
XFILLER_3_317 vccd1 vssd1 vccd1 vssd1 sky130_ef_sc_hd__decap_40_12
X_07158_ net2 _02218_ _02219_ vssd1 vssd1 vccd1 vccd1 _02220_ sky130_fd_sc_hd__o21ai_1
XANTENNA__11468__X net215 vssd1 vssd1 vccd1 vccd1 sky130_fd_sc_hd__diode_2
XANTENNA_fanout887_A net908 vssd1 vssd1 vccd1 vccd1 sky130_fd_sc_hd__diode_2
XANTENNA__07394__A bus3_2\[13\] vssd1 vssd1 vccd1 vccd1 sky130_fd_sc_hd__diode_2
X_07089_ cell1.CB_0.config_dataB\[24\] cell1.CB_0.config_dataB\[21\] cell1.CB_0.config_dataB\[20\]
+ vssd1 vssd1 vccd1 vccd1 _02153_ sky130_fd_sc_hd__or3b_2
XFILLER_120_215 vssd1 vssd1 vccd1 vccd1 sky130_fd_sc_hd__fill_1
XANTENNA_fanout675_X net675 vssd1 vssd1 vccd1 vccd1 sky130_fd_sc_hd__diode_2
Xclkbuf_leaf_98_clk clknet_4_10_0_clk vssd1 vssd1 vccd1 vccd1 clknet_leaf_98_clk sky130_fd_sc_hd__clkbuf_8
X_12810_ cell2.SB0.route_sel\[52\] cell2.SB0.route_sel\[51\] net811 vssd1 vssd1 vccd1
+ vccd1 _01239_ sky130_fd_sc_hd__mux2_1
XFILLER_86_195 vssd1 vssd1 vccd1 vccd1 sky130_fd_sc_hd__fill_1
XANTENNA__09106__A1 bus3_1\[7\] vssd1 vssd1 vccd1 vccd1 sky130_fd_sc_hd__diode_2
XANTENNA_input120_A SBwest_in[30] vssd1 vssd1 vccd1 vccd1 sky130_fd_sc_hd__diode_2
X_13790_ clknet_leaf_104_clk _00762_ net678 vssd1 vssd1 vccd1 vccd1 cell1.SB0.route_sel\[67\]
+ sky130_fd_sc_hd__dfstp_1
XFILLER_28_785 vssd1 vssd1 vccd1 vccd1 sky130_fd_sc_hd__fill_1
X_12741_ cell3.CB_0.config_dataA\[8\] cell3.CB_0.config_dataA\[7\] net925 vssd1 vssd1
+ vccd1 vccd1 _01170_ sky130_fd_sc_hd__mux2_1
Xclkbuf_1_0__f_cell3.LE_1A.sel_clk clknet_0_cell3.LE_1A.sel_clk vssd1 vssd1 vccd1
+ vccd1 clknet_1_0__leaf_cell3.LE_1A.sel_clk sky130_fd_sc_hd__clkbuf_16
XFILLER_103_61 vssd1 vssd1 vccd1 vccd1 sky130_fd_sc_hd__fill_1
X_12672_ net1159 net1181 net955 vssd1 vssd1 vccd1 vccd1 _01101_ sky130_fd_sc_hd__mux2_1
X_14411_ clknet_1_1__leaf_cell3.LE_1A.sel_clk _01383_ net753 vssd1 vssd1 vccd1 vccd1
+ cell3.LE_1A.dff1_out sky130_fd_sc_hd__dfstp_1
X_11623_ cell0.CB_0.config_dataB\[19\] cell0.CB_0.config_dataB\[18\] net780 vssd1
+ vssd1 vccd1 vccd1 _00064_ sky130_fd_sc_hd__mux2_1
XTAP_TAPCELL_ROW_41_923 vssd1 vccd1 sky130_fd_sc_hd__tapvpwrvgnd_1
Xclkbuf_leaf_22_clk clknet_4_4_0_clk vssd1 vssd1 vccd1 vccd1 clknet_leaf_22_clk sky130_fd_sc_hd__clkbuf_8
XFILLER_8_27 vssd1 vssd1 vccd1 vccd1 sky130_fd_sc_hd__fill_1
X_14342_ clknet_leaf_18_clk _01314_ net627 vssd1 vssd1 vccd1 vccd1 cell2.SB0.config_data_out
+ sky130_fd_sc_hd__dfstp_2
XANTENNA__07703__B1_N net90 vssd1 vssd1 vccd1 vccd1 sky130_fd_sc_hd__diode_2
X_11554_ cell0.SB0.route_sel\[31\] cell0.SB0.route_sel\[30\] cell0.SB0.route_sel\[25\]
+ _01818_ _06369_ vssd1 vssd1 vccd1 vccd1 _06370_ sky130_fd_sc_hd__o221a_1
X_14273_ clknet_leaf_24_clk _01245_ net605 vssd1 vssd1 vccd1 vccd1 cell2.SB0.route_sel\[58\]
+ sky130_fd_sc_hd__dfstp_1
X_11485_ _01550_ cell1.SB0.route_sel\[120\] _01551_ cell1.SB0.route_sel\[123\] _06323_
+ vssd1 vssd1 vccd1 vccd1 _06324_ sky130_fd_sc_hd__a221o_1
XFILLER_6_133 vssd1 vssd1 vccd1 vccd1 sky130_fd_sc_hd__fill_4
X_10505_ net322 _03468_ _02283_ vssd1 vssd1 vccd1 vccd1 _05468_ sky130_fd_sc_hd__mux2_1
XFILLER_136_370 vssd1 vssd1 vccd1 vccd1 sky130_fd_sc_hd__fill_1
X_10436_ _01695_ cell3.SB0.route_sel\[26\] vssd1 vssd1 vccd1 vccd1 _05431_ sky130_fd_sc_hd__nand2_1
X_13224_ clknet_leaf_121_clk _00196_ net593 vssd1 vssd1 vccd1 vccd1 cell0.LEI0.config_data\[9\]
+ sky130_fd_sc_hd__dfrtp_1
XANTENNA_output172_A net172 vssd1 vssd1 vccd1 vccd1 sky130_fd_sc_hd__diode_2
XANTENNA_input69_X net69 vssd1 vssd1 vccd1 vccd1 sky130_fd_sc_hd__diode_2
XANTENNA__11378__X net257 vssd1 vssd1 vccd1 vccd1 sky130_fd_sc_hd__diode_2
X_10367_ net429 net427 _05114_ _05365_ cell2.CB_0.config_dataB\[12\] vssd1 vssd1 vccd1
+ vccd1 _05366_ sky130_fd_sc_hd__o311a_1
XFILLER_88_73 vssd1 vssd1 vccd1 vccd1 sky130_fd_sc_hd__fill_1
X_13155_ clknet_leaf_120_clk _00127_ net596 vssd1 vssd1 vccd1 vccd1 cell0.LE_1A.config_data\[6\]
+ sky130_fd_sc_hd__dfrtp_1
XFILLER_40_8 vccd1 vssd1 vccd1 vssd1 sky130_ef_sc_hd__decap_40_12
X_10298_ net431 _05107_ _05296_ net430 vssd1 vssd1 vccd1 vccd1 _05297_ sky130_fd_sc_hd__o211a_1
XFILLER_124_587 vssd1 vssd1 vccd1 vccd1 sky130_fd_sc_hd__fill_1
XFILLER_111_204 vssd1 vssd1 vccd1 vccd1 sky130_fd_sc_hd__fill_1
XFILLER_97_449 vssd1 vssd1 vccd1 vccd1 sky130_fd_sc_hd__fill_1
XANTENNA__13335__SET_B net674 vssd1 vssd1 vccd1 vccd1 sky130_fd_sc_hd__diode_2
X_12106_ net1141 cell1.LE_0A.config_data\[10\] net876 vssd1 vssd1 vccd1 vccd1 _00540_
+ sky130_fd_sc_hd__mux2_1
X_13086_ clknet_leaf_4_clk _00058_ net564 vssd1 vssd1 vccd1 vccd1 cell0.CB_0.config_dataB\[13\]
+ sky130_fd_sc_hd__dfstp_1
XFILLER_2_361 vssd1 vssd1 vccd1 vccd1 sky130_fd_sc_hd__fill_2
XTAP_TAPCELL_ROW_127_2218 vssd1 vccd1 sky130_fd_sc_hd__tapvpwrvgnd_1
XTAP_TAPCELL_ROW_127_2207 vssd1 vccd1 sky130_fd_sc_hd__tapvpwrvgnd_1
Xclkbuf_leaf_89_clk clknet_4_11_0_clk vssd1 vssd1 vccd1 vccd1 clknet_leaf_89_clk sky130_fd_sc_hd__clkbuf_8
XANTENNA__08148__A2 bus1_0\[2\] vssd1 vssd1 vccd1 vccd1 sky130_fd_sc_hd__diode_2
X_12037_ net453 cell1.CB_1.config_dataB\[14\] net887 vssd1 vssd1 vccd1 vccd1 _00474_
+ sky130_fd_sc_hd__mux2_1
XTAP_TAPCELL_ROW_109_1940 vssd1 vccd1 sky130_fd_sc_hd__tapvpwrvgnd_1
XTAP_TAPCELL_ROW_0_309 vssd1 vccd1 sky130_fd_sc_hd__tapvpwrvgnd_1
XTAP_TAPCELL_ROW_140_2407 vssd1 vccd1 sky130_fd_sc_hd__tapvpwrvgnd_1
X_13988_ clknet_leaf_43_clk _00960_ net633 vssd1 vssd1 vccd1 vccd1 cell2.LEI0.config_data\[45\]
+ sky130_fd_sc_hd__dfrtp_1
X_12939_ net1013 cell3.LE_0B.config_data\[3\] net931 vssd1 vssd1 vccd1 vccd1 _01367_
+ sky130_fd_sc_hd__mux2_1
XANTENNA__10258__A3 net39 vssd1 vssd1 vccd1 vccd1 sky130_fd_sc_hd__diode_2
X_06460_ cell1.SB0.route_sel\[75\] vssd1 vssd1 vccd1 vccd1 _01530_ sky130_fd_sc_hd__inv_2
XANTENNA__08608__A0 net4 vssd1 vssd1 vccd1 vccd1 sky130_fd_sc_hd__diode_2
Xclkbuf_leaf_13_clk clknet_4_3_0_clk vssd1 vssd1 vccd1 vccd1 clknet_leaf_13_clk sky130_fd_sc_hd__clkbuf_8
X_08130_ _02136_ _03167_ _03166_ cell0.CB_1.config_dataA\[2\] vssd1 vssd1 vccd1 vccd1
+ _03170_ sky130_fd_sc_hd__a211oi_1
X_06391_ cell0.SB0.route_sel\[56\] vssd1 vssd1 vccd1 vccd1 _01461_ sky130_fd_sc_hd__inv_2
XFILLER_21_449 vssd1 vssd1 vccd1 vccd1 sky130_fd_sc_hd__fill_2
XANTENNA__12955__A2 net550 vssd1 vssd1 vccd1 vccd1 sky130_fd_sc_hd__diode_2
X_08061_ net527 _02894_ vssd1 vssd1 vccd1 vccd1 _03103_ sky130_fd_sc_hd__or2_1
XANTENNA__07198__B net357 vssd1 vssd1 vccd1 vccd1 sky130_fd_sc_hd__diode_2
XANTENNA__09694__A net56 vssd1 vssd1 vccd1 vccd1 sky130_fd_sc_hd__diode_2
X_07012_ _02028_ _02075_ _02076_ vssd1 vssd1 vccd1 vccd1 _02077_ sky130_fd_sc_hd__a21oi_1
XANTENNA__08387__A2 bus1_0\[10\] vssd1 vssd1 vccd1 vccd1 sky130_fd_sc_hd__diode_2
XANTENNA__13686__SET_B net619 vssd1 vssd1 vccd1 vccd1 sky130_fd_sc_hd__diode_2
XFILLER_0_309 vssd1 vssd1 vccd1 vccd1 sky130_fd_sc_hd__fill_1
XFILLER_103_727 vssd1 vssd1 vccd1 vccd1 sky130_fd_sc_hd__fill_1
X_08963_ net464 _03817_ _03994_ net463 vssd1 vssd1 vccd1 vccd1 _03995_ sky130_fd_sc_hd__o211a_1
XFILLER_124_27 vssd1 vssd1 vccd1 vccd1 sky130_fd_sc_hd__fill_1
XANTENNA__10920__X _05874_ vssd1 vssd1 vccd1 vccd1 sky130_fd_sc_hd__diode_2
X_07914_ cell0.CB_0.config_dataA\[13\] cell0.CB_0.config_dataA\[12\] vssd1 vssd1 vccd1
+ vccd1 _02958_ sky130_fd_sc_hd__nor2_1
XANTENNA__11143__A1 net48 vssd1 vssd1 vccd1 vccd1 sky130_fd_sc_hd__diode_2
X_08894_ net472 _03924_ _03925_ vssd1 vssd1 vccd1 vccd1 _03926_ sky130_fd_sc_hd__a21oi_1
XFILLER_29_505 vssd1 vssd1 vccd1 vccd1 sky130_fd_sc_hd__fill_8
X_07845_ cell0.SB0.route_sel\[43\] cell0.SB0.route_sel\[42\] _01610_ cell0.SB0.route_sel\[45\]
+ _02888_ vssd1 vssd1 vccd1 vccd1 _02889_ sky130_fd_sc_hd__o221a_2
XFILLER_140_15 vccd1 vssd1 vccd1 vssd1 sky130_ef_sc_hd__decap_40_12
XFILLER_72_817 vssd1 vssd1 vccd1 vccd1 sky130_fd_sc_hd__fill_1
XTAP_TAPCELL_ROW_67_1309 vssd1 vccd1 sky130_fd_sc_hd__tapvpwrvgnd_1
XTAP_TAPCELL_ROW_27_706 vssd1 vccd1 sky130_fd_sc_hd__tapvpwrvgnd_1
XTAP_TAPCELL_ROW_27_717 vssd1 vccd1 sky130_fd_sc_hd__tapvpwrvgnd_1
X_07776_ cell1.SB0.route_sel\[32\] cell1.SB0.route_sel\[33\] _01512_ cell1.SB0.route_sel\[35\]
+ _02821_ vssd1 vssd1 vccd1 vccd1 _02822_ sky130_fd_sc_hd__o221a_1
X_06727_ cell3.CB_0.config_dataB\[4\] vssd1 vssd1 vccd1 vccd1 _01797_ sky130_fd_sc_hd__inv_2
X_09515_ _04210_ _04534_ vssd1 vssd1 vccd1 vccd1 _04535_ sky130_fd_sc_hd__nor2_1
XFILLER_17_69 vssd1 vssd1 vccd1 vccd1 sky130_fd_sc_hd__fill_2
XANTENNA_fanout635_A net640 vssd1 vssd1 vccd1 vccd1 sky130_fd_sc_hd__diode_2
XTAP_TAPCELL_ROW_80_1509 vssd1 vccd1 sky130_fd_sc_hd__tapvpwrvgnd_1
X_09446_ net328 _01884_ _01885_ _04467_ vssd1 vssd1 vccd1 vccd1 _04468_ sky130_fd_sc_hd__o31a_1
X_06658_ cell3.SB0.route_sel\[81\] vssd1 vssd1 vccd1 vccd1 _01728_ sky130_fd_sc_hd__inv_2
XANTENNA__10406__A0 net61 vssd1 vssd1 vccd1 vccd1 sky130_fd_sc_hd__diode_2
X_09377_ cell3.SB0.route_sel\[38\] cell3.SB0.route_sel\[39\] _01702_ _01703_ _04387_
+ vssd1 vssd1 vccd1 vccd1 _04401_ sky130_fd_sc_hd__a2111o_1
XANTENNA_fanout802_A net806 vssd1 vssd1 vccd1 vccd1 sky130_fd_sc_hd__diode_2
XFILLER_40_769 vssd1 vssd1 vccd1 vccd1 sky130_fd_sc_hd__fill_1
X_06589_ cell1.CB_1.config_dataB\[18\] vssd1 vssd1 vccd1 vccd1 _01659_ sky130_fd_sc_hd__inv_2
XFILLER_33_57 vccd1 vssd1 vccd1 vssd1 sky130_ef_sc_hd__decap_40_12
XFILLER_137_101 vssd1 vssd1 vccd1 vccd1 sky130_fd_sc_hd__fill_2
X_08328_ net510 _02560_ _03365_ vssd1 vssd1 vccd1 vccd1 _03366_ sky130_fd_sc_hd__a21o_1
X_08259_ cell0.CB_1.config_dataA\[19\] _03266_ _03285_ _03298_ vssd1 vssd1 vccd1 vccd1
+ _03299_ sky130_fd_sc_hd__a31o_1
XANTENNA__08614__A3 net323 vssd1 vssd1 vccd1 vccd1 sky130_fd_sc_hd__diode_2
XTAP_TAPCELL_ROW_95_1730 vssd1 vccd1 sky130_fd_sc_hd__tapvpwrvgnd_1
X_11270_ _02101_ _06203_ _02104_ vssd1 vssd1 vccd1 vccd1 net196 sky130_fd_sc_hd__o21ai_2
XFILLER_109_3 vccd1 vssd1 vccd1 vssd1 sky130_ef_sc_hd__decap_40_12
XFILLER_106_543 vssd1 vssd1 vccd1 vccd1 sky130_fd_sc_hd__fill_1
XANTENNA__10709__B2 _05510_ vssd1 vssd1 vccd1 vccd1 sky130_fd_sc_hd__diode_2
XFILLER_4_637 vssd1 vssd1 vccd1 vccd1 sky130_fd_sc_hd__fill_4
XFILLER_3_125 vccd1 vssd1 vccd1 vssd1 sky130_ef_sc_hd__decap_40_12
X_10221_ net60 _05200_ _05201_ net59 cell2.CB_0.config_dataA\[13\] vssd1 vssd1 vccd1
+ vccd1 _05222_ sky130_fd_sc_hd__a221o_1
XFILLER_106_576 vccd1 vssd1 vccd1 vssd1 sky130_ef_sc_hd__decap_40_12
XFILLER_3_169 vccd1 vssd1 vccd1 vssd1 sky130_ef_sc_hd__decap_40_12
X_10152_ net44 _05152_ _05094_ vssd1 vssd1 vccd1 vccd1 _05153_ sky130_fd_sc_hd__o21a_1
XFILLER_79_449 vssd1 vssd1 vccd1 vccd1 sky130_fd_sc_hd__fill_4
XTAP_TAPCELL_ROW_7_420 vssd1 vccd1 sky130_fd_sc_hd__tapvpwrvgnd_1
XFILLER_0_832 vssd1 vssd1 vccd1 vccd1 sky130_fd_sc_hd__fill_2
XANTENNA__07050__A2 net355 vssd1 vssd1 vccd1 vccd1 sky130_fd_sc_hd__diode_2
X_10083_ _02320_ _05083_ vssd1 vssd1 vccd1 vccd1 _05084_ sky130_fd_sc_hd__nand2_4
X_13911_ clknet_leaf_35_clk net1232 net637 vssd1 vssd1 vccd1 vccd1 cell2.LE_0B.config_data\[12\]
+ sky130_fd_sc_hd__dfrtp_1
Xhold9 cell3.LE_1A.dff0_out vssd1 vssd1 vccd1 vccd1 net968 sky130_fd_sc_hd__dlygate4sd3_1
XANTENNA__09878__A2 _04696_ vssd1 vssd1 vccd1 vccd1 sky130_fd_sc_hd__diode_2
XFILLER_58_87 vssd1 vssd1 vccd1 vccd1 sky130_fd_sc_hd__fill_1
XFILLER_101_281 vssd1 vssd1 vccd1 vccd1 sky130_fd_sc_hd__fill_1
XANTENNA_input29_A CBeast_in[6] vssd1 vssd1 vccd1 vccd1 sky130_fd_sc_hd__diode_2
XFILLER_47_324 vssd1 vssd1 vccd1 vccd1 sky130_fd_sc_hd__fill_1
XFILLER_90_614 vssd1 vssd1 vccd1 vccd1 sky130_fd_sc_hd__fill_2
XFILLER_75_688 vssd1 vssd1 vccd1 vccd1 sky130_fd_sc_hd__fill_2
X_13842_ clknet_leaf_115_clk _00814_ net666 vssd1 vssd1 vccd1 vccd1 cell1.SB0.route_sel\[119\]
+ sky130_fd_sc_hd__dfstp_1
XANTENNA__08550__A2 _03533_ vssd1 vssd1 vccd1 vccd1 sky130_fd_sc_hd__diode_2
XTAP_TAPCELL_ROW_122_2137 vssd1 vccd1 sky130_fd_sc_hd__tapvpwrvgnd_1
XFILLER_90_636 vssd1 vssd1 vccd1 vccd1 sky130_fd_sc_hd__fill_4
X_13773_ clknet_leaf_107_clk _00745_ net659 vssd1 vssd1 vccd1 vccd1 cell1.SB0.route_sel\[50\]
+ sky130_fd_sc_hd__dfstp_1
XFILLER_28_582 vssd1 vssd1 vccd1 vccd1 sky130_fd_sc_hd__fill_2
X_10985_ cell3.CB_0.config_dataA\[7\] _05937_ cell3.CB_0.config_dataA\[8\] vssd1 vssd1
+ vccd1 vccd1 _05939_ sky130_fd_sc_hd__a21bo_1
X_12724_ cell3.CB_0.config_dataB\[16\] cell3.CB_0.config_dataB\[15\] net930 vssd1
+ vssd1 vccd1 vccd1 _01153_ sky130_fd_sc_hd__mux2_1
XTAP_TAPCELL_ROW_104_1870 vssd1 vccd1 sky130_fd_sc_hd__tapvpwrvgnd_1
XANTENNA__10660__A3 _05489_ vssd1 vssd1 vccd1 vccd1 sky130_fd_sc_hd__diode_2
XANTENNA__12409__S net837 vssd1 vssd1 vccd1 vccd1 sky130_fd_sc_hd__diode_2
X_12655_ cell3.SB0.route_sel\[120\] cell3.SB0.route_sel\[119\] net921 vssd1 vssd1
+ vccd1 vccd1 _01084_ sky130_fd_sc_hd__mux2_1
XFILLER_90_41 vssd1 vssd1 vccd1 vccd1 sky130_fd_sc_hd__fill_2
X_12586_ cell3.SB0.route_sel\[51\] cell3.SB0.route_sel\[50\] net915 vssd1 vssd1 vccd1
+ vccd1 _01015_ sky130_fd_sc_hd__mux2_1
X_11606_ cell0.CB_0.config_dataB\[2\] net532 net779 vssd1 vssd1 vccd1 vccd1 _00047_
+ sky130_fd_sc_hd__mux2_1
XANTENNA__08066__B2 _02890_ vssd1 vssd1 vccd1 vccd1 sky130_fd_sc_hd__diode_2
X_14325_ clknet_leaf_22_clk _01297_ net605 vssd1 vssd1 vccd1 vccd1 cell2.SB0.route_sel\[110\]
+ sky130_fd_sc_hd__dfstp_1
XTAP_TAPCELL_ROW_13_499 vssd1 vccd1 sky130_fd_sc_hd__tapvpwrvgnd_1
X_11537_ _02630_ _06358_ vssd1 vssd1 vccd1 vccd1 net198 sky130_fd_sc_hd__nor2_1
Xhold409 _00879_ vssd1 vssd1 vccd1 vccd1 net1368 sky130_fd_sc_hd__dlygate4sd3_1
XFILLER_7_453 vssd1 vssd1 vccd1 vccd1 sky130_fd_sc_hd__fill_1
XFILLER_125_841 vssd1 vssd1 vccd1 vccd1 sky130_fd_sc_hd__fill_1
X_14256_ clknet_leaf_27_clk _01228_ net613 vssd1 vssd1 vccd1 vccd1 cell2.SB0.route_sel\[41\]
+ sky130_fd_sc_hd__dfstp_1
XANTENNA__08622__S _03546_ vssd1 vssd1 vccd1 vccd1 sky130_fd_sc_hd__diode_2
X_11468_ _06312_ net270 vssd1 vssd1 vccd1 vccd1 net215 sky130_fd_sc_hd__and2b_1
XFILLER_140_811 vssd1 vssd1 vccd1 vccd1 sky130_fd_sc_hd__fill_1
X_10419_ cell2.LE_0B.config_data\[13\] cell2.LE_0B.config_data\[12\] _05344_ vssd1
+ vssd1 vccd1 vccd1 _05418_ sky130_fd_sc_hd__mux2_1
XTAP_TAPCELL_ROW_133_2299 vssd1 vccd1 sky130_fd_sc_hd__tapvpwrvgnd_1
X_14187_ clknet_leaf_59_clk _01159_ net720 vssd1 vssd1 vccd1 vccd1 cell3.CB_0.config_dataB\[22\]
+ sky130_fd_sc_hd__dfstp_1
XANTENNA__10453__A net274 vssd1 vssd1 vccd1 vccd1 sky130_fd_sc_hd__diode_2
X_13207_ clknet_leaf_23_clk _00179_ net604 vssd1 vssd1 vccd1 vccd1 cell0.LE_0A.config_data\[14\]
+ sky130_fd_sc_hd__dfrtp_1
X_11399_ _02132_ _06266_ vssd1 vssd1 vccd1 vccd1 net229 sky130_fd_sc_hd__nor2_1
XANTENNA__07041__A2 _02080_ vssd1 vssd1 vccd1 vccd1 sky130_fd_sc_hd__diode_2
X_13138_ clknet_leaf_127_clk _00110_ net582 vssd1 vssd1 vccd1 vccd1 cell0.CB_1.config_dataB\[15\]
+ sky130_fd_sc_hd__dfstp_1
XFILLER_97_279 vssd1 vssd1 vccd1 vccd1 sky130_fd_sc_hd__fill_1
Xclkbuf_leaf_2_clk clknet_4_0_0_clk vssd1 vssd1 vccd1 vccd1 clknet_leaf_2_clk sky130_fd_sc_hd__clkbuf_8
X_13069_ clknet_leaf_125_clk _00041_ net654 vssd1 vssd1 vccd1 vccd1 cell0.CB_1.config_dataA\[21\]
+ sky130_fd_sc_hd__dfstp_1
XPHY_EDGE_ROW_119_Right_119 vssd1 vssd1 vccd1 vccd1 sky130_fd_sc_hd__decap_3
XANTENNA__10900__B cell3.SB0.route_sel\[100\] vssd1 vssd1 vccd1 vccd1 sky130_fd_sc_hd__diode_2
X_07630_ _02659_ _02675_ _02677_ _02660_ vssd1 vssd1 vccd1 vccd1 _02679_ sky130_fd_sc_hd__o31a_1
XTAP_TAPCELL_ROW_49_1039 vssd1 vccd1 sky130_fd_sc_hd__tapvpwrvgnd_1
X_07561_ net338 net358 net353 vssd1 vssd1 vccd1 vccd1 _02611_ sky130_fd_sc_hd__or3_1
X_06512_ cell2.SB0.route_sel\[15\] vssd1 vssd1 vccd1 vccd1 _01582_ sky130_fd_sc_hd__inv_2
X_09300_ cell3.SB0.route_sel\[29\] cell3.SB0.route_sel\[28\] net329 _02773_ vssd1
+ vssd1 vccd1 vccd1 _04325_ sky130_fd_sc_hd__o2bb2a_1
XFILLER_110_29 vccd1 vssd1 vccd1 vssd1 sky130_ef_sc_hd__decap_40_12
X_07492_ _02541_ _02543_ _02542_ vssd1 vssd1 vccd1 vccd1 _02544_ sky130_fd_sc_hd__o21bai_1
X_09231_ cell2.SB0.route_sel\[13\] cell2.SB0.route_sel\[12\] vssd1 vssd1 vccd1 vccd1
+ _04258_ sky130_fd_sc_hd__nor2_1
XTAP_TAPCELL_ROW_62_1239 vssd1 vccd1 sky130_fd_sc_hd__tapvpwrvgnd_1
XFILLER_61_393 vssd1 vssd1 vccd1 vccd1 sky130_fd_sc_hd__fill_2
XANTENNA__12389__A0 cell1.SB0.config_data_out vssd1 vssd1 vccd1 vccd1 sky130_fd_sc_hd__diode_2
X_06443_ cell1.SB0.route_sel\[35\] vssd1 vssd1 vccd1 vccd1 _01513_ sky130_fd_sc_hd__inv_2
X_09162_ _02099_ _04189_ vssd1 vssd1 vccd1 vccd1 _04190_ sky130_fd_sc_hd__nor2_1
XANTENNA__08057__A1 bus2_0\[9\] vssd1 vssd1 vccd1 vccd1 sky130_fd_sc_hd__diode_2
XFILLER_9_81 vccd1 vssd1 vccd1 vssd1 sky130_ef_sc_hd__decap_40_12
XANTENNA__11061__A0 net47 vssd1 vssd1 vccd1 vccd1 sky130_fd_sc_hd__diode_2
XFILLER_119_27 vccd1 vssd1 vccd1 vssd1 sky130_ef_sc_hd__decap_40_12
X_08113_ _03122_ _03154_ _03120_ vssd1 vssd1 vccd1 vccd1 _03155_ sky130_fd_sc_hd__mux2_1
XTAP_TAPCELL_ROW_32_786 vssd1 vccd1 sky130_fd_sc_hd__tapvpwrvgnd_1
X_09093_ _04122_ _04087_ _04051_ vssd1 vssd1 vccd1 vccd1 _04123_ sky130_fd_sc_hd__mux2_1
X_08044_ cell0.CB_0.config_dataB\[4\] _03061_ _03078_ _03085_ _01555_ vssd1 vssd1
+ vccd1 vccd1 _03086_ sky130_fd_sc_hd__a32o_1
XTAP_TAPCELL_ROW_77_1460 vssd1 vccd1 sky130_fd_sc_hd__tapvpwrvgnd_1
XFILLER_135_15 vccd1 vssd1 vccd1 vssd1 sky130_ef_sc_hd__decap_40_12
XFILLER_131_822 vssd1 vssd1 vccd1 vccd1 sky130_fd_sc_hd__fill_1
XANTENNA_clkbuf_4_1_0_clk_X clknet_4_1_0_clk vssd1 vssd1 vccd1 vccd1 sky130_fd_sc_hd__diode_2
XFILLER_0_117 vssd1 vssd1 vccd1 vccd1 sky130_fd_sc_hd__fill_1
XFILLER_1_629 vccd1 vssd1 vccd1 vssd1 sky130_ef_sc_hd__decap_40_12
X_09995_ _04641_ _04998_ cell2.CB_1.config_dataB\[12\] vssd1 vssd1 vccd1 vccd1 _04999_
+ sky130_fd_sc_hd__o21ai_1
XTAP_TAPCELL_ROW_90_1660 vssd1 vccd1 sky130_fd_sc_hd__tapvpwrvgnd_1
XANTENNA_fanout585_A net592 vssd1 vssd1 vccd1 vccd1 sky130_fd_sc_hd__diode_2
X_08946_ net464 _03885_ _03977_ net463 vssd1 vssd1 vccd1 vccd1 _03978_ sky130_fd_sc_hd__o211a_1
XANTENNA__06791__A1 _01856_ vssd1 vssd1 vccd1 vccd1 sky130_fd_sc_hd__diode_2
XANTENNA_fanout752_A net754 vssd1 vssd1 vccd1 vccd1 sky130_fd_sc_hd__diode_2
XFILLER_84_430 vssd1 vssd1 vccd1 vccd1 sky130_fd_sc_hd__fill_2
X_08877_ bus3_1\[8\] bus3_1\[9\] bus3_1\[10\] bus3_1\[11\] net473 cell1.CB_0.config_dataA\[1\]
+ vssd1 vssd1 vccd1 vccd1 _03909_ sky130_fd_sc_hd__mux4_1
XANTENNA__11465__Y net214 vssd1 vssd1 vccd1 vccd1 sky130_fd_sc_hd__diode_2
XANTENNA__10875__B1 _05829_ vssd1 vssd1 vccd1 vccd1 sky130_fd_sc_hd__diode_2
X_07828_ net519 _02585_ vssd1 vssd1 vccd1 vccd1 _02872_ sky130_fd_sc_hd__nand2_1
XANTENNA__08532__A2 net6 vssd1 vssd1 vccd1 vccd1 sky130_fd_sc_hd__diode_2
XFILLER_72_625 vssd1 vssd1 vccd1 vccd1 sky130_fd_sc_hd__fill_1
XFILLER_44_23 vssd1 vssd1 vccd1 vccd1 sky130_fd_sc_hd__fill_1
XFILLER_25_530 vssd1 vssd1 vccd1 vccd1 sky130_fd_sc_hd__fill_1
X_07759_ cell0.SB0.route_sel\[36\] cell0.SB0.route_sel\[37\] vssd1 vssd1 vccd1 vccd1
+ _02805_ sky130_fd_sc_hd__nor2_1
X_10770_ _01780_ net368 vssd1 vssd1 vccd1 vccd1 _05726_ sky130_fd_sc_hd__nor2_1
XANTENNA__12092__A2 _01820_ vssd1 vssd1 vccd1 vccd1 sky130_fd_sc_hd__diode_2
XANTENNA__08296__B2 bus1_0\[4\] vssd1 vssd1 vccd1 vccd1 sky130_fd_sc_hd__diode_2
XANTENNA__08296__A1 bus1_0\[5\] vssd1 vssd1 vccd1 vccd1 sky130_fd_sc_hd__diode_2
XANTENNA__12229__S net827 vssd1 vssd1 vccd1 vccd1 sky130_fd_sc_hd__diode_2
X_09429_ _04230_ _04406_ vssd1 vssd1 vccd1 vccd1 _04452_ sky130_fd_sc_hd__nor2_1
X_12440_ net1430 cell2.LE_1B.reset_mode net843 vssd1 vssd1 vccd1 vccd1 _00871_ sky130_fd_sc_hd__mux2_1
XANTENNA__09245__B1 _04271_ vssd1 vssd1 vccd1 vccd1 sky130_fd_sc_hd__diode_2
XFILLER_9_729 vssd1 vssd1 vccd1 vccd1 sky130_fd_sc_hd__fill_8
XANTENNA__09796__A1 _04555_ vssd1 vssd1 vccd1 vccd1 sky130_fd_sc_hd__diode_2
XFILLER_8_228 vssd1 vssd1 vccd1 vccd1 sky130_fd_sc_hd__fill_1
X_14110_ clknet_leaf_78_clk _01082_ net711 vssd1 vssd1 vccd1 vccd1 cell3.SB0.route_sel\[118\]
+ sky130_fd_sc_hd__dfstp_1
X_12371_ cell1.SB0.route_sel\[109\] cell1.SB0.route_sel\[108\] net802 vssd1 vssd1
+ vccd1 vccd1 _00804_ sky130_fd_sc_hd__mux2_1
XTAP_TAPCELL_ROW_10_458 vssd1 vccd1 sky130_fd_sc_hd__tapvpwrvgnd_1
X_11322_ net293 _06226_ _04678_ vssd1 vssd1 vccd1 vccd1 net155 sky130_fd_sc_hd__mux2_1
XANTENNA__06751__A net335 vssd1 vssd1 vccd1 vccd1 sky130_fd_sc_hd__diode_2
X_11253_ net306 _05152_ _04252_ vssd1 vssd1 vccd1 vccd1 _06194_ sky130_fd_sc_hd__mux2_1
X_14041_ clknet_leaf_50_clk _01013_ net711 vssd1 vssd1 vccd1 vccd1 cell3.SB0.route_sel\[49\]
+ sky130_fd_sc_hd__dfstp_1
XFILLER_5_39 vccd1 vssd1 vccd1 vssd1 sky130_ef_sc_hd__decap_40_12
XFILLER_4_445 vccd1 vssd1 vccd1 vssd1 sky130_ef_sc_hd__decap_40_12
XANTENNA__10158__A2 _05156_ vssd1 vssd1 vccd1 vccd1 sky130_fd_sc_hd__diode_2
X_10204_ net416 _05088_ _05204_ net414 vssd1 vssd1 vccd1 vccd1 _05205_ sky130_fd_sc_hd__o211a_1
XFILLER_4_489 vssd1 vssd1 vccd1 vccd1 sky130_fd_sc_hd__fill_4
X_11184_ cell3.CB_0.config_dataB\[14\] _06121_ _06135_ vssd1 vssd1 vccd1 vccd1 _06136_
+ sky130_fd_sc_hd__nor3_1
XFILLER_0_640 vssd1 vssd1 vccd1 vccd1 sky130_fd_sc_hd__fill_4
XANTENNA__09781__B net303 vssd1 vssd1 vccd1 vccd1 sky130_fd_sc_hd__diode_2
X_10135_ _05135_ _04442_ vssd1 vssd1 vccd1 vccd1 _05136_ sky130_fd_sc_hd__and2b_2
XANTENNA__07853__Y _02897_ vssd1 vssd1 vccd1 vccd1 sky130_fd_sc_hd__diode_2
XFILLER_0_651 vssd1 vssd1 vccd1 vccd1 sky130_fd_sc_hd__fill_4
X_10066_ _05032_ _05069_ _05030_ vssd1 vssd1 vccd1 vccd1 _05070_ sky130_fd_sc_hd__mux2_1
XANTENNA_output135_A net135 vssd1 vssd1 vccd1 vccd1 sky130_fd_sc_hd__diode_2
XANTENNA__09720__A1 _04719_ vssd1 vssd1 vccd1 vccd1 sky130_fd_sc_hd__diode_2
XFILLER_63_603 vssd1 vssd1 vccd1 vccd1 sky130_fd_sc_hd__fill_1
XFILLER_63_625 vssd1 vssd1 vccd1 vccd1 sky130_fd_sc_hd__fill_1
X_13825_ clknet_leaf_104_clk _00797_ net662 vssd1 vssd1 vccd1 vccd1 cell1.SB0.route_sel\[102\]
+ sky130_fd_sc_hd__dfstp_1
XFILLER_141_91 vssd1 vssd1 vccd1 vccd1 sky130_fd_sc_hd__fill_4
XFILLER_90_477 vssd1 vssd1 vccd1 vccd1 sky130_fd_sc_hd__fill_4
X_10968_ cell3.SB0.route_sel\[3\] cell3.SB0.route_sel\[2\] vssd1 vssd1 vccd1 vccd1
+ _05922_ sky130_fd_sc_hd__nor2_1
X_13756_ clknet_leaf_111_clk _00728_ net654 vssd1 vssd1 vccd1 vccd1 cell1.SB0.route_sel\[33\]
+ sky130_fd_sc_hd__dfstp_1
X_13687_ clknet_leaf_29_clk _00659_ net619 vssd1 vssd1 vccd1 vccd1 cell2.CB_0.config_dataB\[14\]
+ sky130_fd_sc_hd__dfstp_1
X_12707_ cell3.CB_1.config_dataA\[24\] cell3.CB_1.config_dataA\[23\] net936 vssd1
+ vssd1 vccd1 vccd1 _01136_ sky130_fd_sc_hd__mux2_1
XFILLER_70_190 vssd1 vssd1 vccd1 vccd1 sky130_fd_sc_hd__fill_4
XFILLER_43_382 vssd1 vssd1 vccd1 vccd1 sky130_fd_sc_hd__fill_1
X_10899_ net379 _05847_ _05852_ cell3.CB_0.config_dataA\[1\] vssd1 vssd1 vccd1 vccd1
+ _05853_ sky130_fd_sc_hd__o211a_1
X_12638_ cell3.SB0.route_sel\[103\] cell3.SB0.route_sel\[102\] net922 vssd1 vssd1
+ vccd1 vccd1 _01067_ sky130_fd_sc_hd__mux2_1
XTAP_TAPCELL_ROW_135_2339 vssd1 vccd1 sky130_fd_sc_hd__tapvpwrvgnd_1
XTAP_TAPCELL_ROW_135_2328 vssd1 vccd1 sky130_fd_sc_hd__tapvpwrvgnd_1
XANTENNA__09236__B1 _04262_ vssd1 vssd1 vccd1 vccd1 sky130_fd_sc_hd__diode_2
XANTENNA__10882__S _05758_ vssd1 vssd1 vccd1 vccd1 sky130_fd_sc_hd__diode_2
XANTENNA__10397__A2 _05131_ vssd1 vssd1 vccd1 vccd1 sky130_fd_sc_hd__diode_2
X_12569_ cell3.SB0.route_sel\[34\] cell3.SB0.route_sel\[33\] net911 vssd1 vssd1 vccd1
+ vccd1 _00998_ sky130_fd_sc_hd__mux2_1
XANTENNA__08860__B cell1.SB0.route_sel\[35\] vssd1 vssd1 vccd1 vccd1 sky130_fd_sc_hd__diode_2
Xhold217 cell2.LE_0B.config_data\[4\] vssd1 vssd1 vccd1 vccd1 net1176 sky130_fd_sc_hd__dlygate4sd3_1
Xhold206 cell3.LE_1B.config_data\[12\] vssd1 vssd1 vccd1 vccd1 net1165 sky130_fd_sc_hd__dlygate4sd3_1
X_14308_ clknet_leaf_11_clk _01280_ net588 vssd1 vssd1 vccd1 vccd1 cell2.SB0.route_sel\[93\]
+ sky130_fd_sc_hd__dfstp_2
Xhold239 cell2.LE_0A.config_data\[11\] vssd1 vssd1 vccd1 vccd1 net1198 sky130_fd_sc_hd__dlygate4sd3_1
X_14239_ clknet_leaf_20_clk _01211_ net611 vssd1 vssd1 vccd1 vccd1 cell2.SB0.route_sel\[24\]
+ sky130_fd_sc_hd__dfstp_1
Xhold228 cell0.LE_1A.config_data\[12\] vssd1 vssd1 vccd1 vccd1 net1187 sky130_fd_sc_hd__dlygate4sd3_1
XTAP_TAPCELL_ROW_59_1190 vssd1 vccd1 sky130_fd_sc_hd__tapvpwrvgnd_1
Xfanout719 net724 vssd1 vssd1 vccd1 vccd1 net719 sky130_fd_sc_hd__clkbuf_4
Xfanout708 net710 vssd1 vssd1 vccd1 vccd1 net708 sky130_fd_sc_hd__clkbuf_4
X_08800_ _03826_ _03827_ _03830_ _03831_ _01679_ vssd1 vssd1 vccd1 vccd1 _03832_ sky130_fd_sc_hd__a221o_1
X_09780_ net312 net308 cell2.LEI0.config_data\[18\] vssd1 vssd1 vccd1 vccd1 _04786_
+ sky130_fd_sc_hd__mux2_1
XFILLER_98_577 vssd1 vssd1 vccd1 vccd1 sky130_fd_sc_hd__fill_1
X_06992_ cell1.CB_0.config_dataA\[22\] cell1.CB_0.config_dataA\[23\] vssd1 vssd1 vccd1
+ vccd1 _02058_ sky130_fd_sc_hd__nand2b_1
XPHY_EDGE_ROW_7_Right_7 vssd1 vssd1 vccd1 vccd1 sky130_fd_sc_hd__decap_3
XTAP_TAPCELL_ROW_72_1390 vssd1 vccd1 sky130_fd_sc_hd__tapvpwrvgnd_1
X_08731_ net331 net326 net336 net323 cell1.LEI0.config_data\[33\] cell1.LEI0.config_data\[34\]
+ vssd1 vssd1 vccd1 vccd1 _03765_ sky130_fd_sc_hd__mux4_1
X_08662_ _01655_ _03690_ _03695_ _01657_ _03684_ vssd1 vssd1 vccd1 vccd1 _03696_ sky130_fd_sc_hd__o311a_1
XANTENNA__08100__B _02301_ vssd1 vssd1 vccd1 vccd1 sky130_fd_sc_hd__diode_2
X_07613_ net355 net353 bus1_0\[1\] vssd1 vssd1 vccd1 vccd1 _02662_ sky130_fd_sc_hd__o21ai_1
XFILLER_121_39 vccd1 vssd1 vccd1 vssd1 sky130_ef_sc_hd__decap_40_12
XFILLER_53_124 vssd1 vssd1 vccd1 vccd1 sky130_fd_sc_hd__fill_1
X_08593_ net29 net30 net489 vssd1 vssd1 vccd1 vccd1 _03629_ sky130_fd_sc_hd__mux2_1
XTAP_TAPCELL_ROW_37_856 vssd1 vccd1 sky130_fd_sc_hd__tapvpwrvgnd_1
XTAP_TAPCELL_ROW_37_867 vssd1 vccd1 sky130_fd_sc_hd__tapvpwrvgnd_1
X_07544_ net314 _02592_ vssd1 vssd1 vccd1 vccd1 _02595_ sky130_fd_sc_hd__and2_1
X_07475_ cell2.SB0.route_sel\[117\] cell2.SB0.route_sel\[116\] vssd1 vssd1 vccd1 vccd1
+ _02528_ sky130_fd_sc_hd__nand2_1
XFILLER_14_26 vssd1 vssd1 vccd1 vccd1 sky130_fd_sc_hd__fill_2
X_09214_ _02162_ _04173_ vssd1 vssd1 vccd1 vccd1 _04241_ sky130_fd_sc_hd__or2_1
X_06426_ cell1.SB0.route_sel\[3\] vssd1 vssd1 vccd1 vccd1 _01496_ sky130_fd_sc_hd__inv_2
XTAP_TAPCELL_ROW_79_1500 vssd1 vccd1 sky130_fd_sc_hd__tapvpwrvgnd_1
XANTENNA__10388__A2 _05113_ vssd1 vssd1 vccd1 vccd1 sky130_fd_sc_hd__diode_2
X_09145_ cell2.CB_1.config_dataA\[23\] cell2.CB_1.config_dataA\[22\] vssd1 vssd1 vccd1
+ vccd1 _04173_ sky130_fd_sc_hd__or2_1
X_09076_ _04105_ vssd1 vssd1 vccd1 vccd1 _04106_ sky130_fd_sc_hd__inv_2
XANTENNA__08262__S _03231_ vssd1 vssd1 vccd1 vccd1 sky130_fd_sc_hd__diode_2
X_08027_ _03067_ _03068_ cell0.CB_0.config_dataB\[2\] vssd1 vssd1 vccd1 vccd1 _03069_
+ sky130_fd_sc_hd__mux2_1
XANTENNA__08202__A1 bus1_0\[9\] vssd1 vssd1 vccd1 vccd1 sky130_fd_sc_hd__diode_2
XANTENNA__09950__A1 net305 vssd1 vssd1 vccd1 vccd1 sky130_fd_sc_hd__diode_2
X_09978_ net406 _04583_ _04981_ net405 vssd1 vssd1 vccd1 vccd1 _04982_ sky130_fd_sc_hd__o211a_1
XANTENNA__07961__A0 bus2_0\[12\] vssd1 vssd1 vccd1 vccd1 sky130_fd_sc_hd__diode_2
X_08929_ net467 _03844_ vssd1 vssd1 vccd1 vccd1 _03961_ sky130_fd_sc_hd__nand2_1
XANTENNA_fanout755_X net755 vssd1 vssd1 vccd1 vccd1 sky130_fd_sc_hd__diode_2
X_11940_ cell0.SB0.route_sel\[46\] cell0.SB0.route_sel\[45\] net757 vssd1 vssd1 vccd1
+ vccd1 _00377_ sky130_fd_sc_hd__mux2_1
XFILLER_29_154 vssd1 vssd1 vccd1 vccd1 sky130_fd_sc_hd__fill_2
XANTENNA__08505__A2 _03537_ vssd1 vssd1 vccd1 vccd1 sky130_fd_sc_hd__diode_2
XANTENNA__10312__A2 _05128_ vssd1 vssd1 vccd1 vccd1 sky130_fd_sc_hd__diode_2
XFILLER_85_783 vssd1 vssd1 vccd1 vccd1 sky130_fd_sc_hd__fill_1
XANTENNA__08785__X _03817_ vssd1 vssd1 vccd1 vccd1 sky130_fd_sc_hd__diode_2
X_11871_ cell1.CB_0.config_dataA\[2\] net472 net883 vssd1 vssd1 vccd1 vccd1 _00308_
+ sky130_fd_sc_hd__mux2_1
XFILLER_55_77 vssd1 vssd1 vccd1 vccd1 sky130_fd_sc_hd__fill_1
XANTENNA__08945__B _03881_ vssd1 vssd1 vccd1 vccd1 sky130_fd_sc_hd__diode_2
X_10822_ _05531_ _05761_ _05762_ _05528_ _01782_ vssd1 vssd1 vccd1 vccd1 _05778_ sky130_fd_sc_hd__a221o_1
X_13610_ clknet_leaf_95_clk net1324 net692 vssd1 vssd1 vccd1 vccd1 cell1.LEI0.config_data\[31\]
+ sky130_fd_sc_hd__dfrtp_1
XANTENNA__11273__A0 _05088_ vssd1 vssd1 vccd1 vccd1 sky130_fd_sc_hd__diode_2
X_10753_ net13 _05691_ _05693_ net14 cell3.CB_1.config_dataB\[3\] vssd1 vssd1 vccd1
+ vccd1 _05709_ sky130_fd_sc_hd__a221o_1
X_13541_ clknet_leaf_73_clk net1011 net728 vssd1 vssd1 vccd1 vccd1 cell1.LE_0B.config_data\[6\]
+ sky130_fd_sc_hd__dfrtp_1
XTAP_TAPCELL_ROW_15_528 vssd1 vccd1 sky130_fd_sc_hd__tapvpwrvgnd_1
XTAP_TAPCELL_ROW_15_539 vssd1 vccd1 sky130_fd_sc_hd__tapvpwrvgnd_1
XANTENNA__10615__A3 net25 vssd1 vssd1 vccd1 vccd1 sky130_fd_sc_hd__diode_2
XFILLER_40_330 vssd1 vssd1 vccd1 vccd1 sky130_fd_sc_hd__fill_1
X_10684_ net390 net391 vssd1 vssd1 vccd1 vccd1 _05642_ sky130_fd_sc_hd__nor2_1
X_13472_ clknet_leaf_2_clk _00444_ net561 vssd1 vssd1 vccd1 vccd1 cell0.SB0.route_sel\[113\]
+ sky130_fd_sc_hd__dfstp_2
XFILLER_9_559 vssd1 vssd1 vccd1 vccd1 sky130_fd_sc_hd__fill_1
XANTENNA_input96_A SBsouth_in[9] vssd1 vssd1 vccd1 vccd1 sky130_fd_sc_hd__diode_2
XFILLER_139_785 vccd1 vssd1 vccd1 vssd1 sky130_ef_sc_hd__decap_40_12
XFILLER_139_763 vccd1 vssd1 vccd1 vssd1 sky130_ef_sc_hd__decap_40_12
X_12423_ net1109 net1041 net925 vssd1 vssd1 vccd1 vccd1 _00855_ sky130_fd_sc_hd__mux2_1
XANTENNA__09769__B2 bus3_2\[4\] vssd1 vssd1 vccd1 vccd1 sky130_fd_sc_hd__diode_2
XANTENNA__09769__A1 bus3_2\[5\] vssd1 vssd1 vccd1 vccd1 sky130_fd_sc_hd__diode_2
XANTENNA__10555__X _05513_ vssd1 vssd1 vccd1 vccd1 sky130_fd_sc_hd__diode_2
XTAP_TAPCELL_ROW_117_2069 vssd1 vccd1 sky130_fd_sc_hd__tapvpwrvgnd_1
XTAP_TAPCELL_ROW_117_2058 vssd1 vccd1 sky130_fd_sc_hd__tapvpwrvgnd_1
XANTENNA__07244__A2 cell2.SB0.route_sel\[93\] vssd1 vssd1 vccd1 vccd1 sky130_fd_sc_hd__diode_2
XFILLER_5_721 vssd1 vssd1 vccd1 vccd1 sky130_fd_sc_hd__fill_4
X_12354_ cell1.SB0.route_sel\[92\] cell1.SB0.route_sel\[91\] net868 vssd1 vssd1 vccd1
+ vccd1 _00787_ sky130_fd_sc_hd__mux2_1
X_11305_ _04479_ _05478_ vssd1 vssd1 vccd1 vccd1 _06217_ sky130_fd_sc_hd__and2b_1
XANTENNA__08992__A2 bus3_1\[2\] vssd1 vssd1 vccd1 vccd1 sky130_fd_sc_hd__diode_2
XFILLER_5_765 vssd1 vssd1 vccd1 vccd1 sky130_fd_sc_hd__fill_2
XANTENNA_input51_X net51 vssd1 vssd1 vccd1 vccd1 sky130_fd_sc_hd__diode_2
XTAP_TAPCELL_ROW_130_2258 vssd1 vccd1 sky130_fd_sc_hd__tapvpwrvgnd_1
XFILLER_107_660 vssd1 vssd1 vccd1 vccd1 sky130_fd_sc_hd__fill_1
X_14024_ clknet_leaf_81_clk _00996_ net702 vssd1 vssd1 vccd1 vccd1 cell3.SB0.route_sel\[32\]
+ sky130_fd_sc_hd__dfstp_1
X_12285_ cell1.SB0.route_sel\[23\] cell1.SB0.route_sel\[22\] net864 vssd1 vssd1 vccd1
+ vccd1 _00718_ sky130_fd_sc_hd__mux2_1
XFILLER_4_253 vccd1 vssd1 vccd1 vssd1 sky130_ef_sc_hd__decap_40_12
X_11236_ _06186_ _06187_ _06107_ vssd1 vssd1 vccd1 vccd1 _06188_ sky130_fd_sc_hd__mux2_1
XANTENNA_output252_A net252 vssd1 vssd1 vccd1 vccd1 sky130_fd_sc_hd__diode_2
X_11167_ _06111_ _06117_ cell3.CB_0.config_dataB\[12\] vssd1 vssd1 vccd1 vccd1 _06119_
+ sky130_fd_sc_hd__mux2_1
XFILLER_96_51 vssd1 vssd1 vccd1 vccd1 sky130_fd_sc_hd__fill_1
XFILLER_95_503 vssd1 vssd1 vccd1 vccd1 sky130_fd_sc_hd__fill_1
XANTENNA__09941__A1 bus3_2\[14\] vssd1 vssd1 vccd1 vccd1 sky130_fd_sc_hd__diode_2
X_10118_ net63 net64 net34 net35 net419 cell2.CB_0.config_dataA\[6\] vssd1 vssd1 vccd1
+ vccd1 _05119_ sky130_fd_sc_hd__mux4_1
XTAP_TAPCELL_ROW_112_1991 vssd1 vccd1 sky130_fd_sc_hd__tapvpwrvgnd_1
X_11098_ net49 net50 net51 net52 net389 net388 vssd1 vssd1 vccd1 vccd1 _06050_ sky130_fd_sc_hd__mux4_1
XANTENNA__09154__C1 _02901_ vssd1 vssd1 vccd1 vccd1 sky130_fd_sc_hd__diode_2
X_10049_ net401 _04298_ _05052_ cell2.CB_1.config_dataB\[16\] vssd1 vssd1 vccd1 vccd1
+ _05053_ sky130_fd_sc_hd__o211a_1
XFILLER_91_731 vssd1 vssd1 vccd1 vccd1 sky130_fd_sc_hd__fill_1
XTAP_TAPCELL_ROW_34_815 vssd1 vccd1 sky130_fd_sc_hd__tapvpwrvgnd_1
X_13808_ clknet_leaf_112_clk _00780_ net661 vssd1 vssd1 vccd1 vccd1 cell1.SB0.route_sel\[85\]
+ sky130_fd_sc_hd__dfstp_1
Xclkbuf_0_cell0.LE_0B.sel_clk cell0.LE_0B.sel_clk vssd1 vssd1 vccd1 vccd1 clknet_0_cell0.LE_0B.sel_clk
+ sky130_fd_sc_hd__clkbuf_16
X_13739_ clknet_leaf_107_clk _00711_ net658 vssd1 vssd1 vccd1 vccd1 cell1.SB0.route_sel\[16\]
+ sky130_fd_sc_hd__dfstp_1
XANTENNA__10606__A3 _05521_ vssd1 vssd1 vccd1 vccd1 sky130_fd_sc_hd__diode_2
XFILLER_91_3 vccd1 vssd1 vccd1 vssd1 sky130_ef_sc_hd__decap_40_12
X_07260_ _02315_ _02317_ _02318_ vssd1 vssd1 vccd1 vccd1 _02319_ sky130_fd_sc_hd__a21o_1
XANTENNA__08680__B2 _03477_ vssd1 vssd1 vccd1 vccd1 sky130_fd_sc_hd__diode_2
XANTENNA__08680__A1 _03473_ vssd1 vssd1 vccd1 vccd1 sky130_fd_sc_hd__diode_2
XANTENNA__10465__X bus3_2\[12\] vssd1 vssd1 vccd1 vccd1 sky130_fd_sc_hd__diode_2
X_07191_ cell2.SB0.route_sel\[80\] cell2.SB0.route_sel\[81\] _02251_ vssd1 vssd1 vccd1
+ vccd1 _02252_ sky130_fd_sc_hd__a21o_1
XFILLER_117_413 vssd1 vssd1 vccd1 vccd1 sky130_fd_sc_hd__fill_1
XANTENNA_clkbuf_leaf_83_clk_A clknet_4_9_0_clk vssd1 vssd1 vccd1 vccd1 sky130_fd_sc_hd__diode_2
X_09901_ _01753_ _04906_ _04905_ cell2.LEI0.config_data\[44\] vssd1 vssd1 vccd1 vccd1
+ _04907_ sky130_fd_sc_hd__a211oi_2
XANTENNA_clkbuf_leaf_98_clk_A clknet_4_10_0_clk vssd1 vssd1 vccd1 vccd1 sky130_fd_sc_hd__diode_2
Xfanout505 cell0.CB_1.config_dataB\[6\] vssd1 vssd1 vccd1 vccd1 net505 sky130_fd_sc_hd__buf_2
XANTENNA__08196__A0 _02350_ vssd1 vssd1 vccd1 vccd1 sky130_fd_sc_hd__diode_2
X_09832_ _04641_ _04837_ cell2.CB_1.config_dataA\[12\] vssd1 vssd1 vccd1 vccd1 _04838_
+ sky130_fd_sc_hd__o21ai_1
XFILLER_86_503 vssd1 vssd1 vccd1 vccd1 sky130_fd_sc_hd__fill_8
Xfanout516 cell0.CB_0.config_dataA\[10\] vssd1 vssd1 vccd1 vccd1 net516 sky130_fd_sc_hd__clkbuf_2
Xfanout527 net528 vssd1 vssd1 vccd1 vccd1 net527 sky130_fd_sc_hd__buf_2
Xfanout538 cell0.CB_1.config_dataA\[11\] vssd1 vssd1 vccd1 vccd1 net538 sky130_fd_sc_hd__buf_2
Xfanout549 net550 vssd1 vssd1 vccd1 vccd1 net549 sky130_fd_sc_hd__clkbuf_4
X_09763_ _04761_ _04764_ _04768_ cell2.CB_1.config_dataA\[8\] vssd1 vssd1 vccd1 vccd1
+ _04769_ sky130_fd_sc_hd__or4b_1
XFILLER_132_27 vssd1 vssd1 vccd1 vccd1 sky130_fd_sc_hd__fill_1
XANTENNA_clkbuf_leaf_21_clk_A clknet_4_4_0_clk vssd1 vssd1 vccd1 vccd1 sky130_fd_sc_hd__diode_2
X_06975_ _02016_ _02037_ _02039_ vssd1 vssd1 vccd1 vccd1 _02041_ sky130_fd_sc_hd__or3_1
X_08714_ _03540_ _03737_ _03738_ _03537_ vssd1 vssd1 vccd1 vccd1 _03748_ sky130_fd_sc_hd__a22o_1
XANTENNA__11098__A3 net52 vssd1 vssd1 vccd1 vccd1 sky130_fd_sc_hd__diode_2
X_09694_ net56 _04707_ vssd1 vssd1 vccd1 vccd1 _04708_ sky130_fd_sc_hd__or2_1
XFILLER_82_753 vssd1 vssd1 vccd1 vccd1 sky130_fd_sc_hd__fill_1
X_08645_ net458 _03509_ vssd1 vssd1 vccd1 vccd1 _03679_ sky130_fd_sc_hd__nand2_1
XFILLER_27_669 vssd1 vssd1 vccd1 vccd1 sky130_fd_sc_hd__fill_1
XANTENNA_fanout548_A net550 vssd1 vssd1 vccd1 vccd1 sky130_fd_sc_hd__diode_2
X_08576_ _03611_ _03607_ cell1.CB_1.config_dataA\[13\] vssd1 vssd1 vccd1 vccd1 _03612_
+ sky130_fd_sc_hd__or3b_1
XANTENNA_clkbuf_leaf_36_clk_A clknet_4_7_0_clk vssd1 vssd1 vccd1 vccd1 sky130_fd_sc_hd__diode_2
XANTENNA__06566__A cell2.SB0.route_sel\[93\] vssd1 vssd1 vccd1 vccd1 sky130_fd_sc_hd__diode_2
XTAP_TAPCELL_ROW_85_1581 vssd1 vccd1 sky130_fd_sc_hd__tapvpwrvgnd_1
X_07527_ cell1.SB0.route_sel\[121\] cell1.SB0.route_sel\[120\] _02572_ _02578_ net874
+ vssd1 vssd1 vccd1 vccd1 _02579_ sky130_fd_sc_hd__a311oi_4
XANTENNA_fanout336_X net336 vssd1 vssd1 vccd1 vccd1 sky130_fd_sc_hd__diode_2
X_07458_ _01831_ _01888_ _02367_ _02508_ vssd1 vssd1 vccd1 vccd1 _02512_ sky130_fd_sc_hd__o31a_1
XFILLER_22_363 vssd1 vssd1 vccd1 vccd1 sky130_fd_sc_hd__fill_1
X_06409_ cell0.SB0.route_sel\[105\] vssd1 vssd1 vccd1 vccd1 _01479_ sky130_fd_sc_hd__inv_2
X_07389_ cell1.SB0.route_sel\[105\] cell1.SB0.route_sel\[104\] vssd1 vssd1 vccd1 vccd1
+ _02445_ sky130_fd_sc_hd__nor2_1
XFILLER_10_558 vssd1 vssd1 vccd1 vccd1 sky130_fd_sc_hd__fill_1
XANTENNA__07668__Y _02716_ vssd1 vssd1 vccd1 vccd1 sky130_fd_sc_hd__diode_2
X_09128_ net331 net326 net336 net323 cell1.LEI0.config_data\[39\] cell1.LEI0.config_data\[40\]
+ vssd1 vssd1 vccd1 vccd1 _04158_ sky130_fd_sc_hd__mux4_1
XANTENNA__09620__B1 cell3.SB0.route_sel\[101\] vssd1 vssd1 vccd1 vccd1 sky130_fd_sc_hd__diode_2
X_09059_ net479 _03841_ _04088_ net478 vssd1 vssd1 vccd1 vccd1 _04089_ sky130_fd_sc_hd__o211a_1
XFILLER_2_713 vccd1 vssd1 vccd1 vssd1 sky130_ef_sc_hd__decap_40_12
Xhold570 cell2.LEI0.config_data\[35\] vssd1 vssd1 vccd1 vccd1 net1529 sky130_fd_sc_hd__dlygate4sd3_1
Xhold581 cell0.LEI0.config_data\[5\] vssd1 vssd1 vccd1 vccd1 net1540 sky130_fd_sc_hd__dlygate4sd3_1
X_12070_ net550 _03666_ vssd1 vssd1 vccd1 vccd1 _06378_ sky130_fd_sc_hd__nor2_1
XFILLER_2_757 vccd1 vssd1 vccd1 vssd1 sky130_ef_sc_hd__decap_40_12
XFILLER_1_223 vssd1 vssd1 vccd1 vccd1 sky130_fd_sc_hd__fill_1
X_11021_ _05967_ _05970_ _05974_ cell3.CB_0.config_dataA\[13\] vssd1 vssd1 vccd1 vccd1
+ _05975_ sky130_fd_sc_hd__and4bb_1
XANTENNA_clkbuf_leaf_109_clk_A clknet_4_8_0_clk vssd1 vssd1 vccd1 vccd1 sky130_fd_sc_hd__diode_2
Xhold592 cell1.LE_1B.config_data\[8\] vssd1 vssd1 vccd1 vccd1 net1551 sky130_fd_sc_hd__dlygate4sd3_1
XFILLER_2_29 vccd1 vssd1 vccd1 vssd1 sky130_ef_sc_hd__decap_40_12
X_12972_ cell3.LE_0A.config_data\[15\] net1306 net928 vssd1 vssd1 vccd1 vccd1 _01400_
+ sky130_fd_sc_hd__mux2_1
XFILLER_18_625 vssd1 vssd1 vccd1 vccd1 sky130_fd_sc_hd__fill_2
XFILLER_18_636 vssd1 vssd1 vccd1 vccd1 sky130_fd_sc_hd__fill_8
XANTENNA_input11_A CBeast_in[19] vssd1 vssd1 vccd1 vccd1 sky130_fd_sc_hd__diode_2
XFILLER_45_422 vssd1 vssd1 vccd1 vccd1 sky130_fd_sc_hd__fill_1
X_11923_ cell0.SB0.route_sel\[29\] cell0.SB0.route_sel\[28\] net760 vssd1 vssd1 vccd1
+ vccd1 _00360_ sky130_fd_sc_hd__mux2_1
XFILLER_17_146 vssd1 vssd1 vccd1 vccd1 sky130_fd_sc_hd__fill_1
XFILLER_18_647 vssd1 vssd1 vccd1 vccd1 sky130_fd_sc_hd__fill_2
X_11854_ net480 cell1.CB_0.config_dataB\[9\] net897 vssd1 vssd1 vccd1 vccd1 _00291_
+ sky130_fd_sc_hd__mux2_1
X_10805_ net366 net367 vssd1 vssd1 vccd1 vccd1 _05761_ sky130_fd_sc_hd__and2b_2
XFILLER_45_499 vssd1 vssd1 vccd1 vccd1 sky130_fd_sc_hd__fill_1
X_11785_ net1445 net1419 net793 vssd1 vssd1 vccd1 vccd1 _00222_ sky130_fd_sc_hd__mux2_1
X_10736_ net371 net370 vssd1 vssd1 vccd1 vccd1 _05692_ sky130_fd_sc_hd__or2_1
X_13524_ clknet_leaf_100_clk net1052 net679 vssd1 vssd1 vccd1 vccd1 cell1.LE_1A.config_data\[11\]
+ sky130_fd_sc_hd__dfrtp_1
XANTENNA_input99_X net99 vssd1 vssd1 vccd1 vccd1 sky130_fd_sc_hd__diode_2
X_10667_ _04354_ _04362_ _04370_ _05503_ _01791_ vssd1 vssd1 vccd1 vccd1 _05625_ sky130_fd_sc_hd__a2111o_1
X_13455_ clknet_leaf_123_clk _00427_ net579 vssd1 vssd1 vccd1 vccd1 cell0.SB0.route_sel\[96\]
+ sky130_fd_sc_hd__dfstp_2
X_12406_ net399 net400 net832 vssd1 vssd1 vccd1 vccd1 _00839_ sky130_fd_sc_hd__mux2_1
XANTENNA__10221__A1 net60 vssd1 vssd1 vccd1 vccd1 sky130_fd_sc_hd__diode_2
X_10598_ _05546_ _05550_ _05555_ _05537_ vssd1 vssd1 vccd1 vccd1 _05556_ sky130_fd_sc_hd__a31o_1
X_13386_ clknet_leaf_133_clk _00358_ net556 vssd1 vssd1 vccd1 vccd1 cell0.SB0.route_sel\[27\]
+ sky130_fd_sc_hd__dfstp_2
XANTENNA__10221__B2 net59 vssd1 vssd1 vccd1 vccd1 sky130_fd_sc_hd__diode_2
XFILLER_5_573 vssd1 vssd1 vccd1 vccd1 sky130_fd_sc_hd__fill_4
X_12337_ cell1.SB0.route_sel\[75\] cell1.SB0.route_sel\[74\] net868 vssd1 vssd1 vccd1
+ vccd1 _00770_ sky130_fd_sc_hd__mux2_1
X_12268_ cell1.SB0.route_sel\[6\] cell1.SB0.route_sel\[5\] net866 vssd1 vssd1 vccd1
+ vccd1 _00701_ sky130_fd_sc_hd__mux2_1
X_11219_ cell3.CB_0.config_dataB\[18\] cell3.CB_0.config_dataB\[17\] cell3.CB_0.config_dataB\[19\]
+ vssd1 vssd1 vccd1 vccd1 _06171_ sky130_fd_sc_hd__or3b_1
X_14007_ clknet_leaf_79_clk _00979_ net709 vssd1 vssd1 vccd1 vccd1 cell3.SB0.route_sel\[15\]
+ sky130_fd_sc_hd__dfstp_1
X_12199_ cell2.CB_1.config_dataA\[12\] net440 net913 vssd1 vssd1 vccd1 vccd1 _00632_
+ sky130_fd_sc_hd__mux2_1
XFILLER_95_377 vssd1 vssd1 vccd1 vccd1 sky130_fd_sc_hd__fill_1
X_06760_ cell0.CB_1.le_outB vssd1 vssd1 vccd1 vccd1 _01830_ sky130_fd_sc_hd__inv_2
XANTENNA__10288__A1 _05156_ vssd1 vssd1 vccd1 vccd1 sky130_fd_sc_hd__diode_2
XANTENNA__10288__B2 _05152_ vssd1 vssd1 vccd1 vccd1 sky130_fd_sc_hd__diode_2
X_06691_ cell2.CB_0.config_dataB\[17\] vssd1 vssd1 vccd1 vccd1 _01761_ sky130_fd_sc_hd__inv_2
XANTENNA__08350__A0 bus1_0\[8\] vssd1 vssd1 vccd1 vccd1 sky130_fd_sc_hd__diode_2
X_08430_ cell1.SB0.route_sel\[88\] cell1.SB0.route_sel\[89\] vssd1 vssd1 vccd1 vccd1
+ _03466_ sky130_fd_sc_hd__nand2b_1
XFILLER_36_466 vssd1 vssd1 vccd1 vccd1 sky130_fd_sc_hd__fill_1
XANTENNA__08102__A0 bus2_0\[8\] vssd1 vssd1 vccd1 vccd1 sky130_fd_sc_hd__diode_2
X_08361_ _02846_ _03384_ _03386_ _02807_ vssd1 vssd1 vccd1 vccd1 _03399_ sky130_fd_sc_hd__a22o_1
X_07312_ net325 _02368_ _02366_ vssd1 vssd1 vccd1 vccd1 _02370_ sky130_fd_sc_hd__o21a_1
XANTENNA__08653__A1 _03473_ vssd1 vssd1 vccd1 vccd1 sky130_fd_sc_hd__diode_2
X_08292_ _02678_ _03315_ _03316_ _02633_ cell0.CB_1.config_dataB\[7\] vssd1 vssd1
+ vccd1 vccd1 _03330_ sky130_fd_sc_hd__a221o_1
XANTENNA__08653__B2 _03477_ vssd1 vssd1 vccd1 vccd1 sky130_fd_sc_hd__diode_2
XANTENNA__10907__Y _05861_ vssd1 vssd1 vccd1 vccd1 sky130_fd_sc_hd__diode_2
X_07243_ _02298_ _02299_ _02300_ _02274_ _02270_ vssd1 vssd1 vccd1 vccd1 _02302_ sky130_fd_sc_hd__a311o_1
XANTENNA__11231__S _06076_ vssd1 vssd1 vccd1 vccd1 sky130_fd_sc_hd__diode_2
XANTENNA__10212__A1 _05152_ vssd1 vssd1 vccd1 vccd1 sky130_fd_sc_hd__diode_2
X_07174_ _02208_ _02234_ vssd1 vssd1 vccd1 vccd1 _02235_ sky130_fd_sc_hd__and2_2
XFILLER_11_27 vccd1 vssd1 vccd1 vssd1 sky130_ef_sc_hd__decap_40_12
XFILLER_127_27 vccd1 vssd1 vccd1 vssd1 sky130_ef_sc_hd__decap_40_12
XANTENNA__10212__B2 _05156_ vssd1 vssd1 vccd1 vccd1 sky130_fd_sc_hd__diode_2
XANTENNA__08956__A2 _03841_ vssd1 vssd1 vccd1 vccd1 sky130_fd_sc_hd__diode_2
XANTENNA__10763__A2 net298 vssd1 vssd1 vccd1 vccd1 sky130_fd_sc_hd__diode_2
Xfanout313 cell2.CB_0.le_outA vssd1 vssd1 vccd1 vccd1 net313 sky130_fd_sc_hd__clkbuf_2
Xfanout302 _01833_ vssd1 vssd1 vccd1 vccd1 net302 sky130_fd_sc_hd__buf_2
X_09815_ _04399_ _04794_ cell2.CB_1.config_dataA\[2\] vssd1 vssd1 vccd1 vccd1 _04821_
+ sky130_fd_sc_hd__o21ai_1
XANTENNA_input3_A CBeast_in[11] vssd1 vssd1 vccd1 vccd1 sky130_fd_sc_hd__diode_2
XFILLER_86_300 vssd1 vssd1 vccd1 vccd1 sky130_fd_sc_hd__fill_1
XANTENNA__07916__A0 bus2_0\[6\] vssd1 vssd1 vccd1 vccd1 sky130_fd_sc_hd__diode_2
Xfanout324 cell1.CB_1.le_outB vssd1 vssd1 vccd1 vccd1 net324 sky130_fd_sc_hd__dlymetal6s2s_1
Xfanout346 _01828_ vssd1 vssd1 vccd1 vccd1 net346 sky130_fd_sc_hd__buf_2
Xfanout335 net337 vssd1 vssd1 vccd1 vccd1 net335 sky130_fd_sc_hd__buf_2
Xfanout357 _02015_ vssd1 vssd1 vccd1 vccd1 net357 sky130_fd_sc_hd__buf_2
XANTENNA_fanout286_X net286 vssd1 vssd1 vccd1 vccd1 sky130_fd_sc_hd__diode_2
Xfanout379 cell3.CB_0.config_dataA\[0\] vssd1 vssd1 vccd1 vccd1 net379 sky130_fd_sc_hd__buf_2
Xfanout368 cell3.CB_1.config_dataB\[6\] vssd1 vssd1 vccd1 vccd1 net368 sky130_fd_sc_hd__clkbuf_2
XFILLER_100_132 vssd1 vssd1 vccd1 vccd1 sky130_fd_sc_hd__fill_1
XFILLER_100_121 vssd1 vssd1 vccd1 vccd1 sky130_fd_sc_hd__fill_2
XFILLER_74_506 vccd1 vssd1 vccd1 vssd1 sky130_ef_sc_hd__decap_40_12
XFILLER_59_569 vssd1 vssd1 vccd1 vccd1 sky130_fd_sc_hd__fill_1
X_09746_ cell2.SB0.route_sel\[43\] _01607_ vssd1 vssd1 vccd1 vccd1 _04753_ sky130_fd_sc_hd__nand2_1
XTAP_TAPCELL_ROW_87_1610 vssd1 vccd1 sky130_fd_sc_hd__tapvpwrvgnd_1
XFILLER_27_400 vssd1 vssd1 vccd1 vccd1 sky130_fd_sc_hd__fill_1
X_06958_ cell0.SB0.route_sel\[69\] cell0.SB0.route_sel\[68\] net127 _02022_ _02021_
+ vssd1 vssd1 vccd1 vccd1 _02024_ sky130_fd_sc_hd__a41o_1
X_09677_ _03814_ _03815_ _03816_ _02515_ _02510_ vssd1 vssd1 vccd1 vccd1 _04691_ sky130_fd_sc_hd__a311o_1
XANTENNA__07144__A1 bus2_0\[10\] vssd1 vssd1 vccd1 vccd1 sky130_fd_sc_hd__diode_2
X_08628_ _03662_ _03663_ _03583_ vssd1 vssd1 vccd1 vccd1 _03664_ sky130_fd_sc_hd__mux2_1
X_06889_ net360 _01933_ _01953_ _01955_ vssd1 vssd1 vccd1 vccd1 _01957_ sky130_fd_sc_hd__o211a_1
XFILLER_82_583 vssd1 vssd1 vccd1 vccd1 sky130_fd_sc_hd__fill_2
XANTENNA__08892__A1 bus3_1\[7\] vssd1 vssd1 vccd1 vccd1 sky130_fd_sc_hd__diode_2
XFILLER_27_499 vssd1 vssd1 vccd1 vccd1 sky130_fd_sc_hd__fill_1
X_08559_ _03594_ vssd1 vssd1 vccd1 vccd1 _03595_ sky130_fd_sc_hd__inv_2
X_11570_ net1143 net1164 net799 vssd1 vssd1 vccd1 vccd1 _00011_ sky130_fd_sc_hd__mux2_1
XTAP_TAPCELL_ROW_25_678 vssd1 vccd1 sky130_fd_sc_hd__tapvpwrvgnd_1
XTAP_TAPCELL_ROW_25_689 vssd1 vccd1 sky130_fd_sc_hd__tapvpwrvgnd_1
XFILLER_139_3 vccd1 vssd1 vccd1 vssd1 sky130_ef_sc_hd__decap_40_12
X_10521_ _05475_ _05478_ _01788_ vssd1 vssd1 vccd1 vccd1 _05479_ sky130_fd_sc_hd__mux2_1
X_13240_ clknet_leaf_11_clk net1451 net585 vssd1 vssd1 vccd1 vccd1 cell0.LEI0.config_data\[25\]
+ sky130_fd_sc_hd__dfrtp_1
XTAP_TAPCELL_ROW_114_2017 vssd1 vccd1 sky130_fd_sc_hd__tapvpwrvgnd_1
XTAP_TAPCELL_ROW_98_1783 vssd1 vccd1 sky130_fd_sc_hd__tapvpwrvgnd_1
XTAP_TAPCELL_ROW_98_1772 vssd1 vccd1 sky130_fd_sc_hd__tapvpwrvgnd_1
X_10452_ _01718_ cell3.SB0.route_sel\[66\] cell3.SB0.route_sel\[69\] _01722_ _05441_
+ vssd1 vssd1 vccd1 vccd1 _05442_ sky130_fd_sc_hd__a221o_1
X_10383_ _05345_ _05381_ _05309_ vssd1 vssd1 vccd1 vccd1 _05382_ sky130_fd_sc_hd__mux2_1
X_13171_ clknet_leaf_118_clk _00143_ net597 vssd1 vssd1 vccd1 vccd1 cell0.LE_0B.config_data\[0\]
+ sky130_fd_sc_hd__dfrtp_1
XANTENNA_input59_A CBnorth_in[4] vssd1 vssd1 vccd1 vccd1 sky130_fd_sc_hd__diode_2
X_12122_ cell1.LEI0.config_data\[4\] cell1.LEI0.config_data\[3\] net896 vssd1 vssd1
+ vccd1 vccd1 _00555_ sky130_fd_sc_hd__mux2_1
XFILLER_111_408 vssd1 vssd1 vccd1 vccd1 sky130_fd_sc_hd__fill_1
XANTENNA__10552__Y _05510_ vssd1 vssd1 vccd1 vccd1 sky130_fd_sc_hd__diode_2
X_12053_ net1049 net1001 net889 vssd1 vssd1 vccd1 vccd1 _00489_ sky130_fd_sc_hd__mux2_1
X_11004_ _05956_ _05957_ _05948_ _05954_ vssd1 vssd1 vccd1 vccd1 _05958_ sky130_fd_sc_hd__o211a_1
XFILLER_89_171 vssd1 vssd1 vccd1 vccd1 sky130_fd_sc_hd__fill_1
XFILLER_77_322 vssd1 vssd1 vccd1 vccd1 sky130_fd_sc_hd__fill_2
XFILLER_77_300 vssd1 vssd1 vccd1 vccd1 sky130_fd_sc_hd__fill_1
XFILLER_2_587 vssd1 vssd1 vccd1 vccd1 sky130_fd_sc_hd__fill_1
Xfanout880 net884 vssd1 vssd1 vccd1 vccd1 net880 sky130_fd_sc_hd__clkbuf_2
XANTENNA__07861__Y _02905_ vssd1 vssd1 vccd1 vccd1 sky130_fd_sc_hd__diode_2
XTAP_TAPCELL_ROW_5_381 vssd1 vccd1 sky130_fd_sc_hd__tapvpwrvgnd_1
Xfanout891 net908 vssd1 vssd1 vccd1 vccd1 net891 sky130_fd_sc_hd__buf_2
XANTENNA_input14_X net14 vssd1 vssd1 vccd1 vccd1 sky130_fd_sc_hd__diode_2
X_12955_ net1493 net550 _06385_ vssd1 vssd1 vccd1 vccd1 _01383_ sky130_fd_sc_hd__a21bo_1
XFILLER_92_347 vssd1 vssd1 vccd1 vccd1 sky130_fd_sc_hd__fill_1
XANTENNA__09124__A2 _03841_ vssd1 vssd1 vccd1 vccd1 sky130_fd_sc_hd__diode_2
XTAP_TAPCELL_ROW_142_2460 vssd1 vccd1 sky130_fd_sc_hd__tapvpwrvgnd_1
XTAP_TAPCELL_ROW_125_2179 vssd1 vccd1 sky130_fd_sc_hd__tapvpwrvgnd_1
XFILLER_73_561 vssd1 vssd1 vccd1 vccd1 sky130_fd_sc_hd__fill_2
X_11906_ cell0.SB0.route_sel\[12\] cell0.SB0.route_sel\[11\] net781 vssd1 vssd1 vccd1
+ vccd1 _00343_ sky130_fd_sc_hd__mux2_1
XANTENNA_output215_A net215 vssd1 vssd1 vccd1 vccd1 sky130_fd_sc_hd__diode_2
XFILLER_18_477 vssd1 vssd1 vccd1 vccd1 sky130_fd_sc_hd__fill_2
XANTENNA__08332__A0 bus1_0\[8\] vssd1 vssd1 vccd1 vccd1 sky130_fd_sc_hd__diode_2
X_12886_ cell3.CB_1.config_dataB\[0\] cell3.CB_1.config_dataA\[24\] net940 vssd1 vssd1
+ vccd1 vccd1 _01315_ sky130_fd_sc_hd__mux2_1
XANTENNA__08883__B2 _03830_ vssd1 vssd1 vccd1 vccd1 sky130_fd_sc_hd__diode_2
XANTENNA__08883__A1 _03826_ vssd1 vssd1 vccd1 vccd1 sky130_fd_sc_hd__diode_2
XANTENNA__08973__X _04005_ vssd1 vssd1 vccd1 vccd1 sky130_fd_sc_hd__diode_2
XANTENNA__10690__A1 net18 vssd1 vssd1 vccd1 vccd1 sky130_fd_sc_hd__diode_2
XTAP_TAPCELL_ROW_44_965 vssd1 vccd1 sky130_fd_sc_hd__tapvpwrvgnd_1
X_11837_ cell1.CB_1.config_dataA\[18\] cell1.CB_1.config_dataA\[17\] net889 vssd1
+ vssd1 vccd1 vccd1 _00274_ sky130_fd_sc_hd__mux2_1
X_11768_ cell0.LEI0.config_data\[18\] net1066 net775 vssd1 vssd1 vccd1 vccd1 _00205_
+ sky130_fd_sc_hd__mux2_1
XANTENNA__08635__A1 net458 vssd1 vssd1 vccd1 vccd1 sky130_fd_sc_hd__diode_2
X_10719_ _05562_ _05674_ _05637_ vssd1 vssd1 vccd1 vccd1 _05677_ sky130_fd_sc_hd__o21ai_1
X_13507_ clknet_leaf_104_clk _00479_ net678 vssd1 vssd1 vccd1 vccd1 cell1.CB_1.config_dataB\[20\]
+ sky130_fd_sc_hd__dfstp_1
X_11699_ net1548 cell0.LE_1A.edge_mode net804 vssd1 vssd1 vccd1 vccd1 _00139_ sky130_fd_sc_hd__mux2_1
XFILLER_9_186 vssd1 vssd1 vccd1 vccd1 sky130_fd_sc_hd__fill_1
X_13438_ clknet_leaf_129_clk _00410_ net578 vssd1 vssd1 vccd1 vccd1 cell0.SB0.route_sel\[79\]
+ sky130_fd_sc_hd__dfstp_1
XFILLER_54_3 vssd1 vssd1 vccd1 vccd1 sky130_fd_sc_hd__fill_1
XANTENNA__11986__S net787 vssd1 vssd1 vccd1 vccd1 sky130_fd_sc_hd__diode_2
X_13369_ clknet_leaf_132_clk _00341_ net558 vssd1 vssd1 vccd1 vccd1 cell0.SB0.route_sel\[10\]
+ sky130_fd_sc_hd__dfstp_1
XFILLER_102_408 vssd1 vssd1 vccd1 vccd1 sky130_fd_sc_hd__fill_1
XFILLER_69_812 vssd1 vssd1 vccd1 vccd1 sky130_fd_sc_hd__fill_1
X_07930_ _02972_ _02973_ cell0.CB_0.config_dataA\[12\] vssd1 vssd1 vccd1 vccd1 _02974_
+ sky130_fd_sc_hd__mux2_1
XTAP_TAPCELL_ROW_54_1119 vssd1 vccd1 sky130_fd_sc_hd__tapvpwrvgnd_1
XFILLER_123_791 vssd1 vssd1 vccd1 vccd1 sky130_fd_sc_hd__fill_1
X_07861_ _02675_ _02904_ vssd1 vssd1 vccd1 vccd1 _02905_ sky130_fd_sc_hd__nor2_4
X_09600_ _04612_ _04615_ _04616_ vssd1 vssd1 vccd1 vccd1 _04617_ sky130_fd_sc_hd__a21o_1
X_07792_ net359 net354 bus2_0\[5\] vssd1 vssd1 vccd1 vccd1 _02837_ sky130_fd_sc_hd__o21a_1
X_06812_ net79 _01879_ _01845_ vssd1 vssd1 vccd1 vccd1 _01882_ sky130_fd_sc_hd__a21oi_1
X_06743_ cell3.LE_0A.config_data\[16\] vssd1 vssd1 vccd1 vccd1 _01813_ sky130_fd_sc_hd__inv_2
X_09531_ cell3.SB0.route_sel\[70\] cell3.SB0.route_sel\[71\] vssd1 vssd1 vccd1 vccd1
+ _04551_ sky130_fd_sc_hd__nor2_1
XTAP_TAPCELL_ROW_69_1340 vssd1 vccd1 sky130_fd_sc_hd__tapvpwrvgnd_1
XFILLER_52_701 vssd1 vssd1 vccd1 vccd1 sky130_fd_sc_hd__fill_1
XANTENNA__13946__RESET_B net635 vssd1 vssd1 vccd1 vccd1 sky130_fd_sc_hd__diode_2
X_09462_ _04482_ _04483_ cell3.SB0.route_sel\[48\] cell3.SB0.route_sel\[49\] vssd1
+ vssd1 vccd1 vccd1 _04484_ sky130_fd_sc_hd__o211a_1
X_06674_ cell3.SB0.route_sel\[113\] vssd1 vssd1 vccd1 vccd1 _01744_ sky130_fd_sc_hd__inv_2
X_09393_ _04416_ net281 _04415_ vssd1 vssd1 vccd1 vccd1 _04417_ sky130_fd_sc_hd__mux2_1
XFILLER_91_391 vssd1 vssd1 vccd1 vccd1 sky130_fd_sc_hd__fill_1
XTAP_TAPCELL_ROW_82_1540 vssd1 vccd1 sky130_fd_sc_hd__tapvpwrvgnd_1
X_08413_ cell0.LE_1B.config_data\[1\] cell0.LE_1B.config_data\[0\] _03380_ vssd1 vssd1
+ vccd1 vccd1 _03451_ sky130_fd_sc_hd__mux2_1
X_08344_ net503 _02494_ net502 vssd1 vssd1 vccd1 vccd1 _03382_ sky130_fd_sc_hd__o21ai_1
XFILLER_11_119 vssd1 vssd1 vccd1 vccd1 sky130_fd_sc_hd__fill_1
XANTENNA__06844__A _01874_ vssd1 vssd1 vccd1 vccd1 sky130_fd_sc_hd__diode_2
XTAP_TAPCELL_ROW_22_637 vssd1 vccd1 sky130_fd_sc_hd__tapvpwrvgnd_1
XFILLER_138_839 vssd1 vssd1 vccd1 vccd1 sky130_fd_sc_hd__fill_1
XANTENNA__10366__A _05111_ vssd1 vssd1 vccd1 vccd1 sky130_fd_sc_hd__diode_2
XANTENNA__10984__A2 net51 vssd1 vssd1 vccd1 vccd1 sky130_fd_sc_hd__diode_2
X_08275_ net506 _02211_ net505 vssd1 vssd1 vccd1 vccd1 _03313_ sky130_fd_sc_hd__o21ai_1
X_07226_ _02285_ net335 _02284_ vssd1 vssd1 vccd1 vccd1 _02286_ sky130_fd_sc_hd__mux2_1
XFILLER_4_819 vssd1 vssd1 vccd1 vccd1 sky130_fd_sc_hd__fill_1
X_07157_ net322 _01837_ _02047_ _02051_ _01841_ vssd1 vssd1 vccd1 vccd1 _02219_ sky130_fd_sc_hd__o32a_1
XANTENNA__08270__S _03263_ vssd1 vssd1 vccd1 vccd1 sky130_fd_sc_hd__diode_2
XFILLER_3_329 vssd1 vssd1 vccd1 vccd1 sky130_fd_sc_hd__fill_4
XFILLER_133_555 vssd1 vssd1 vccd1 vccd1 sky130_fd_sc_hd__fill_1
X_07088_ _02058_ _02151_ vssd1 vssd1 vccd1 vccd1 _02152_ sky130_fd_sc_hd__or2_2
XFILLER_105_279 vssd1 vssd1 vccd1 vccd1 sky130_fd_sc_hd__fill_1
XANTENNA_input6_X net6 vssd1 vssd1 vccd1 vccd1 sky130_fd_sc_hd__diode_2
XFILLER_86_141 vssd1 vssd1 vccd1 vccd1 sky130_fd_sc_hd__fill_2
XFILLER_59_388 vssd1 vssd1 vccd1 vccd1 sky130_fd_sc_hd__fill_4
X_09729_ _01748_ cell3.SB0.route_sel\[122\] net262 cell3.SB0.route_sel\[126\] _04741_
+ vssd1 vssd1 vccd1 vccd1 _04742_ sky130_fd_sc_hd__o221a_1
XTAP_TAPCELL_ROW_2_340 vssd1 vccd1 sky130_fd_sc_hd__tapvpwrvgnd_1
X_12740_ cell3.CB_0.config_dataA\[7\] net376 net925 vssd1 vssd1 vccd1 vccd1 _01169_
+ sky130_fd_sc_hd__mux2_1
XFILLER_63_33 vssd1 vssd1 vccd1 vccd1 sky130_fd_sc_hd__fill_1
XANTENNA_input113_A SBwest_in[24] vssd1 vssd1 vccd1 vccd1 sky130_fd_sc_hd__diode_2
X_12671_ net1181 cell3.LE_1B.config_data\[7\] net954 vssd1 vssd1 vccd1 vccd1 _01100_
+ sky130_fd_sc_hd__mux2_1
X_14410_ clknet_leaf_62_clk _01382_ net747 vssd1 vssd1 vccd1 vccd1 cell3.LE_0B.reset_mode
+ sky130_fd_sc_hd__dfrtp_1
X_11622_ cell0.CB_0.config_dataB\[18\] cell0.CB_0.config_dataB\[17\] net774 vssd1
+ vssd1 vccd1 vccd1 _00063_ sky130_fd_sc_hd__mux2_1
XTAP_TAPCELL_ROW_41_924 vssd1 vccd1 sky130_fd_sc_hd__tapvpwrvgnd_1
X_14341_ clknet_leaf_18_clk _01313_ net627 vssd1 vssd1 vccd1 vccd1 cell2.SB0.route_sel\[126\]
+ sky130_fd_sc_hd__dfstp_1
XFILLER_129_839 vssd1 vssd1 vccd1 vccd1 sky130_fd_sc_hd__fill_1
X_11553_ cell0.SB0.route_sel\[27\] _01597_ vssd1 vssd1 vccd1 vccd1 _06369_ sky130_fd_sc_hd__nand2_1
X_14272_ clknet_leaf_22_clk _01244_ net605 vssd1 vssd1 vccd1 vccd1 cell2.SB0.route_sel\[57\]
+ sky130_fd_sc_hd__dfstp_1
X_11484_ cell1.SB0.config_data_out cell1.SB0.route_sel\[126\] vssd1 vssd1 vccd1 vccd1
+ _06323_ sky130_fd_sc_hd__nor2_1
X_10504_ _02219_ _05467_ _02221_ vssd1 vssd1 vccd1 vccd1 net135 sky130_fd_sc_hd__a21bo_1
XANTENNA__10563__X _05521_ vssd1 vssd1 vccd1 vccd1 sky130_fd_sc_hd__diode_2
X_10435_ _05430_ _04321_ vssd1 vssd1 vccd1 vccd1 bus3_2\[2\] sky130_fd_sc_hd__and2b_2
X_13223_ clknet_leaf_121_clk _00195_ net593 vssd1 vssd1 vccd1 vccd1 cell0.LEI0.config_data\[8\]
+ sky130_fd_sc_hd__dfrtp_1
XFILLER_12_81 vssd1 vssd1 vccd1 vccd1 sky130_fd_sc_hd__fill_2
XFILLER_124_511 vssd1 vssd1 vccd1 vccd1 sky130_fd_sc_hd__fill_1
X_13154_ clknet_leaf_120_clk net1153 net595 vssd1 vssd1 vccd1 vccd1 cell0.LE_1A.config_data\[5\]
+ sky130_fd_sc_hd__dfrtp_1
X_10366_ _05111_ _05348_ vssd1 vssd1 vccd1 vccd1 _05365_ sky130_fd_sc_hd__nand2_1
XFILLER_97_417 vssd1 vssd1 vccd1 vccd1 sky130_fd_sc_hd__fill_1
XFILLER_88_41 vssd1 vssd1 vccd1 vccd1 sky130_fd_sc_hd__fill_2
X_12105_ net1278 net1177 net876 vssd1 vssd1 vccd1 vccd1 _00539_ sky130_fd_sc_hd__mux2_1
X_10297_ net431 _05103_ vssd1 vssd1 vccd1 vccd1 _05296_ sky130_fd_sc_hd__nand2_1
XANTENNA__06800__B1 bus2_0\[6\] vssd1 vssd1 vccd1 vccd1 sky130_fd_sc_hd__diode_2
X_13085_ clknet_leaf_4_clk _00057_ net564 vssd1 vssd1 vccd1 vccd1 cell0.CB_0.config_dataB\[12\]
+ sky130_fd_sc_hd__dfstp_1
XTAP_TAPCELL_ROW_127_2219 vssd1 vccd1 sky130_fd_sc_hd__tapvpwrvgnd_1
XTAP_TAPCELL_ROW_127_2208 vssd1 vccd1 sky130_fd_sc_hd__tapvpwrvgnd_1
XANTENNA__07872__X _02916_ vssd1 vssd1 vccd1 vccd1 sky130_fd_sc_hd__diode_2
XANTENNA__08148__A3 bus1_0\[3\] vssd1 vssd1 vccd1 vccd1 sky130_fd_sc_hd__diode_2
X_12036_ cell1.CB_1.config_dataB\[14\] cell1.CB_1.config_dataB\[13\] net891 vssd1
+ vssd1 vccd1 vccd1 _00473_ sky130_fd_sc_hd__mux2_1
XFILLER_93_612 vssd1 vssd1 vccd1 vccd1 sky130_fd_sc_hd__fill_1
XFILLER_78_686 vssd1 vssd1 vccd1 vccd1 sky130_fd_sc_hd__fill_1
XTAP_TAPCELL_ROW_109_1941 vssd1 vccd1 sky130_fd_sc_hd__tapvpwrvgnd_1
XANTENNA__09305__A net107 vssd1 vssd1 vccd1 vccd1 sky130_fd_sc_hd__diode_2
XTAP_TAPCELL_ROW_140_2408 vssd1 vccd1 sky130_fd_sc_hd__tapvpwrvgnd_1
X_13987_ clknet_leaf_43_clk _00959_ net633 vssd1 vssd1 vccd1 vccd1 cell2.LEI0.config_data\[44\]
+ sky130_fd_sc_hd__dfrtp_1
XANTENNA__08305__A0 net344 vssd1 vssd1 vccd1 vccd1 sky130_fd_sc_hd__diode_2
X_12938_ net1024 net1015 net931 vssd1 vssd1 vccd1 vccd1 _01366_ sky130_fd_sc_hd__mux2_1
XANTENNA__10885__S _05758_ vssd1 vssd1 vccd1 vccd1 sky130_fd_sc_hd__diode_2
XANTENNA__10663__B2 net13 vssd1 vssd1 vccd1 vccd1 sky130_fd_sc_hd__diode_2
XANTENNA__10663__A1 net14 vssd1 vssd1 vccd1 vccd1 sky130_fd_sc_hd__diode_2
XFILLER_73_391 vssd1 vssd1 vccd1 vccd1 sky130_fd_sc_hd__fill_1
X_12869_ cell2.SB0.route_sel\[111\] cell2.SB0.route_sel\[110\] net810 vssd1 vssd1
+ vccd1 vccd1 _01298_ sky130_fd_sc_hd__mux2_1
XTAP_TAPCELL_ROW_64_1270 vssd1 vccd1 sky130_fd_sc_hd__tapvpwrvgnd_1
XANTENNA__08608__A1 net5 vssd1 vssd1 vccd1 vccd1 sky130_fd_sc_hd__diode_2
X_06390_ cell0.SB0.route_sel\[51\] vssd1 vssd1 vccd1 vccd1 _01460_ sky130_fd_sc_hd__inv_2
XFILLER_135_809 vccd1 vssd1 vccd1 vssd1 sky130_ef_sc_hd__decap_40_12
X_08060_ net527 _02897_ vssd1 vssd1 vccd1 vccd1 _03102_ sky130_fd_sc_hd__nand2_1
XFILLER_127_360 vssd1 vssd1 vccd1 vccd1 sky130_fd_sc_hd__fill_1
XANTENNA__10179__A0 net33 vssd1 vssd1 vccd1 vccd1 sky130_fd_sc_hd__diode_2
X_07011_ cell2.SB0.route_sel\[69\] cell2.SB0.route_sel\[68\] _02029_ vssd1 vssd1 vccd1
+ vccd1 _02076_ sky130_fd_sc_hd__a21o_1
XFILLER_108_29 vssd1 vssd1 vccd1 vccd1 sky130_fd_sc_hd__fill_1
XFILLER_115_555 vssd1 vssd1 vccd1 vccd1 sky130_fd_sc_hd__fill_1
XANTENNA__08387__A3 bus1_0\[11\] vssd1 vssd1 vccd1 vccd1 sky130_fd_sc_hd__diode_2
X_08962_ net464 _03820_ vssd1 vssd1 vccd1 vccd1 _03994_ sky130_fd_sc_hd__nand2_1
XPHY_EDGE_ROW_126_Left_269 vssd1 vssd1 vccd1 vccd1 sky130_fd_sc_hd__decap_3
X_08893_ bus3_1\[5\] _03905_ _03906_ bus3_1\[4\] cell1.CB_0.config_dataA\[3\] vssd1
+ vssd1 vccd1 vccd1 _03925_ sky130_fd_sc_hd__a221o_1
X_07913_ _02950_ _02953_ _02955_ _02956_ vssd1 vssd1 vccd1 vccd1 _02957_ sky130_fd_sc_hd__o22a_1
XANTENNA__07782__X _02827_ vssd1 vssd1 vccd1 vccd1 sky130_fd_sc_hd__diode_2
X_07844_ cell0.SB0.route_sel\[46\] cell0.SB0.route_sel\[47\] vssd1 vssd1 vccd1 vccd1
+ _02888_ sky130_fd_sc_hd__nand2b_1
XFILLER_83_111 vssd1 vssd1 vccd1 vccd1 sky130_fd_sc_hd__fill_1
XFILLER_17_15 vccd1 vssd1 vccd1 vssd1 sky130_ef_sc_hd__decap_40_12
XTAP_TAPCELL_ROW_27_707 vssd1 vccd1 sky130_fd_sc_hd__tapvpwrvgnd_1
XTAP_TAPCELL_ROW_27_718 vssd1 vccd1 sky130_fd_sc_hd__tapvpwrvgnd_1
X_07775_ cell1.SB0.route_sel\[36\] cell1.SB0.route_sel\[37\] vssd1 vssd1 vccd1 vccd1
+ _02821_ sky130_fd_sc_hd__nand2b_1
XFILLER_140_27 vssd1 vssd1 vccd1 vccd1 sky130_fd_sc_hd__fill_1
X_06726_ net389 vssd1 vssd1 vccd1 vccd1 _01796_ sky130_fd_sc_hd__inv_2
X_09514_ net363 net362 vssd1 vssd1 vccd1 vccd1 _04534_ sky130_fd_sc_hd__nand2b_1
XANTENNA__07006__Y bus1_0\[8\] vssd1 vssd1 vccd1 vccd1 sky130_fd_sc_hd__diode_2
X_09445_ cell3.SB0.route_sel\[52\] cell3.SB0.route_sel\[53\] vssd1 vssd1 vccd1 vccd1
+ _04467_ sky130_fd_sc_hd__nand2_2
XANTENNA__06858__B1 _01926_ vssd1 vssd1 vccd1 vccd1 sky130_fd_sc_hd__diode_2
X_06657_ cell3.SB0.route_sel\[77\] vssd1 vssd1 vccd1 vccd1 _01727_ sky130_fd_sc_hd__inv_2
XFILLER_52_531 vssd1 vssd1 vccd1 vccd1 sky130_fd_sc_hd__fill_1
XANTENNA_fanout628_A net632 vssd1 vssd1 vccd1 vccd1 sky130_fd_sc_hd__diode_2
XANTENNA__11480__A _02444_ vssd1 vssd1 vccd1 vccd1 sky130_fd_sc_hd__diode_2
XPHY_EDGE_ROW_135_Left_278 vssd1 vssd1 vccd1 vccd1 sky130_fd_sc_hd__decap_3
XANTENNA__10406__A1 net62 vssd1 vssd1 vccd1 vccd1 sky130_fd_sc_hd__diode_2
X_09376_ _04379_ _04398_ _04396_ vssd1 vssd1 vccd1 vccd1 _04400_ sky130_fd_sc_hd__or3b_1
X_06588_ net455 vssd1 vssd1 vccd1 vccd1 _01658_ sky130_fd_sc_hd__inv_2
XANTENNA__10096__A _02106_ vssd1 vssd1 vccd1 vccd1 sky130_fd_sc_hd__diode_2
X_08327_ net510 _02494_ net508 vssd1 vssd1 vccd1 vccd1 _03365_ sky130_fd_sc_hd__o21ai_1
XFILLER_33_69 vccd1 vssd1 vccd1 vssd1 sky130_ef_sc_hd__decap_40_12
X_08258_ _03295_ _03296_ _03297_ _01500_ vssd1 vssd1 vccd1 vccd1 _03298_ sky130_fd_sc_hd__a2bb2o_1
XTAP_TAPCELL_ROW_95_1731 vssd1 vccd1 sky130_fd_sc_hd__tapvpwrvgnd_1
X_07209_ net344 _02268_ vssd1 vssd1 vccd1 vccd1 _02269_ sky130_fd_sc_hd__nor2_1
XFILLER_134_831 vssd1 vssd1 vccd1 vccd1 sky130_fd_sc_hd__fill_1
X_10220_ net61 net62 net416 vssd1 vssd1 vccd1 vccd1 _05221_ sky130_fd_sc_hd__mux2_1
XFILLER_106_533 vssd1 vssd1 vccd1 vccd1 sky130_fd_sc_hd__fill_2
X_08189_ net342 net346 net350 net338 cell0.LEI0.config_data\[18\] cell0.LEI0.config_data\[19\]
+ vssd1 vssd1 vccd1 vccd1 _03229_ sky130_fd_sc_hd__mux4_1
XFILLER_3_137 vccd1 vssd1 vccd1 vssd1 sky130_ef_sc_hd__decap_40_12
X_10151_ _05151_ _04257_ vssd1 vssd1 vccd1 vccd1 _05152_ sky130_fd_sc_hd__and2b_4
XANTENNA__08788__X _03820_ vssd1 vssd1 vccd1 vccd1 sky130_fd_sc_hd__diode_2
XTAP_TAPCELL_ROW_7_410 vssd1 vccd1 sky130_fd_sc_hd__tapvpwrvgnd_1
XFILLER_0_811 vssd1 vssd1 vccd1 vccd1 sky130_fd_sc_hd__fill_1
X_10082_ _01635_ cell2.SB0.route_sel\[95\] cell2.SB0.route_sel\[92\] _01636_ _05082_
+ vssd1 vssd1 vccd1 vccd1 _05083_ sky130_fd_sc_hd__a221o_1
XANTENNA_fanout952_X net952 vssd1 vssd1 vccd1 vccd1 sky130_fd_sc_hd__diode_2
X_13910_ clknet_leaf_35_clk _00882_ net637 vssd1 vssd1 vccd1 vccd1 cell2.LE_0B.config_data\[11\]
+ sky130_fd_sc_hd__dfrtp_1
X_13841_ clknet_leaf_114_clk _00813_ net673 vssd1 vssd1 vccd1 vccd1 cell1.SB0.route_sel\[118\]
+ sky130_fd_sc_hd__dfstp_1
X_10984_ net49 net50 net51 net52 net377 net376 vssd1 vssd1 vccd1 vccd1 _05938_ sky130_fd_sc_hd__mux4_1
XTAP_TAPCELL_ROW_122_2138 vssd1 vccd1 sky130_fd_sc_hd__tapvpwrvgnd_1
XANTENNA_input116_X net116 vssd1 vssd1 vccd1 vccd1 sky130_fd_sc_hd__diode_2
X_13772_ clknet_leaf_110_clk _00744_ net653 vssd1 vssd1 vccd1 vccd1 cell1.SB0.route_sel\[49\]
+ sky130_fd_sc_hd__dfstp_1
X_12723_ net383 cell3.CB_0.config_dataB\[14\] net932 vssd1 vssd1 vccd1 vccd1 _01152_
+ sky130_fd_sc_hd__mux2_1
XFILLER_74_87 vssd1 vssd1 vccd1 vccd1 sky130_fd_sc_hd__fill_1
XFILLER_43_542 vssd1 vssd1 vccd1 vccd1 sky130_fd_sc_hd__fill_1
XFILLER_15_222 vssd1 vssd1 vccd1 vccd1 sky130_fd_sc_hd__fill_2
XFILLER_15_233 vssd1 vssd1 vccd1 vccd1 sky130_fd_sc_hd__fill_2
XTAP_TAPCELL_ROW_104_1871 vssd1 vccd1 sky130_fd_sc_hd__tapvpwrvgnd_1
XANTENNA__13692__SET_B net621 vssd1 vssd1 vccd1 vccd1 sky130_fd_sc_hd__diode_2
X_12654_ cell3.SB0.route_sel\[119\] cell3.SB0.route_sel\[118\] net921 vssd1 vssd1
+ vccd1 vccd1 _01083_ sky130_fd_sc_hd__mux2_1
X_12585_ cell3.SB0.route_sel\[50\] cell3.SB0.route_sel\[49\] net921 vssd1 vssd1 vccd1
+ vccd1 _01014_ sky130_fd_sc_hd__mux2_1
XFILLER_88_9 vccd1 vssd1 vccd1 vssd1 sky130_ef_sc_hd__decap_40_12
X_11605_ cell0.CB_0.config_dataB\[1\] net534 net779 vssd1 vssd1 vccd1 vccd1 _00046_
+ sky130_fd_sc_hd__mux2_1
XANTENNA__11070__A1 net279 vssd1 vssd1 vccd1 vccd1 sky130_fd_sc_hd__diode_2
XTAP_TAPCELL_ROW_137_2370 vssd1 vccd1 sky130_fd_sc_hd__tapvpwrvgnd_1
XFILLER_128_135 vssd1 vssd1 vccd1 vccd1 sky130_fd_sc_hd__fill_1
XFILLER_128_124 vssd1 vssd1 vccd1 vccd1 sky130_fd_sc_hd__fill_1
XANTENNA__11110__A1_N _05898_ vssd1 vssd1 vccd1 vccd1 sky130_fd_sc_hd__diode_2
XANTENNA__09795__A _04527_ vssd1 vssd1 vccd1 vccd1 sky130_fd_sc_hd__diode_2
X_14324_ clknet_leaf_21_clk _01296_ net610 vssd1 vssd1 vccd1 vccd1 cell2.SB0.route_sel\[109\]
+ sky130_fd_sc_hd__dfstp_1
XANTENNA_input81_X net81 vssd1 vssd1 vccd1 vccd1 sky130_fd_sc_hd__diode_2
X_11536_ _01577_ cell0.SB0.route_sel\[2\] cell0.SB0.route_sel\[7\] cell0.SB0.route_sel\[6\]
+ _06357_ vssd1 vssd1 vccd1 vccd1 _06358_ sky130_fd_sc_hd__o221a_1
X_14255_ clknet_leaf_26_clk _01227_ net613 vssd1 vssd1 vccd1 vccd1 cell2.SB0.route_sel\[40\]
+ sky130_fd_sc_hd__dfstp_1
X_13206_ clknet_leaf_23_clk net1019 net604 vssd1 vssd1 vccd1 vccd1 cell0.LE_0A.config_data\[13\]
+ sky130_fd_sc_hd__dfrtp_1
XANTENNA__09015__A1 _03853_ vssd1 vssd1 vccd1 vccd1 sky130_fd_sc_hd__diode_2
XANTENNA__09015__B2 _03849_ vssd1 vssd1 vccd1 vccd1 sky130_fd_sc_hd__diode_2
X_11467_ _01528_ cell1.SB0.route_sel\[73\] cell1.SB0.route_sel\[78\] cell1.SB0.route_sel\[79\]
+ _06311_ vssd1 vssd1 vccd1 vccd1 _06312_ sky130_fd_sc_hd__o221a_1
X_10418_ _05382_ _05416_ _05380_ vssd1 vssd1 vccd1 vccd1 _05417_ sky130_fd_sc_hd__mux2_1
XANTENNA__14212__SET_B net723 vssd1 vssd1 vccd1 vccd1 sky130_fd_sc_hd__diode_2
X_14186_ clknet_leaf_51_clk _01158_ net720 vssd1 vssd1 vccd1 vccd1 cell3.CB_0.config_dataB\[21\]
+ sky130_fd_sc_hd__dfstp_1
XANTENNA__08223__C1 _03262_ vssd1 vssd1 vccd1 vccd1 sky130_fd_sc_hd__diode_2
XANTENNA__08237__A1_N _02040_ vssd1 vssd1 vccd1 vccd1 sky130_fd_sc_hd__diode_2
X_11398_ cell0.SB0.route_sel\[78\] cell0.SB0.route_sel\[79\] cell0.SB0.route_sel\[74\]
+ _01470_ _06265_ vssd1 vssd1 vccd1 vccd1 _06266_ sky130_fd_sc_hd__o221a_1
X_10349_ net426 net428 vssd1 vssd1 vccd1 vccd1 _05348_ sky130_fd_sc_hd__and2b_1
XFILLER_124_385 vssd1 vssd1 vccd1 vccd1 sky130_fd_sc_hd__fill_1
X_13137_ clknet_leaf_127_clk _00109_ net581 vssd1 vssd1 vccd1 vccd1 cell0.CB_1.config_dataB\[14\]
+ sky130_fd_sc_hd__dfstp_1
XFILLER_3_671 vssd1 vssd1 vccd1 vccd1 sky130_fd_sc_hd__fill_1
XFILLER_140_845 vssd1 vssd1 vccd1 vccd1 sky130_fd_sc_hd__fill_2
X_13068_ clknet_leaf_125_clk _00040_ net584 vssd1 vssd1 vccd1 vccd1 cell0.CB_1.config_dataA\[20\]
+ sky130_fd_sc_hd__dfstp_1
XFILLER_97_269 vssd1 vssd1 vccd1 vccd1 sky130_fd_sc_hd__fill_1
X_12019_ cell0.SB0.route_sel\[125\] cell0.SB0.route_sel\[124\] net791 vssd1 vssd1
+ vccd1 vccd1 _00456_ sky130_fd_sc_hd__mux2_1
XFILLER_93_420 vssd1 vssd1 vccd1 vccd1 sky130_fd_sc_hd__fill_1
XFILLER_17_3 vccd1 vssd1 vccd1 vssd1 sky130_ef_sc_hd__decap_40_12
XFILLER_81_615 vssd1 vssd1 vccd1 vccd1 sky130_fd_sc_hd__fill_1
XANTENNA__13553__Q cell1.LE_0B.reset_val vssd1 vssd1 vccd1 vccd1 sky130_fd_sc_hd__diode_2
X_07560_ net358 net353 vssd1 vssd1 vccd1 vccd1 _02610_ sky130_fd_sc_hd__nor2_1
XANTENNA__10636__A1 _05513_ vssd1 vssd1 vccd1 vccd1 sky130_fd_sc_hd__diode_2
X_06511_ cell2.SB0.route_sel\[10\] vssd1 vssd1 vccd1 vccd1 _01581_ sky130_fd_sc_hd__inv_2
XFILLER_34_520 vssd1 vssd1 vccd1 vccd1 sky130_fd_sc_hd__fill_2
XANTENNA__10468__X bus3_2\[13\] vssd1 vssd1 vccd1 vccd1 sky130_fd_sc_hd__diode_2
X_09230_ _04247_ _04251_ _04256_ net829 vssd1 vssd1 vccd1 vccd1 _04257_ sky130_fd_sc_hd__a211oi_4
X_07491_ _01933_ _02326_ bus1_0\[15\] vssd1 vssd1 vccd1 vccd1 _02543_ sky130_fd_sc_hd__o21a_1
XFILLER_22_715 vssd1 vssd1 vccd1 vccd1 sky130_fd_sc_hd__fill_1
X_06442_ cell1.SB0.route_sel\[34\] vssd1 vssd1 vccd1 vccd1 _01512_ sky130_fd_sc_hd__inv_2
X_09161_ cell2.CB_0.config_dataA\[22\] cell2.CB_0.config_dataA\[23\] vssd1 vssd1 vccd1
+ vccd1 _04189_ sky130_fd_sc_hd__or2_1
XANTENNA__08057__A2 bus2_0\[10\] vssd1 vssd1 vccd1 vccd1 sky130_fd_sc_hd__diode_2
XANTENNA__11061__A1 net48 vssd1 vssd1 vccd1 vccd1 sky130_fd_sc_hd__diode_2
X_09092_ cell1.LE_0B.config_data\[3\] cell1.LE_0B.config_data\[2\] _04086_ vssd1 vssd1
+ vccd1 vccd1 _04122_ sky130_fd_sc_hd__mux2_1
X_08112_ _03152_ _03153_ _03057_ vssd1 vssd1 vccd1 vccd1 _03154_ sky130_fd_sc_hd__mux2_1
XFILLER_9_93 vccd1 vssd1 vccd1 vssd1 sky130_ef_sc_hd__decap_40_12
XTAP_TAPCELL_ROW_32_787 vssd1 vccd1 sky130_fd_sc_hd__tapvpwrvgnd_1
XFILLER_135_617 vssd1 vssd1 vccd1 vccd1 sky130_fd_sc_hd__fill_1
XFILLER_119_39 vccd1 vssd1 vccd1 vssd1 sky130_ef_sc_hd__decap_40_12
X_08043_ net344 net347 cell0.CB_1.le_outA cell0.CB_1.le_outB cell0.LEI0.config_data\[3\]
+ cell0.LEI0.config_data\[4\] vssd1 vssd1 vccd1 vccd1 _03085_ sky130_fd_sc_hd__mux4_1
XTAP_TAPCELL_ROW_77_1461 vssd1 vccd1 sky130_fd_sc_hd__tapvpwrvgnd_1
XFILLER_135_27 vccd1 vssd1 vccd1 vssd1 sky130_ef_sc_hd__decap_40_12
X_09994_ net404 net402 vssd1 vssd1 vccd1 vccd1 _04998_ sky130_fd_sc_hd__or2_1
XTAP_TAPCELL_ROW_90_1661 vssd1 vccd1 sky130_fd_sc_hd__tapvpwrvgnd_1
X_08945_ net464 _03881_ vssd1 vssd1 vccd1 vccd1 _03977_ sky130_fd_sc_hd__nand2_1
X_08876_ net472 _03903_ _03904_ _03907_ vssd1 vssd1 vccd1 vccd1 _03908_ sky130_fd_sc_hd__a31o_1
X_07827_ bus2_0\[12\] bus2_0\[13\] bus2_0\[14\] bus2_0\[15\] net518 net517 vssd1 vssd1
+ vccd1 vccd1 _02871_ sky130_fd_sc_hd__mux4_1
XANTENNA__08532__A3 net7 vssd1 vssd1 vccd1 vccd1 sky130_fd_sc_hd__diode_2
XFILLER_56_177 vssd1 vssd1 vccd1 vccd1 sky130_fd_sc_hd__fill_1
X_07758_ _02790_ _02798_ _02803_ net551 vssd1 vssd1 vccd1 vccd1 _02804_ sky130_fd_sc_hd__o211a_4
X_06709_ cell3.CB_1.config_dataB\[7\] vssd1 vssd1 vccd1 vccd1 _01779_ sky130_fd_sc_hd__inv_2
XFILLER_71_169 vssd1 vssd1 vccd1 vccd1 sky130_fd_sc_hd__fill_8
X_07689_ cell1.SB0.route_sel\[16\] cell1.SB0.route_sel\[17\] _02736_ vssd1 vssd1 vccd1
+ vccd1 _02737_ sky130_fd_sc_hd__a21oi_1
XANTENNA__13702__SET_B net621 vssd1 vssd1 vccd1 vccd1 sky130_fd_sc_hd__diode_2
X_09428_ net14 _04450_ vssd1 vssd1 vccd1 vccd1 _04451_ sky130_fd_sc_hd__or2_1
XFILLER_12_236 vssd1 vssd1 vccd1 vccd1 sky130_fd_sc_hd__fill_4
XFILLER_138_411 vssd1 vssd1 vccd1 vccd1 sky130_fd_sc_hd__fill_1
X_09359_ cell2.SB0.route_sel\[36\] cell2.SB0.route_sel\[37\] _02799_ vssd1 vssd1 vccd1
+ vccd1 _04383_ sky130_fd_sc_hd__a21oi_1
XANTENNA_fanout700_X net700 vssd1 vssd1 vccd1 vccd1 sky130_fd_sc_hd__diode_2
XANTENNA__08048__A2 _02235_ vssd1 vssd1 vccd1 vccd1 sky130_fd_sc_hd__diode_2
XANTENNA__07256__B1 net35 vssd1 vssd1 vccd1 vccd1 sky130_fd_sc_hd__diode_2
X_12370_ cell1.SB0.route_sel\[108\] cell1.SB0.route_sel\[107\] net874 vssd1 vssd1
+ vccd1 vccd1 _00803_ sky130_fd_sc_hd__mux2_1
XFILLER_121_3 vccd1 vssd1 vccd1 vssd1 sky130_ef_sc_hd__decap_40_12
X_11321_ _05532_ net288 _04679_ vssd1 vssd1 vccd1 vccd1 _06226_ sky130_fd_sc_hd__mux2_1
XTAP_TAPCELL_ROW_10_459 vssd1 vccd1 sky130_fd_sc_hd__tapvpwrvgnd_1
XFILLER_138_488 vssd1 vssd1 vccd1 vccd1 sky130_fd_sc_hd__fill_1
XFILLER_107_820 vssd1 vssd1 vccd1 vccd1 sky130_fd_sc_hd__fill_2
X_11252_ _06193_ net311 _04190_ vssd1 vssd1 vccd1 vccd1 net166 sky130_fd_sc_hd__mux2_1
X_14040_ clknet_leaf_49_clk _01012_ net706 vssd1 vssd1 vccd1 vccd1 cell3.SB0.route_sel\[48\]
+ sky130_fd_sc_hd__dfstp_1
XFILLER_4_457 vccd1 vssd1 vccd1 vssd1 sky130_ef_sc_hd__decap_40_12
XANTENNA__11369__B _02804_ vssd1 vssd1 vccd1 vccd1 sky130_fd_sc_hd__diode_2
X_11183_ _06123_ _06124_ _06131_ _06134_ vssd1 vssd1 vccd1 vccd1 _06135_ sky130_fd_sc_hd__o211a_1
X_10203_ net415 _05084_ vssd1 vssd1 vccd1 vccd1 _05204_ sky130_fd_sc_hd__nand2_1
XANTENNA_input41_A CBnorth_in[17] vssd1 vssd1 vccd1 vccd1 sky130_fd_sc_hd__diode_2
X_10134_ cell2.SB0.route_sel\[43\] cell2.SB0.route_sel\[42\] cell2.SB0.route_sel\[46\]
+ _01608_ _05134_ vssd1 vssd1 vccd1 vccd1 _05135_ sky130_fd_sc_hd__o221a_1
XANTENNA__09407__X _04430_ vssd1 vssd1 vccd1 vccd1 sky130_fd_sc_hd__diode_2
XANTENNA__09597__A1_N net330 vssd1 vssd1 vccd1 vccd1 sky130_fd_sc_hd__diode_2
X_10065_ _05067_ _05068_ _04992_ vssd1 vssd1 vccd1 vccd1 _05069_ sky130_fd_sc_hd__mux2_1
XFILLER_0_685 vccd1 vssd1 vccd1 vssd1 sky130_ef_sc_hd__decap_40_12
XANTENNA__10866__A1 _05510_ vssd1 vssd1 vccd1 vccd1 sky130_fd_sc_hd__diode_2
XTAP_TAPCELL_ROW_106_1900 vssd1 vccd1 sky130_fd_sc_hd__tapvpwrvgnd_1
XANTENNA__07192__C1 net551 vssd1 vssd1 vccd1 vccd1 sky130_fd_sc_hd__diode_2
XFILLER_63_637 vssd1 vssd1 vccd1 vccd1 sky130_fd_sc_hd__fill_1
XFILLER_63_615 vssd1 vssd1 vccd1 vccd1 sky130_fd_sc_hd__fill_1
X_13824_ clknet_leaf_104_clk _00796_ net662 vssd1 vssd1 vccd1 vccd1 cell1.SB0.route_sel\[101\]
+ sky130_fd_sc_hd__dfstp_1
XFILLER_141_81 vssd1 vssd1 vccd1 vccd1 sky130_fd_sc_hd__fill_8
XFILLER_90_489 vssd1 vssd1 vccd1 vccd1 sky130_fd_sc_hd__fill_1
X_10967_ net276 _05920_ vssd1 vssd1 vccd1 vccd1 _05921_ sky130_fd_sc_hd__nand2_4
Xclkbuf_1_0__f_cell1.LE_0A.sel_clk clknet_0_cell1.LE_0A.sel_clk vssd1 vssd1 vccd1
+ vccd1 clknet_1_0__leaf_cell1.LE_0A.sel_clk sky130_fd_sc_hd__clkbuf_16
X_13755_ clknet_leaf_108_clk _00727_ net652 vssd1 vssd1 vccd1 vccd1 cell1.SB0.route_sel\[32\]
+ sky130_fd_sc_hd__dfstp_1
XFILLER_16_553 vssd1 vssd1 vccd1 vccd1 sky130_fd_sc_hd__fill_2
X_13686_ clknet_leaf_29_clk _00658_ net619 vssd1 vssd1 vccd1 vccd1 cell2.CB_0.config_dataB\[13\]
+ sky130_fd_sc_hd__dfstp_1
X_10898_ _01806_ net272 _05849_ vssd1 vssd1 vccd1 vccd1 _05852_ sky130_fd_sc_hd__or3_1
X_12706_ cell3.CB_1.config_dataA\[23\] cell3.CB_1.config_dataA\[22\] net940 vssd1
+ vssd1 vccd1 vccd1 _01135_ sky130_fd_sc_hd__mux2_1
XFILLER_31_523 vssd1 vssd1 vccd1 vccd1 sky130_fd_sc_hd__fill_1
X_12637_ cell3.SB0.route_sel\[102\] cell3.SB0.route_sel\[101\] net922 vssd1 vssd1
+ vccd1 vccd1 _01066_ sky130_fd_sc_hd__mux2_1
XANTENNA__07103__A bus3_2\[9\] vssd1 vssd1 vccd1 vccd1 sky130_fd_sc_hd__diode_2
XTAP_TAPCELL_ROW_135_2329 vssd1 vccd1 sky130_fd_sc_hd__tapvpwrvgnd_1
XFILLER_117_606 vssd1 vssd1 vccd1 vccd1 sky130_fd_sc_hd__fill_1
X_12568_ cell3.SB0.route_sel\[33\] cell3.SB0.route_sel\[32\] net911 vssd1 vssd1 vccd1
+ vccd1 _00997_ sky130_fd_sc_hd__mux2_1
Xhold207 _01105_ vssd1 vssd1 vccd1 vccd1 net1166 sky130_fd_sc_hd__dlygate4sd3_1
XFILLER_116_127 vssd1 vssd1 vccd1 vccd1 sky130_fd_sc_hd__fill_1
X_12499_ net1370 cell2.LEI0.config_data\[12\] net840 vssd1 vssd1 vccd1 vccd1 _00928_
+ sky130_fd_sc_hd__mux2_1
X_14307_ clknet_leaf_17_clk _01279_ net626 vssd1 vssd1 vccd1 vccd1 cell2.SB0.route_sel\[92\]
+ sky130_fd_sc_hd__dfstp_2
X_11519_ _06346_ _02253_ vssd1 vssd1 vccd1 vccd1 net248 sky130_fd_sc_hd__and2b_2
XFILLER_7_273 vssd1 vssd1 vccd1 vccd1 sky130_fd_sc_hd__fill_4
X_14238_ clknet_leaf_20_clk _01210_ net611 vssd1 vssd1 vccd1 vccd1 cell2.SB0.route_sel\[23\]
+ sky130_fd_sc_hd__dfstp_1
Xhold218 cell1.LE_0A.config_data\[9\] vssd1 vssd1 vccd1 vccd1 net1177 sky130_fd_sc_hd__dlygate4sd3_1
Xhold229 cell0.LE_1B.config_data\[6\] vssd1 vssd1 vccd1 vccd1 net1188 sky130_fd_sc_hd__dlygate4sd3_1
X_14169_ clknet_leaf_52_clk _01141_ net720 vssd1 vssd1 vccd1 vccd1 cell3.CB_0.config_dataB\[4\]
+ sky130_fd_sc_hd__dfstp_1
XTAP_TAPCELL_ROW_59_1191 vssd1 vccd1 sky130_fd_sc_hd__tapvpwrvgnd_1
Xfanout709 net710 vssd1 vssd1 vccd1 vccd1 net709 sky130_fd_sc_hd__clkbuf_2
X_06991_ cell1.CB_0.config_dataA\[24\] cell1.CB_0.config_dataA\[21\] cell1.CB_0.config_dataA\[20\]
+ vssd1 vssd1 vccd1 vccd1 _02057_ sky130_fd_sc_hd__or3_2
XTAP_TAPCELL_ROW_72_1391 vssd1 vccd1 sky130_fd_sc_hd__tapvpwrvgnd_1
X_08730_ cell1.CB_1.config_dataB\[13\] cell1.CB_1.config_dataB\[12\] cell1.CB_1.config_dataB\[14\]
+ _03738_ vssd1 vssd1 vccd1 vccd1 _03764_ sky130_fd_sc_hd__or4bb_1
X_08661_ _03686_ _03687_ _03692_ _03694_ vssd1 vssd1 vccd1 vccd1 _03695_ sky130_fd_sc_hd__a2bb2o_1
XFILLER_93_272 vssd1 vssd1 vccd1 vccd1 sky130_fd_sc_hd__fill_1
XFILLER_66_475 vssd1 vssd1 vccd1 vccd1 sky130_fd_sc_hd__fill_1
X_07612_ _02109_ _02606_ net348 vssd1 vssd1 vccd1 vccd1 _02661_ sky130_fd_sc_hd__and3b_1
XANTENNA__07722__A1 net26 vssd1 vssd1 vccd1 vccd1 sky130_fd_sc_hd__diode_2
X_08592_ cell1.CB_1.config_dataA\[18\] cell1.CB_1.config_dataA\[17\] vssd1 vssd1 vccd1
+ vccd1 _03628_ sky130_fd_sc_hd__nor2_1
XTAP_TAPCELL_ROW_37_857 vssd1 vccd1 sky130_fd_sc_hd__tapvpwrvgnd_1
XTAP_TAPCELL_ROW_37_868 vssd1 vccd1 sky130_fd_sc_hd__tapvpwrvgnd_1
X_07543_ bus3_2\[15\] _02591_ _02592_ _02593_ vssd1 vssd1 vccd1 vccd1 _02594_ sky130_fd_sc_hd__a211o_1
XANTENNA__11234__S _06076_ vssd1 vssd1 vccd1 vccd1 sky130_fd_sc_hd__diode_2
X_07474_ _02486_ _02491_ _02525_ _02488_ vssd1 vssd1 vccd1 vccd1 _02527_ sky130_fd_sc_hd__a31o_1
XTAP_TAPCELL_ROW_17_570 vssd1 vccd1 sky130_fd_sc_hd__tapvpwrvgnd_1
XFILLER_139_208 vssd1 vssd1 vccd1 vccd1 sky130_fd_sc_hd__fill_1
XANTENNA__09227__A1 net44 vssd1 vssd1 vccd1 vccd1 sky130_fd_sc_hd__diode_2
X_06425_ net877 vssd1 vssd1 vccd1 vccd1 _01495_ sky130_fd_sc_hd__inv_2
X_09213_ _02692_ _02694_ _04237_ _04239_ vssd1 vssd1 vccd1 vccd1 _04240_ sky130_fd_sc_hd__a31o_1
XANTENNA__11034__A1 _05921_ vssd1 vssd1 vccd1 vccd1 sky130_fd_sc_hd__diode_2
X_09144_ cell1.LE_0B.config_data\[16\] _04171_ _04172_ net352 vssd1 vssd1 vccd1 vccd1
+ cell1.CB_0.le_outB sky130_fd_sc_hd__o211a_1
XANTENNA_fanout326_A net327 vssd1 vssd1 vccd1 vccd1 sky130_fd_sc_hd__diode_2
X_09075_ bus3_1\[0\] bus3_1\[1\] bus3_1\[2\] bus3_1\[3\] net479 net478 vssd1 vssd1
+ vccd1 vccd1 _04105_ sky130_fd_sc_hd__mux4_1
XFILLER_30_26 vssd1 vssd1 vccd1 vccd1 sky130_fd_sc_hd__fill_2
XFILLER_107_149 vssd1 vssd1 vccd1 vccd1 sky130_fd_sc_hd__fill_1
X_08026_ bus2_0\[12\] bus2_0\[13\] bus2_0\[14\] bus2_0\[15\] net534 cell0.CB_0.config_dataB\[1\]
+ vssd1 vssd1 vccd1 vccd1 _03068_ sky130_fd_sc_hd__mux4_1
XANTENNA_fanout695_A net700 vssd1 vssd1 vccd1 vccd1 sky130_fd_sc_hd__diode_2
XFILLER_1_405 vccd1 vssd1 vccd1 vssd1 sky130_ef_sc_hd__decap_40_12
XANTENNA__07410__A0 net37 vssd1 vssd1 vccd1 vccd1 sky130_fd_sc_hd__diode_2
XFILLER_89_534 vssd1 vssd1 vccd1 vccd1 sky130_fd_sc_hd__fill_2
XFILLER_1_449 vccd1 vssd1 vccd1 vssd1 sky130_ef_sc_hd__decap_40_12
XANTENNA__08202__A2 bus1_0\[10\] vssd1 vssd1 vccd1 vccd1 sky130_fd_sc_hd__diode_2
XANTENNA__09950__A2 net315 vssd1 vssd1 vccd1 vccd1 sky130_fd_sc_hd__diode_2
X_09977_ net406 _04608_ vssd1 vssd1 vccd1 vccd1 _04981_ sky130_fd_sc_hd__nand2_1
XANTENNA__07961__A1 bus2_0\[13\] vssd1 vssd1 vccd1 vccd1 sky130_fd_sc_hd__diode_2
XFILLER_39_57 vccd1 vssd1 vccd1 vssd1 sky130_ef_sc_hd__decap_40_12
XANTENNA_fanout862_A net863 vssd1 vssd1 vccd1 vccd1 sky130_fd_sc_hd__diode_2
XFILLER_130_185 vssd1 vssd1 vccd1 vccd1 sky130_fd_sc_hd__fill_1
XFILLER_57_420 vssd1 vssd1 vccd1 vccd1 sky130_fd_sc_hd__fill_1
X_08928_ _03958_ _03959_ cell1.CB_0.config_dataA\[12\] vssd1 vssd1 vccd1 vccd1 _03960_
+ sky130_fd_sc_hd__mux2_1
XANTENNA_fanout650_X net650 vssd1 vssd1 vccd1 vccd1 sky130_fd_sc_hd__diode_2
XANTENNA__11492__X net238 vssd1 vssd1 vccd1 vccd1 sky130_fd_sc_hd__diode_2
XFILLER_45_615 vssd1 vssd1 vccd1 vccd1 sky130_fd_sc_hd__fill_1
X_08859_ _01514_ cell1.SB0.route_sel\[39\] vssd1 vssd1 vccd1 vccd1 _03891_ sky130_fd_sc_hd__nand2_1
X_11870_ cell1.CB_0.config_dataA\[1\] net473 net883 vssd1 vssd1 vccd1 vccd1 _00307_
+ sky130_fd_sc_hd__mux2_1
X_10821_ _05519_ _05523_ net367 vssd1 vssd1 vccd1 vccd1 _05777_ sky130_fd_sc_hd__mux2_1
XANTENNA__13921__Q cell2.LE_0A.config_data\[0\] vssd1 vssd1 vccd1 vccd1 sky130_fd_sc_hd__diode_2
XANTENNA__11273__A1 net308 vssd1 vssd1 vccd1 vccd1 sky130_fd_sc_hd__diode_2
XFILLER_111_51 vssd1 vssd1 vccd1 vccd1 sky130_fd_sc_hd__fill_4
X_10752_ net15 net16 cell3.CB_1.config_dataB\[0\] vssd1 vssd1 vccd1 vccd1 _05708_
+ sky130_fd_sc_hd__mux2_1
X_13540_ clknet_leaf_73_clk _00512_ net729 vssd1 vssd1 vccd1 vccd1 cell1.LE_0B.config_data\[5\]
+ sky130_fd_sc_hd__dfrtp_1
XTAP_TAPCELL_ROW_15_529 vssd1 vccd1 sky130_fd_sc_hd__tapvpwrvgnd_1
XTAP_TAPCELL_ROW_101_1830 vssd1 vccd1 sky130_fd_sc_hd__tapvpwrvgnd_1
X_13471_ clknet_leaf_1_clk _00443_ net561 vssd1 vssd1 vccd1 vccd1 cell0.SB0.route_sel\[112\]
+ sky130_fd_sc_hd__dfstp_2
X_12422_ net1041 cell2.LE_1A.config_data\[4\] net925 vssd1 vssd1 vccd1 vccd1 _00854_
+ sky130_fd_sc_hd__mux2_1
X_10683_ _05519_ _05523_ net391 vssd1 vssd1 vccd1 vccd1 _05641_ sky130_fd_sc_hd__mux2_1
XFILLER_139_775 vssd1 vssd1 vccd1 vccd1 sky130_fd_sc_hd__fill_8
XANTENNA__06762__A net317 vssd1 vssd1 vccd1 vccd1 sky130_fd_sc_hd__diode_2
XANTENNA__07858__A _02630_ vssd1 vssd1 vccd1 vccd1 sky130_fd_sc_hd__diode_2
XANTENNA_input89_A SBsouth_in[31] vssd1 vssd1 vccd1 vccd1 sky130_fd_sc_hd__diode_2
XANTENNA__08426__C1 net351 vssd1 vssd1 vccd1 vccd1 sky130_fd_sc_hd__diode_2
XFILLER_139_797 vccd1 vssd1 vccd1 vssd1 sky130_ef_sc_hd__decap_40_12
XTAP_TAPCELL_ROW_117_2059 vssd1 vccd1 sky130_fd_sc_hd__tapvpwrvgnd_1
X_12353_ cell1.SB0.route_sel\[91\] cell1.SB0.route_sel\[90\] net870 vssd1 vssd1 vccd1
+ vccd1 _00786_ sky130_fd_sc_hd__mux2_1
XANTENNA__10715__C _05672_ vssd1 vssd1 vccd1 vccd1 sky130_fd_sc_hd__diode_2
X_11304_ net295 _04452_ _04453_ _06216_ vssd1 vssd1 vccd1 vccd1 net147 sky130_fd_sc_hd__a22o_1
X_12284_ cell1.SB0.route_sel\[22\] cell1.SB0.route_sel\[21\] net864 vssd1 vssd1 vccd1
+ vccd1 _00717_ sky130_fd_sc_hd__mux2_1
X_11235_ cell3.LE_0B.config_data\[4\] cell3.LE_0B.config_data\[5\] _06076_ vssd1 vssd1
+ vccd1 vccd1 _06187_ sky130_fd_sc_hd__mux2_1
XTAP_TAPCELL_ROW_130_2259 vssd1 vccd1 sky130_fd_sc_hd__tapvpwrvgnd_1
X_14023_ clknet_leaf_81_clk _00995_ net702 vssd1 vssd1 vccd1 vccd1 cell3.SB0.route_sel\[31\]
+ sky130_fd_sc_hd__dfstp_1
XANTENNA__08992__A3 bus3_1\[3\] vssd1 vssd1 vccd1 vccd1 sky130_fd_sc_hd__diode_2
XFILLER_4_265 vccd1 vssd1 vccd1 vssd1 sky130_ef_sc_hd__decap_40_12
XANTENNA__10536__A0 net15 vssd1 vssd1 vccd1 vccd1 sky130_fd_sc_hd__diode_2
XFILLER_20_81 vssd1 vssd1 vccd1 vccd1 sky130_fd_sc_hd__fill_2
XANTENNA_input44_X net44 vssd1 vssd1 vccd1 vccd1 sky130_fd_sc_hd__diode_2
XFILLER_136_81 vssd1 vssd1 vccd1 vccd1 sky130_fd_sc_hd__fill_2
X_11166_ net384 _06112_ _06113_ cell3.CB_0.config_dataB\[12\] vssd1 vssd1 vccd1 vccd1
+ _06118_ sky130_fd_sc_hd__a211o_1
XANTENNA_output245_A net245 vssd1 vssd1 vccd1 vccd1 sky130_fd_sc_hd__diode_2
XTAP_TAPCELL_ROW_112_1981 vssd1 vccd1 sky130_fd_sc_hd__tapvpwrvgnd_1
XANTENNA__10631__S0 net398 vssd1 vssd1 vccd1 vccd1 sky130_fd_sc_hd__diode_2
XANTENNA__09941__A2 bus3_2\[13\] vssd1 vssd1 vccd1 vccd1 sky130_fd_sc_hd__diode_2
XFILLER_96_41 vssd1 vssd1 vccd1 vccd1 sky130_fd_sc_hd__fill_8
XFILLER_122_686 vssd1 vssd1 vccd1 vccd1 sky130_fd_sc_hd__fill_1
X_10117_ net36 net37 net38 net39 net419 cell2.CB_0.config_dataA\[6\] vssd1 vssd1 vccd1
+ vccd1 _05118_ sky130_fd_sc_hd__mux4_1
X_11097_ _05856_ _06046_ _06048_ _05861_ _01795_ vssd1 vssd1 vccd1 vccd1 _06049_ sky130_fd_sc_hd__a221o_1
XTAP_TAPCELL_ROW_112_1992 vssd1 vccd1 sky130_fd_sc_hd__tapvpwrvgnd_1
XFILLER_96_85 vssd1 vssd1 vccd1 vccd1 sky130_fd_sc_hd__fill_2
XFILLER_96_74 vssd1 vssd1 vccd1 vccd1 sky130_fd_sc_hd__fill_1
XFILLER_95_548 vssd1 vssd1 vccd1 vccd1 sky130_fd_sc_hd__fill_1
XFILLER_0_471 vssd1 vssd1 vccd1 vccd1 sky130_fd_sc_hd__fill_2
XFILLER_95_559 vssd1 vssd1 vccd1 vccd1 sky130_fd_sc_hd__fill_1
X_10048_ net401 _04348_ vssd1 vssd1 vccd1 vccd1 _05052_ sky130_fd_sc_hd__nand2_1
XANTENNA__09154__B1 _02630_ vssd1 vssd1 vccd1 vccd1 sky130_fd_sc_hd__diode_2
XFILLER_48_475 vssd1 vssd1 vccd1 vccd1 sky130_fd_sc_hd__fill_1
Xhold90 cell1.LE_1A.config_data\[4\] vssd1 vssd1 vccd1 vccd1 net1049 sky130_fd_sc_hd__dlygate4sd3_1
Xclkbuf_1_0__f_cell3.LE_0B.sel_clk clknet_0_cell3.LE_0B.sel_clk vssd1 vssd1 vccd1
+ vccd1 clknet_1_0__leaf_cell3.LE_0B.sel_clk sky130_fd_sc_hd__clkbuf_16
XTAP_TAPCELL_ROW_34_816 vssd1 vccd1 sky130_fd_sc_hd__tapvpwrvgnd_1
X_13807_ clknet_leaf_112_clk _00779_ net656 vssd1 vssd1 vccd1 vccd1 cell1.SB0.route_sel\[84\]
+ sky130_fd_sc_hd__dfstp_1
X_11999_ cell0.SB0.route_sel\[105\] cell0.SB0.route_sel\[104\] net770 vssd1 vssd1
+ vccd1 vccd1 _00436_ sky130_fd_sc_hd__mux2_1
X_13738_ clknet_leaf_107_clk _00710_ net658 vssd1 vssd1 vccd1 vccd1 cell1.SB0.route_sel\[15\]
+ sky130_fd_sc_hd__dfstp_1
X_13669_ clknet_leaf_45_clk _00641_ net629 vssd1 vssd1 vccd1 vccd1 cell2.CB_1.config_dataA\[21\]
+ sky130_fd_sc_hd__dfstp_1
XANTENNA__08871__B _03841_ vssd1 vssd1 vccd1 vccd1 sky130_fd_sc_hd__diode_2
X_07190_ _02250_ net313 _02249_ vssd1 vssd1 vccd1 vccd1 _02251_ sky130_fd_sc_hd__mux2_1
XANTENNA__10775__A0 net21 vssd1 vssd1 vccd1 vccd1 sky130_fd_sc_hd__diode_2
XFILLER_117_458 vssd1 vssd1 vccd1 vccd1 sky130_fd_sc_hd__fill_2
XFILLER_117_447 vssd1 vssd1 vccd1 vccd1 sky130_fd_sc_hd__fill_1
XANTENNA__09917__C1 net351 vssd1 vssd1 vccd1 vccd1 sky130_fd_sc_hd__diode_2
X_09900_ _01822_ net305 cell2.LEI0.config_data\[42\] vssd1 vssd1 vccd1 vccd1 _04906_
+ sky130_fd_sc_hd__mux2_1
XTAP_TAPCELL_ROW_74_1420 vssd1 vccd1 sky130_fd_sc_hd__tapvpwrvgnd_1
XFILLER_6_83 vssd1 vssd1 vccd1 vccd1 sky130_fd_sc_hd__fill_1
XFILLER_116_29 vccd1 vssd1 vccd1 vssd1 sky130_ef_sc_hd__decap_40_12
Xfanout506 cell0.CB_1.config_dataB\[5\] vssd1 vssd1 vccd1 vccd1 net506 sky130_fd_sc_hd__clkbuf_2
XANTENNA_clkload13_A clknet_4_14_0_clk vssd1 vssd1 vccd1 vccd1 sky130_fd_sc_hd__diode_2
XFILLER_98_342 vssd1 vssd1 vccd1 vccd1 sky130_fd_sc_hd__fill_1
X_09831_ net441 net440 vssd1 vssd1 vccd1 vccd1 _04837_ sky130_fd_sc_hd__or2_1
XANTENNA__11296__Y net142 vssd1 vssd1 vccd1 vccd1 sky130_fd_sc_hd__diode_2
Xfanout528 cell0.CB_0.config_dataB\[10\] vssd1 vssd1 vccd1 vccd1 net528 sky130_fd_sc_hd__clkbuf_2
Xfanout517 cell0.CB_0.config_dataA\[6\] vssd1 vssd1 vccd1 vccd1 net517 sky130_fd_sc_hd__buf_2
Xfanout539 net540 vssd1 vssd1 vccd1 vccd1 net539 sky130_fd_sc_hd__buf_2
X_09762_ cell2.CB_1.config_dataA\[7\] _04766_ _04767_ vssd1 vssd1 vccd1 vccd1 _04768_
+ sky130_fd_sc_hd__and3_1
XFILLER_100_303 vssd1 vssd1 vccd1 vccd1 sky130_fd_sc_hd__fill_1
XANTENNA__07943__B2 bus2_0\[5\] vssd1 vssd1 vccd1 vccd1 sky130_fd_sc_hd__diode_2
XANTENNA__07943__A1 bus2_0\[4\] vssd1 vssd1 vccd1 vccd1 sky130_fd_sc_hd__diode_2
X_06974_ _02037_ _02039_ vssd1 vssd1 vccd1 vccd1 _02040_ sky130_fd_sc_hd__nor2_2
X_08713_ net455 _03533_ _03746_ net454 vssd1 vssd1 vccd1 vccd1 _03747_ sky130_fd_sc_hd__o211a_1
X_09693_ _04313_ _04654_ vssd1 vssd1 vccd1 vccd1 _04707_ sky130_fd_sc_hd__nor2_1
X_08644_ cell1.CB_1.config_dataB\[6\] _03676_ _03677_ vssd1 vssd1 vccd1 vccd1 _03678_
+ sky130_fd_sc_hd__a21oi_1
XFILLER_54_489 vssd1 vssd1 vccd1 vccd1 sky130_fd_sc_hd__fill_1
XFILLER_25_15 vccd1 vssd1 vccd1 vssd1 sky130_ef_sc_hd__decap_40_12
X_08575_ _03609_ _03610_ vssd1 vssd1 vccd1 vccd1 _03611_ sky130_fd_sc_hd__nor2_1
XANTENNA__11255__A1 _05148_ vssd1 vssd1 vccd1 vccd1 sky130_fd_sc_hd__diode_2
XTAP_TAPCELL_ROW_85_1582 vssd1 vccd1 sky130_fd_sc_hd__tapvpwrvgnd_1
X_07526_ cell1.SB0.route_sel\[121\] cell1.SB0.route_sel\[120\] _02577_ vssd1 vssd1
+ vccd1 vccd1 _02578_ sky130_fd_sc_hd__a21oi_1
XANTENNA__09877__B _04724_ vssd1 vssd1 vccd1 vccd1 sky130_fd_sc_hd__diode_2
X_07457_ _01888_ _02367_ bus3_1\[14\] vssd1 vssd1 vccd1 vccd1 _02511_ sky130_fd_sc_hd__o21ai_1
XFILLER_10_515 vssd1 vssd1 vccd1 vccd1 sky130_fd_sc_hd__fill_8
XANTENNA__06582__A cell2.SB0.config_data_out vssd1 vssd1 vccd1 vccd1 sky130_fd_sc_hd__diode_2
X_07388_ cell1.SB0.route_sel\[105\] cell1.SB0.route_sel\[104\] _02437_ _02443_ net874
+ vssd1 vssd1 vccd1 vccd1 _02444_ sky130_fd_sc_hd__a311o_4
X_06408_ cell0.SB0.route_sel\[99\] vssd1 vssd1 vccd1 vccd1 _01478_ sky130_fd_sc_hd__inv_2
X_09127_ _04148_ _04156_ cell1.CB_0.config_dataB\[19\] _04144_ vssd1 vssd1 vccd1 vccd1
+ _04157_ sky130_fd_sc_hd__a211o_1
XFILLER_136_745 vssd1 vssd1 vccd1 vccd1 sky130_fd_sc_hd__fill_1
X_09058_ net479 _03844_ vssd1 vssd1 vccd1 vccd1 _04088_ sky130_fd_sc_hd__nand2_1
XANTENNA__09620__B2 cell3.SB0.route_sel\[100\] vssd1 vssd1 vccd1 vccd1 sky130_fd_sc_hd__diode_2
XANTENNA__13533__SET_B net753 vssd1 vssd1 vccd1 vccd1 sky130_fd_sc_hd__diode_2
X_08009_ bus2_0\[0\] bus2_0\[1\] bus2_0\[2\] bus2_0\[3\] net530 net529 vssd1 vssd1
+ vccd1 vccd1 _03051_ sky130_fd_sc_hd__mux4_1
Xhold571 _00950_ vssd1 vssd1 vccd1 vccd1 net1530 sky130_fd_sc_hd__dlygate4sd3_1
XANTENNA__09384__A0 net13 vssd1 vssd1 vccd1 vccd1 sky130_fd_sc_hd__diode_2
Xhold560 cell1.LE_0B.config_data\[13\] vssd1 vssd1 vccd1 vccd1 net1519 sky130_fd_sc_hd__dlygate4sd3_1
XFILLER_2_725 vccd1 vssd1 vccd1 vssd1 sky130_ef_sc_hd__decap_40_12
X_11020_ _05884_ _05965_ _05972_ _05973_ cell3.CB_0.config_dataA\[12\] vssd1 vssd1
+ vccd1 vccd1 _05974_ sky130_fd_sc_hd__a2111o_1
XANTENNA__09923__A2 _04298_ vssd1 vssd1 vccd1 vccd1 sky130_fd_sc_hd__diode_2
Xhold582 cell1.LEI0.config_data\[12\] vssd1 vssd1 vccd1 vccd1 net1541 sky130_fd_sc_hd__dlygate4sd3_1
Xhold593 cell1.LE_0A.reset_val vssd1 vssd1 vccd1 vccd1 net1552 sky130_fd_sc_hd__dlygate4sd3_1
XANTENNA__08726__A3 _03498_ vssd1 vssd1 vccd1 vccd1 sky130_fd_sc_hd__diode_2
XFILLER_2_769 vccd1 vssd1 vccd1 vssd1 sky130_ef_sc_hd__decap_40_12
XFILLER_77_537 vssd1 vssd1 vccd1 vccd1 sky130_fd_sc_hd__fill_1
XFILLER_1_279 vssd1 vssd1 vccd1 vccd1 sky130_fd_sc_hd__fill_1
XFILLER_77_559 vssd1 vssd1 vccd1 vccd1 sky130_fd_sc_hd__fill_1
XANTENNA__08021__B _02585_ vssd1 vssd1 vccd1 vccd1 sky130_fd_sc_hd__diode_2
X_12971_ net1306 net1206 net928 vssd1 vssd1 vccd1 vccd1 _01399_ sky130_fd_sc_hd__mux2_1
XFILLER_85_581 vssd1 vssd1 vccd1 vccd1 sky130_fd_sc_hd__fill_4
XANTENNA__06757__A net344 vssd1 vssd1 vccd1 vccd1 sky130_fd_sc_hd__diode_2
X_11922_ cell0.SB0.route_sel\[28\] cell0.SB0.route_sel\[27\] net762 vssd1 vssd1 vccd1
+ vccd1 _00359_ sky130_fd_sc_hd__mux2_1
XFILLER_122_61 vssd1 vssd1 vccd1 vccd1 sky130_fd_sc_hd__fill_2
XFILLER_82_21 vssd1 vssd1 vccd1 vccd1 sky130_fd_sc_hd__fill_4
X_11853_ cell1.CB_0.config_dataB\[9\] cell1.CB_0.config_dataB\[8\] net895 vssd1 vssd1
+ vccd1 vccd1 _00290_ sky130_fd_sc_hd__mux2_1
XANTENNA__08675__C _03498_ vssd1 vssd1 vccd1 vccd1 sky130_fd_sc_hd__diode_2
X_10804_ _05478_ _05475_ net367 vssd1 vssd1 vccd1 vccd1 _05760_ sky130_fd_sc_hd__mux2_1
XANTENNA__10049__A2 _04298_ vssd1 vssd1 vccd1 vccd1 sky130_fd_sc_hd__diode_2
XFILLER_82_43 vssd1 vssd1 vccd1 vccd1 sky130_fd_sc_hd__fill_1
XTAP_TAPCELL_ROW_0_290 vssd1 vccd1 sky130_fd_sc_hd__tapvpwrvgnd_1
XFILLER_14_821 vssd1 vssd1 vccd1 vccd1 sky130_fd_sc_hd__fill_1
X_11784_ net1419 cell0.LEI0.config_data\[33\] net793 vssd1 vssd1 vccd1 vccd1 _00221_
+ sky130_fd_sc_hd__mux2_1
X_10735_ net371 cell3.CB_1.config_dataB\[1\] vssd1 vssd1 vccd1 vccd1 _05691_ sky130_fd_sc_hd__nor2_1
X_13523_ clknet_leaf_100_clk _00495_ net679 vssd1 vssd1 vccd1 vccd1 cell1.LE_1A.config_data\[10\]
+ sky130_fd_sc_hd__dfrtp_1
XFILLER_13_375 vssd1 vssd1 vccd1 vccd1 sky130_fd_sc_hd__fill_1
X_10666_ _05619_ _05622_ _05623_ _01790_ vssd1 vssd1 vccd1 vccd1 _05624_ sky130_fd_sc_hd__a22o_1
X_13454_ clknet_leaf_123_clk _00426_ net579 vssd1 vssd1 vccd1 vccd1 cell0.SB0.route_sel\[95\]
+ sky130_fd_sc_hd__dfstp_1
XANTENNA_output195_A net195 vssd1 vssd1 vccd1 vccd1 sky130_fd_sc_hd__diode_2
X_12405_ net400 cell2.CB_1.config_dataB\[14\] net832 vssd1 vssd1 vccd1 vccd1 _00838_
+ sky130_fd_sc_hd__mux2_1
X_13385_ clknet_leaf_133_clk _00357_ net556 vssd1 vssd1 vccd1 vccd1 cell0.SB0.route_sel\[26\]
+ sky130_fd_sc_hd__dfstp_1
X_10597_ _05486_ _05553_ _01787_ vssd1 vssd1 vccd1 vccd1 _05555_ sky130_fd_sc_hd__o21a_1
XANTENNA__07622__B1 bus2_0\[1\] vssd1 vssd1 vccd1 vccd1 sky130_fd_sc_hd__diode_2
X_12336_ cell1.SB0.route_sel\[74\] cell1.SB0.route_sel\[73\] net868 vssd1 vssd1 vccd1
+ vccd1 _00769_ sky130_fd_sc_hd__mux2_1
XTAP_TAPCELL_ROW_56_1150 vssd1 vccd1 sky130_fd_sc_hd__tapvpwrvgnd_1
XANTENNA__08178__A1 _02422_ vssd1 vssd1 vccd1 vccd1 sky130_fd_sc_hd__diode_2
X_12267_ cell1.SB0.route_sel\[5\] cell1.SB0.route_sel\[4\] net866 vssd1 vssd1 vccd1
+ vccd1 _00700_ sky130_fd_sc_hd__mux2_1
X_11218_ cell3.CB_0.config_dataB\[18\] _06162_ _06166_ _06169_ vssd1 vssd1 vccd1 vccd1
+ _06170_ sky130_fd_sc_hd__and4_1
X_12198_ cell2.CB_1.config_dataA\[11\] net442 net913 vssd1 vssd1 vccd1 vccd1 _00631_
+ sky130_fd_sc_hd__mux2_1
X_14006_ clknet_leaf_78_clk _00978_ net708 vssd1 vssd1 vccd1 vccd1 cell3.SB0.route_sel\[14\]
+ sky130_fd_sc_hd__dfstp_1
X_11149_ _05912_ _05916_ net387 vssd1 vssd1 vccd1 vccd1 _06101_ sky130_fd_sc_hd__mux2_1
XFILLER_110_601 vssd1 vssd1 vccd1 vccd1 sky130_fd_sc_hd__fill_4
X_06690_ cell2.CB_0.config_dataB\[18\] vssd1 vssd1 vccd1 vccd1 _01760_ sky130_fd_sc_hd__inv_2
XFILLER_76_581 vssd1 vssd1 vccd1 vccd1 sky130_fd_sc_hd__fill_2
XANTENNA__08350__A1 bus1_0\[9\] vssd1 vssd1 vccd1 vccd1 sky130_fd_sc_hd__diode_2
XFILLER_36_456 vssd1 vssd1 vccd1 vccd1 sky130_fd_sc_hd__fill_1
X_08360_ net504 _01877_ _03397_ net502 vssd1 vssd1 vccd1 vccd1 _03398_ sky130_fd_sc_hd__o211a_1
XANTENNA__08102__A1 bus2_0\[9\] vssd1 vssd1 vccd1 vccd1 sky130_fd_sc_hd__diode_2
X_07311_ bus3_1\[12\] _02368_ vssd1 vssd1 vccd1 vccd1 _02369_ sky130_fd_sc_hd__nand2_1
XANTENNA__06954__X _02020_ vssd1 vssd1 vccd1 vccd1 sky130_fd_sc_hd__diode_2
XANTENNA__07769__Y _02815_ vssd1 vssd1 vccd1 vccd1 sky130_fd_sc_hd__diode_2
X_08291_ net506 _02719_ _03328_ net505 vssd1 vssd1 vccd1 vccd1 _03329_ sky130_fd_sc_hd__o211a_1
X_07242_ _02298_ _02299_ _02300_ _02274_ vssd1 vssd1 vccd1 vccd1 _02301_ sky130_fd_sc_hd__a31o_2
X_07173_ _01471_ cell0.SB0.route_sel\[84\] _01472_ cell0.SB0.route_sel\[87\] _02233_
+ vssd1 vssd1 vccd1 vccd1 _02234_ sky130_fd_sc_hd__a221o_1
XFILLER_11_39 vccd1 vssd1 vccd1 vssd1 sky130_ef_sc_hd__decap_40_12
XFILLER_127_39 vccd1 vssd1 vccd1 vssd1 sky130_ef_sc_hd__decap_40_12
XFILLER_117_255 vssd1 vssd1 vccd1 vccd1 sky130_fd_sc_hd__fill_1
XANTENNA__07613__B1 bus1_0\[1\] vssd1 vssd1 vccd1 vccd1 sky130_fd_sc_hd__diode_2
XANTENNA__10763__A3 net291 vssd1 vssd1 vccd1 vccd1 sky130_fd_sc_hd__diode_2
XFILLER_99_640 vssd1 vssd1 vccd1 vccd1 sky130_fd_sc_hd__fill_1
XANTENNA__11748__A net755 vssd1 vssd1 vccd1 vccd1 sky130_fd_sc_hd__diode_2
XANTENNA__07945__B _02897_ vssd1 vssd1 vccd1 vccd1 sky130_fd_sc_hd__diode_2
Xfanout303 cell2.CB_1.le_outB vssd1 vssd1 vccd1 vccd1 net303 sky130_fd_sc_hd__clkbuf_4
Xfanout314 net316 vssd1 vssd1 vccd1 vccd1 net314 sky130_fd_sc_hd__clkbuf_4
XANTENNA__08169__A1 bus1_0\[4\] vssd1 vssd1 vccd1 vccd1 sky130_fd_sc_hd__diode_2
XANTENNA__08169__B2 bus1_0\[5\] vssd1 vssd1 vccd1 vccd1 sky130_fd_sc_hd__diode_2
X_09814_ net447 _04472_ _04819_ net446 vssd1 vssd1 vccd1 vccd1 _04820_ sky130_fd_sc_hd__o211a_1
XANTENNA__07916__A1 bus2_0\[7\] vssd1 vssd1 vccd1 vccd1 sky130_fd_sc_hd__diode_2
Xfanout347 cell0.CB_0.le_outB vssd1 vssd1 vccd1 vccd1 net347 sky130_fd_sc_hd__buf_2
Xfanout336 net337 vssd1 vssd1 vccd1 vccd1 net336 sky130_fd_sc_hd__buf_2
Xfanout325 _01831_ vssd1 vssd1 vccd1 vccd1 net325 sky130_fd_sc_hd__clkbuf_4
Xfanout369 cell3.CB_1.config_dataB\[5\] vssd1 vssd1 vccd1 vccd1 net369 sky130_fd_sc_hd__clkbuf_4
XFILLER_59_559 vssd1 vssd1 vccd1 vccd1 sky130_fd_sc_hd__fill_1
XANTENNA__07009__Y _02074_ vssd1 vssd1 vccd1 vccd1 sky130_fd_sc_hd__diode_2
Xfanout358 _02014_ vssd1 vssd1 vccd1 vccd1 net358 sky130_fd_sc_hd__buf_4
X_09745_ _04752_ _04396_ vssd1 vssd1 vccd1 vccd1 bus2_0\[4\] sky130_fd_sc_hd__and2b_4
XTAP_TAPCELL_ROW_87_1611 vssd1 vccd1 sky130_fd_sc_hd__tapvpwrvgnd_1
XFILLER_74_518 vssd1 vssd1 vccd1 vccd1 sky130_fd_sc_hd__fill_4
X_06957_ cell0.SB0.route_sel\[69\] cell0.SB0.route_sel\[68\] net95 vssd1 vssd1 vccd1
+ vccd1 _02023_ sky130_fd_sc_hd__a21boi_1
XANTENNA_fanout279_X net279 vssd1 vssd1 vccd1 vccd1 sky130_fd_sc_hd__diode_2
X_09676_ _04690_ _04688_ vssd1 vssd1 vccd1 vccd1 bus3_1\[13\] sky130_fd_sc_hd__and2b_2
X_06888_ _01953_ _01955_ vssd1 vssd1 vccd1 vccd1 _01956_ sky130_fd_sc_hd__and2_2
X_08627_ cell1.LE_1A.config_data\[1\] cell1.LE_1A.config_data\[0\] _03546_ vssd1 vssd1
+ vccd1 vccd1 _03663_ sky130_fd_sc_hd__mux2_1
XANTENNA_fanout825_A net827 vssd1 vssd1 vccd1 vccd1 sky130_fd_sc_hd__diode_2
XFILLER_27_489 vssd1 vssd1 vccd1 vccd1 sky130_fd_sc_hd__fill_1
XFILLER_14_139 vssd1 vssd1 vccd1 vccd1 sky130_fd_sc_hd__fill_1
XANTENNA__06864__X _01932_ vssd1 vssd1 vccd1 vccd1 sky130_fd_sc_hd__diode_2
X_08558_ net1 net12 net23 net26 net492 cell1.CB_1.config_dataA\[11\] vssd1 vssd1 vccd1
+ vccd1 _03594_ sky130_fd_sc_hd__mux4_1
XANTENNA__12976__A1 cell3.LE_0A.reset_val vssd1 vssd1 vccd1 vccd1 sky130_fd_sc_hd__diode_2
XANTENNA__10987__A0 _05874_ vssd1 vssd1 vccd1 vccd1 sky130_fd_sc_hd__diode_2
XFILLER_22_150 vssd1 vssd1 vccd1 vccd1 sky130_fd_sc_hd__fill_1
XTAP_TAPCELL_ROW_25_679 vssd1 vccd1 sky130_fd_sc_hd__tapvpwrvgnd_1
X_07509_ _01932_ _02325_ _02557_ _02559_ vssd1 vssd1 vccd1 vccd1 _02561_ sky130_fd_sc_hd__a211oi_1
X_08489_ net28 _03474_ _03478_ net27 cell1.CB_1.config_dataA\[3\] vssd1 vssd1 vccd1
+ vccd1 _03525_ sky130_fd_sc_hd__a221o_1
X_10520_ _04477_ _04484_ _04491_ _05477_ vssd1 vssd1 vccd1 vccd1 _05478_ sky130_fd_sc_hd__a211o_2
X_10451_ cell3.SB0.route_sel\[64\] cell3.SB0.route_sel\[65\] vssd1 vssd1 vccd1 vccd1
+ _05441_ sky130_fd_sc_hd__nor2_1
XTAP_TAPCELL_ROW_114_2018 vssd1 vccd1 sky130_fd_sc_hd__tapvpwrvgnd_1
XTAP_TAPCELL_ROW_98_1773 vssd1 vccd1 sky130_fd_sc_hd__tapvpwrvgnd_1
XANTENNA__10739__A0 net17 vssd1 vssd1 vccd1 vccd1 sky130_fd_sc_hd__diode_2
XANTENNA__08016__B _02301_ vssd1 vssd1 vccd1 vccd1 sky130_fd_sc_hd__diode_2
X_10382_ cell2.LE_0B.config_data\[3\] cell2.LE_0B.config_data\[2\] _05344_ vssd1 vssd1
+ vccd1 vccd1 _05381_ sky130_fd_sc_hd__mux2_1
XTAP_TAPCELL_ROW_98_1784 vssd1 vccd1 sky130_fd_sc_hd__tapvpwrvgnd_1
X_13170_ clknet_1_0__leaf_cell0.LE_1A.sel_clk _00142_ net751 vssd1 vssd1 vccd1 vccd1
+ cell0.LE_1A.dff0_out sky130_fd_sc_hd__dfrtp_1
XANTENNA__07604__B1 _02653_ vssd1 vssd1 vccd1 vccd1 sky130_fd_sc_hd__diode_2
X_12121_ cell1.LEI0.config_data\[3\] net1375 net904 vssd1 vssd1 vccd1 vccd1 _00554_
+ sky130_fd_sc_hd__mux2_1
XFILLER_2_533 vccd1 vssd1 vccd1 vssd1 sky130_ef_sc_hd__decap_40_12
Xhold390 cell2.LEI0.config_data\[38\] vssd1 vssd1 vccd1 vccd1 net1349 sky130_fd_sc_hd__dlygate4sd3_1
XANTENNA__09357__B1 net109 vssd1 vssd1 vccd1 vccd1 sky130_fd_sc_hd__diode_2
X_12052_ net1001 cell1.LE_1A.config_data\[2\] net890 vssd1 vssd1 vccd1 vccd1 _00488_
+ sky130_fd_sc_hd__mux2_1
X_11003_ _05921_ _05935_ _05955_ cell3.CB_0.config_dataA\[6\] cell3.CB_0.config_dataA\[7\]
+ vssd1 vssd1 vccd1 vccd1 _05957_ sky130_fd_sc_hd__a221o_1
XFILLER_89_161 vssd1 vssd1 vccd1 vccd1 sky130_fd_sc_hd__fill_1
XANTENNA__11703__A2 net548 vssd1 vssd1 vccd1 vccd1 sky130_fd_sc_hd__diode_2
XTAP_TAPCELL_ROW_129_2250 vssd1 vccd1 sky130_fd_sc_hd__tapvpwrvgnd_1
Xfanout870 net871 vssd1 vssd1 vccd1 vccd1 net870 sky130_fd_sc_hd__clkbuf_2
Xfanout881 net883 vssd1 vssd1 vccd1 vccd1 net881 sky130_fd_sc_hd__clkbuf_4
XTAP_TAPCELL_ROW_51_1080 vssd1 vccd1 sky130_fd_sc_hd__tapvpwrvgnd_1
Xfanout892 net898 vssd1 vssd1 vccd1 vccd1 net892 sky130_fd_sc_hd__clkbuf_4
XTAP_TAPCELL_ROW_5_382 vssd1 vccd1 sky130_fd_sc_hd__tapvpwrvgnd_1
XFILLER_37_209 vssd1 vssd1 vccd1 vccd1 sky130_fd_sc_hd__fill_1
X_12954_ cell3.LE_0B.reset_mode cell3.LE_0B.reset_val net957 vssd1 vssd1 vccd1 vccd1
+ _01382_ sky130_fd_sc_hd__mux2_1
XANTENNA_clkbuf_leaf_82_clk_A clknet_4_9_0_clk vssd1 vssd1 vccd1 vccd1 sky130_fd_sc_hd__diode_2
XANTENNA__11393__A _02037_ vssd1 vssd1 vccd1 vccd1 sky130_fd_sc_hd__diode_2
XTAP_TAPCELL_ROW_142_2450 vssd1 vccd1 sky130_fd_sc_hd__tapvpwrvgnd_1
X_11905_ cell0.SB0.route_sel\[11\] cell0.SB0.route_sel\[10\] net762 vssd1 vssd1 vccd1
+ vccd1 _00342_ sky130_fd_sc_hd__mux2_1
XANTENNA__08332__A1 bus1_0\[9\] vssd1 vssd1 vccd1 vccd1 sky130_fd_sc_hd__diode_2
X_12885_ cell2.SB0.config_data_out cell2.SB0.route_sel\[126\] net832 vssd1 vssd1 vccd1
+ vccd1 _01314_ sky130_fd_sc_hd__mux2_1
XANTENNA_output208_A net208 vssd1 vssd1 vccd1 vccd1 sky130_fd_sc_hd__diode_2
XANTENNA__10690__A2 net19 vssd1 vssd1 vccd1 vccd1 sky130_fd_sc_hd__diode_2
XTAP_TAPCELL_ROW_44_966 vssd1 vccd1 sky130_fd_sc_hd__tapvpwrvgnd_1
X_11836_ cell1.CB_1.config_dataA\[17\] cell1.CB_1.config_dataA\[16\] net889 vssd1
+ vssd1 vccd1 vccd1 _00273_ sky130_fd_sc_hd__mux2_1
XANTENNA__08096__A0 bus2_0\[12\] vssd1 vssd1 vccd1 vccd1 sky130_fd_sc_hd__diode_2
X_11767_ net1066 net1092 net775 vssd1 vssd1 vccd1 vccd1 _00204_ sky130_fd_sc_hd__mux2_1
XANTENNA_clkbuf_leaf_97_clk_A clknet_4_10_0_clk vssd1 vssd1 vccd1 vccd1 sky130_fd_sc_hd__diode_2
XANTENNA__08635__A2 _03533_ vssd1 vssd1 vccd1 vccd1 sky130_fd_sc_hd__diode_2
X_10718_ _05561_ _05675_ vssd1 vssd1 vccd1 vccd1 _05676_ sky130_fd_sc_hd__nor2_1
X_13506_ clknet_leaf_86_clk _00478_ net685 vssd1 vssd1 vccd1 vccd1 cell1.CB_1.config_dataB\[19\]
+ sky130_fd_sc_hd__dfstp_1
X_11698_ cell0.LE_1A.edge_mode net1088 net804 vssd1 vssd1 vccd1 vccd1 _00138_ sky130_fd_sc_hd__mux2_1
XFILLER_139_391 vssd1 vssd1 vccd1 vccd1 sky130_fd_sc_hd__fill_1
X_10649_ net393 _05540_ net392 vssd1 vssd1 vccd1 vccd1 _05607_ sky130_fd_sc_hd__o21ai_1
XANTENNA_clkbuf_leaf_20_clk_A clknet_4_4_0_clk vssd1 vssd1 vccd1 vccd1 sky130_fd_sc_hd__diode_2
X_13437_ clknet_leaf_129_clk _00409_ net578 vssd1 vssd1 vccd1 vccd1 cell0.SB0.route_sel\[78\]
+ sky130_fd_sc_hd__dfstp_1
X_13368_ clknet_leaf_132_clk _00340_ net577 vssd1 vssd1 vccd1 vccd1 cell0.SB0.route_sel\[9\]
+ sky130_fd_sc_hd__dfstp_1
XANTENNA__06950__A net358 vssd1 vssd1 vccd1 vccd1 sky130_fd_sc_hd__diode_2
XANTENNA__10745__A3 _05553_ vssd1 vssd1 vccd1 vccd1 sky130_fd_sc_hd__diode_2
X_12319_ cell1.SB0.route_sel\[57\] cell1.SB0.route_sel\[56\] net856 vssd1 vssd1 vccd1
+ vccd1 _00752_ sky130_fd_sc_hd__mux2_1
XANTENNA_clkbuf_leaf_35_clk_A clknet_4_7_0_clk vssd1 vssd1 vccd1 vccd1 sky130_fd_sc_hd__diode_2
XFILLER_47_3 vssd1 vssd1 vccd1 vccd1 sky130_fd_sc_hd__fill_1
XPHY_EDGE_ROW_39_Left_182 vssd1 vssd1 vccd1 vccd1 sky130_fd_sc_hd__decap_3
X_13299_ clknet_leaf_99_clk _00271_ net682 vssd1 vssd1 vccd1 vccd1 cell1.CB_1.config_dataA\[15\]
+ sky130_fd_sc_hd__dfstp_1
XFILLER_3_51 vssd1 vssd1 vccd1 vccd1 sky130_fd_sc_hd__fill_4
X_07860_ cell0.SB0.route_sel\[11\] cell0.SB0.route_sel\[10\] _01585_ cell0.SB0.route_sel\[13\]
+ _02903_ vssd1 vssd1 vccd1 vccd1 _02904_ sky130_fd_sc_hd__o221a_2
XFILLER_84_816 vssd1 vssd1 vccd1 vccd1 sky130_fd_sc_hd__fill_1
X_07791_ net359 net354 vssd1 vssd1 vccd1 vccd1 _02836_ sky130_fd_sc_hd__nor2_1
X_06811_ _01853_ _01878_ _01880_ vssd1 vssd1 vccd1 vccd1 _01881_ sky130_fd_sc_hd__a21o_1
X_06742_ cell3.CB_0.config_dataA\[17\] vssd1 vssd1 vccd1 vccd1 _01812_ sky130_fd_sc_hd__inv_2
X_09530_ cell3.SB0.route_sel\[64\] cell3.SB0.route_sel\[65\] _04542_ _04549_ net917
+ vssd1 vssd1 vccd1 vccd1 _04550_ sky130_fd_sc_hd__a311oi_2
XANTENNA__08596__B _03529_ vssd1 vssd1 vccd1 vccd1 sky130_fd_sc_hd__diode_2
X_09461_ _04478_ _04481_ _04476_ vssd1 vssd1 vccd1 vccd1 _04483_ sky130_fd_sc_hd__o21ai_1
XTAP_TAPCELL_ROW_69_1341 vssd1 vccd1 sky130_fd_sc_hd__tapvpwrvgnd_1
X_06673_ cell3.SB0.route_sel\[109\] vssd1 vssd1 vccd1 vccd1 _01743_ sky130_fd_sc_hd__inv_2
XPHY_EDGE_ROW_48_Left_191 vssd1 vssd1 vccd1 vccd1 sky130_fd_sc_hd__decap_3
X_09392_ net45 net277 _04413_ vssd1 vssd1 vccd1 vccd1 _04416_ sky130_fd_sc_hd__mux2_1
XTAP_TAPCELL_ROW_82_1541 vssd1 vccd1 sky130_fd_sc_hd__tapvpwrvgnd_1
X_08412_ cell0.LE_1B.config_data\[3\] cell0.LE_1B.config_data\[2\] _03380_ vssd1 vssd1
+ vccd1 vccd1 _03450_ sky130_fd_sc_hd__mux2_1
X_08343_ cell0.LE_1B.config_data\[5\] cell0.LE_1B.config_data\[4\] _03380_ vssd1 vssd1
+ vccd1 vccd1 _03381_ sky130_fd_sc_hd__mux2_1
XFILLER_11_109 vssd1 vssd1 vccd1 vccd1 sky130_fd_sc_hd__fill_2
XANTENNA__11091__C1 net351 vssd1 vssd1 vccd1 vccd1 sky130_fd_sc_hd__diode_2
X_08274_ cell0.LE_1A.config_data\[16\] _03311_ _03312_ net351 vssd1 vssd1 vccd1 vccd1
+ cell0.CB_1.le_outA sky130_fd_sc_hd__o211a_2
XANTENNA__06844__B _01912_ vssd1 vssd1 vccd1 vccd1 sky130_fd_sc_hd__diode_2
XANTENNA_clkbuf_leaf_108_clk_A clknet_4_8_0_clk vssd1 vssd1 vccd1 vccd1 sky130_fd_sc_hd__diode_2
XTAP_TAPCELL_ROW_22_638 vssd1 vccd1 sky130_fd_sc_hd__tapvpwrvgnd_1
XANTENNA__07021__A bus3_2\[8\] vssd1 vssd1 vccd1 vccd1 sky130_fd_sc_hd__diode_2
XFILLER_22_27 vssd1 vssd1 vccd1 vccd1 sky130_fd_sc_hd__fill_1
X_07225_ net321 net3 _02283_ vssd1 vssd1 vccd1 vccd1 _02285_ sky130_fd_sc_hd__mux2_1
XFILLER_138_27 vssd1 vssd1 vccd1 vccd1 sky130_fd_sc_hd__fill_1
XANTENNA__10984__A3 net52 vssd1 vssd1 vccd1 vccd1 sky130_fd_sc_hd__diode_2
XFILLER_118_9 vccd1 vssd1 vccd1 vssd1 sky130_ef_sc_hd__decap_40_12
X_07156_ _01837_ _02047_ vssd1 vssd1 vccd1 vccd1 _02218_ sky130_fd_sc_hd__nor2_1
X_07087_ cell1.CB_0.config_dataA\[24\] cell1.CB_0.config_dataA\[21\] cell1.CB_0.config_dataA\[20\]
+ vssd1 vssd1 vccd1 vccd1 _02151_ sky130_fd_sc_hd__or3b_1
XANTENNA__11146__A0 net40 vssd1 vssd1 vccd1 vccd1 sky130_fd_sc_hd__diode_2
XFILLER_87_698 vssd1 vssd1 vccd1 vccd1 sky130_fd_sc_hd__fill_1
XFILLER_87_665 vssd1 vssd1 vccd1 vccd1 sky130_fd_sc_hd__fill_4
XANTENNA__09235__X _04262_ vssd1 vssd1 vccd1 vccd1 sky130_fd_sc_hd__diode_2
XFILLER_86_164 vssd1 vssd1 vccd1 vccd1 sky130_fd_sc_hd__fill_1
X_09728_ cell3.SB0.route_sel\[120\] _01747_ vssd1 vssd1 vccd1 vccd1 _04741_ sky130_fd_sc_hd__nand2_1
XFILLER_86_197 vssd1 vssd1 vccd1 vccd1 sky130_fd_sc_hd__fill_1
X_07989_ _02388_ _03029_ _03030_ _02456_ _01558_ vssd1 vssd1 vccd1 vccd1 _03031_ sky130_fd_sc_hd__a221o_1
XTAP_TAPCELL_ROW_2_341 vssd1 vccd1 sky130_fd_sc_hd__tapvpwrvgnd_1
XPHY_EDGE_ROW_29_Right_29 vssd1 vssd1 vccd1 vccd1 sky130_fd_sc_hd__decap_3
XANTENNA_fanout828_X net828 vssd1 vssd1 vccd1 vccd1 sky130_fd_sc_hd__diode_2
X_09659_ _02450_ _04672_ _04673_ vssd1 vssd1 vccd1 vccd1 _04674_ sky130_fd_sc_hd__a21o_1
X_12670_ net1235 cell3.LE_1B.config_data\[6\] net954 vssd1 vssd1 vccd1 vccd1 _01099_
+ sky130_fd_sc_hd__mux2_1
XFILLER_63_45 vssd1 vssd1 vccd1 vccd1 sky130_fd_sc_hd__fill_1
XANTENNA_input106_A SBwest_in[18] vssd1 vssd1 vccd1 vccd1 sky130_fd_sc_hd__diode_2
XANTENNA__09411__A net110 vssd1 vssd1 vccd1 vccd1 sky130_fd_sc_hd__diode_2
XANTENNA__08078__B1 _03119_ vssd1 vssd1 vccd1 vccd1 sky130_fd_sc_hd__diode_2
X_11621_ cell0.CB_0.config_dataB\[17\] net523 net774 vssd1 vssd1 vccd1 vccd1 _00062_
+ sky130_fd_sc_hd__mux2_1
XTAP_TAPCELL_ROW_41_925 vssd1 vccd1 sky130_fd_sc_hd__tapvpwrvgnd_1
X_14340_ clknet_leaf_16_clk _01312_ net626 vssd1 vssd1 vccd1 vccd1 cell2.SB0.route_sel\[125\]
+ sky130_fd_sc_hd__dfstp_1
XFILLER_8_29 vccd1 vssd1 vccd1 vssd1 sky130_ef_sc_hd__decap_40_12
X_11552_ _06368_ _02716_ vssd1 vssd1 vccd1 vccd1 net252 sky130_fd_sc_hd__and2b_1
XPHY_EDGE_ROW_38_Right_38 vssd1 vssd1 vccd1 vccd1 sky130_fd_sc_hd__decap_3
X_14271_ clknet_leaf_24_clk _01243_ net605 vssd1 vssd1 vccd1 vccd1 cell2.SB0.route_sel\[56\]
+ sky130_fd_sc_hd__dfstp_1
X_10503_ _01837_ _02047_ _03465_ vssd1 vssd1 vccd1 vccd1 _05467_ sky130_fd_sc_hd__o21ai_1
X_11483_ _02515_ _06322_ vssd1 vssd1 vccd1 vccd1 net221 sky130_fd_sc_hd__nor2_1
X_10434_ cell3.SB0.route_sel\[16\] cell3.SB0.route_sel\[17\] _01693_ cell3.SB0.route_sel\[20\]
+ _05429_ vssd1 vssd1 vccd1 vccd1 _05430_ sky130_fd_sc_hd__o221a_1
X_13222_ clknet_leaf_122_clk _00194_ net593 vssd1 vssd1 vccd1 vccd1 cell0.LEI0.config_data\[7\]
+ sky130_fd_sc_hd__dfrtp_1
XFILLER_7_669 vssd1 vssd1 vccd1 vccd1 sky130_fd_sc_hd__fill_2
XANTENNA_input71_A SBsouth_in[15] vssd1 vssd1 vccd1 vccd1 sky130_fd_sc_hd__diode_2
XANTENNA__06770__A net29 vssd1 vssd1 vccd1 vccd1 sky130_fd_sc_hd__diode_2
X_10365_ net429 _05103_ _05363_ vssd1 vssd1 vccd1 vccd1 _05364_ sky130_fd_sc_hd__a21o_1
X_13153_ clknet_leaf_120_clk net1248 net595 vssd1 vssd1 vccd1 vccd1 cell0.LE_1A.config_data\[4\]
+ sky130_fd_sc_hd__dfrtp_1
X_12104_ net1177 cell1.LE_0A.config_data\[8\] net876 vssd1 vssd1 vccd1 vccd1 _00538_
+ sky130_fd_sc_hd__mux2_1
X_10296_ net36 net37 net38 net39 net432 cell2.CB_0.config_dataB\[6\] vssd1 vssd1 vccd1
+ vccd1 _05295_ sky130_fd_sc_hd__mux4_1
X_13084_ clknet_leaf_4_clk _00056_ net564 vssd1 vssd1 vccd1 vccd1 cell0.CB_0.config_dataB\[11\]
+ sky130_fd_sc_hd__dfstp_1
XFILLER_2_363 vssd1 vssd1 vccd1 vccd1 sky130_fd_sc_hd__fill_1
XTAP_TAPCELL_ROW_127_2209 vssd1 vccd1 sky130_fd_sc_hd__tapvpwrvgnd_1
XANTENNA__12885__A0 cell2.SB0.config_data_out vssd1 vssd1 vccd1 vccd1 sky130_fd_sc_hd__diode_2
XFILLER_26_8 vccd1 vssd1 vccd1 vssd1 sky130_ef_sc_hd__decap_40_12
X_12035_ cell1.CB_1.config_dataB\[13\] cell1.CB_1.config_dataB\[12\] net891 vssd1
+ vssd1 vccd1 vccd1 _00472_ sky130_fd_sc_hd__mux2_1
XFILLER_120_784 vssd1 vssd1 vccd1 vccd1 sky130_fd_sc_hd__fill_1
XPHY_EDGE_ROW_47_Right_47 vssd1 vssd1 vccd1 vccd1 sky130_fd_sc_hd__decap_3
XANTENNA__08553__B2 _03537_ vssd1 vssd1 vccd1 vccd1 sky130_fd_sc_hd__diode_2
XANTENNA__08553__A1 _03540_ vssd1 vssd1 vccd1 vccd1 sky130_fd_sc_hd__diode_2
XTAP_TAPCELL_ROW_140_2409 vssd1 vccd1 sky130_fd_sc_hd__tapvpwrvgnd_1
X_13986_ clknet_leaf_43_clk _00958_ net633 vssd1 vssd1 vccd1 vccd1 cell2.LEI0.config_data\[43\]
+ sky130_fd_sc_hd__dfrtp_1
XTAP_TAPCELL_ROW_109_1942 vssd1 vccd1 sky130_fd_sc_hd__tapvpwrvgnd_1
XANTENNA__08305__A1 net347 vssd1 vssd1 vccd1 vccd1 sky130_fd_sc_hd__diode_2
X_12937_ net1015 cell3.LE_0B.config_data\[1\] net931 vssd1 vssd1 vccd1 vccd1 _01365_
+ sky130_fd_sc_hd__mux2_1
XFILLER_80_318 vssd1 vssd1 vccd1 vccd1 sky130_fd_sc_hd__fill_1
XFILLER_18_264 vssd1 vssd1 vccd1 vccd1 sky130_fd_sc_hd__fill_1
XFILLER_34_713 vssd1 vssd1 vccd1 vccd1 sky130_fd_sc_hd__fill_1
X_12868_ cell2.SB0.route_sel\[110\] cell2.SB0.route_sel\[109\] net810 vssd1 vssd1
+ vccd1 vccd1 _01297_ sky130_fd_sc_hd__mux2_1
XFILLER_33_234 vssd1 vssd1 vccd1 vccd1 sky130_fd_sc_hd__fill_1
X_11819_ cell1.CB_1.config_dataA\[0\] cell1.CB_0.config_dataB\[24\] net892 vssd1 vssd1
+ vccd1 vccd1 _00256_ sky130_fd_sc_hd__mux2_1
X_12799_ cell2.SB0.route_sel\[41\] cell2.SB0.route_sel\[40\] net819 vssd1 vssd1 vccd1
+ vccd1 _01228_ sky130_fd_sc_hd__mux2_1
XTAP_TAPCELL_ROW_64_1271 vssd1 vccd1 sky130_fd_sc_hd__tapvpwrvgnd_1
XPHY_EDGE_ROW_56_Right_56 vssd1 vssd1 vccd1 vccd1 sky130_fd_sc_hd__decap_3
XFILLER_42_790 vssd1 vssd1 vccd1 vccd1 sky130_fd_sc_hd__fill_1
XANTENNA__08608__A2 net6 vssd1 vssd1 vccd1 vccd1 sky130_fd_sc_hd__diode_2
XFILLER_21_429 vssd1 vssd1 vccd1 vccd1 sky130_fd_sc_hd__fill_1
X_14469_ clknet_leaf_60_clk _01441_ net740 vssd1 vssd1 vccd1 vccd1 cell3.LEI0.config_data\[34\]
+ sky130_fd_sc_hd__dfrtp_1
XANTENNA__10179__A1 net44 vssd1 vssd1 vccd1 vccd1 sky130_fd_sc_hd__diode_2
X_07010_ _02033_ _02037_ _02073_ _02034_ vssd1 vssd1 vccd1 vccd1 _02075_ sky130_fd_sc_hd__o31a_1
XFILLER_5_190 vssd1 vssd1 vccd1 vccd1 sky130_fd_sc_hd__fill_4
XFILLER_103_729 vssd1 vssd1 vccd1 vccd1 sky130_fd_sc_hd__fill_1
XFILLER_102_206 vssd1 vssd1 vccd1 vccd1 sky130_fd_sc_hd__fill_1
XPHY_EDGE_ROW_65_Right_65 vssd1 vssd1 vccd1 vccd1 sky130_fd_sc_hd__decap_3
X_08961_ _01683_ _03992_ vssd1 vssd1 vccd1 vccd1 _03993_ sky130_fd_sc_hd__nand2_1
XFILLER_124_29 vccd1 vssd1 vccd1 vssd1 sky130_ef_sc_hd__decap_40_12
XANTENNA__10930__A _05883_ vssd1 vssd1 vccd1 vccd1 sky130_fd_sc_hd__diode_2
X_08892_ bus3_1\[6\] bus3_1\[7\] net473 vssd1 vssd1 vccd1 vccd1 _03924_ sky130_fd_sc_hd__mux2_1
X_07912_ _02887_ _02951_ _02952_ _02890_ _01573_ vssd1 vssd1 vccd1 vccd1 _02956_ sky130_fd_sc_hd__a221o_1
XFILLER_84_613 vssd1 vssd1 vccd1 vccd1 sky130_fd_sc_hd__fill_2
X_07843_ _02804_ _02886_ vssd1 vssd1 vccd1 vccd1 _02887_ sky130_fd_sc_hd__and2_2
XFILLER_68_197 vssd1 vssd1 vccd1 vccd1 sky130_fd_sc_hd__fill_1
XFILLER_17_27 vccd1 vssd1 vccd1 vssd1 sky130_ef_sc_hd__decap_40_12
XTAP_TAPCELL_ROW_27_708 vssd1 vccd1 sky130_fd_sc_hd__tapvpwrvgnd_1
X_07774_ cell1.SB0.route_sel\[32\] cell1.SB0.route_sel\[33\] _02813_ _02819_ net861
+ vssd1 vssd1 vccd1 vccd1 _02820_ sky130_fd_sc_hd__a311o_2
X_06725_ cell3.CB_0.config_dataB\[2\] vssd1 vssd1 vccd1 vccd1 _01795_ sky130_fd_sc_hd__inv_2
XANTENNA__10929__X _05883_ vssd1 vssd1 vccd1 vccd1 sky130_fd_sc_hd__diode_2
X_09513_ cell3.SB0.route_sel\[69\] cell3.SB0.route_sel\[68\] _02066_ _04532_ _02060_
+ vssd1 vssd1 vccd1 vccd1 _04533_ sky130_fd_sc_hd__a221o_1
XTAP_TAPCELL_ROW_27_719 vssd1 vccd1 sky130_fd_sc_hd__tapvpwrvgnd_1
X_06656_ cell3.SB0.route_sel\[78\] vssd1 vssd1 vccd1 vccd1 _01726_ sky130_fd_sc_hd__inv_2
X_09444_ _01897_ _03884_ _01891_ vssd1 vssd1 vccd1 vccd1 _04466_ sky130_fd_sc_hd__or3b_1
XPHY_EDGE_ROW_74_Right_74 vssd1 vssd1 vccd1 vccd1 sky130_fd_sc_hd__decap_3
XFILLER_25_779 vssd1 vssd1 vccd1 vccd1 sky130_fd_sc_hd__fill_1
XFILLER_33_15 vccd1 vssd1 vccd1 vssd1 sky130_ef_sc_hd__decap_40_12
X_09375_ _04398_ _04396_ vssd1 vssd1 vccd1 vccd1 _04399_ sky130_fd_sc_hd__and2b_2
X_06587_ cell1.CB_1.config_dataB\[9\] vssd1 vssd1 vccd1 vccd1 _01657_ sky130_fd_sc_hd__inv_2
XANTENNA__10096__B _05096_ vssd1 vssd1 vccd1 vccd1 sky130_fd_sc_hd__diode_2
X_08326_ _03349_ _03352_ _03359_ _03363_ vssd1 vssd1 vccd1 vccd1 _03364_ sky130_fd_sc_hd__o211a_1
X_08257_ net344 net347 cell0.CB_1.le_outA cell0.CB_1.le_outB cell0.LEI0.config_data\[42\]
+ cell0.LEI0.config_data\[43\] vssd1 vssd1 vccd1 vccd1 _03297_ sky130_fd_sc_hd__mux4_1
XFILLER_20_473 vssd1 vssd1 vccd1 vccd1 sky130_fd_sc_hd__fill_2
X_07208_ _01943_ _02027_ vssd1 vssd1 vccd1 vccd1 _02268_ sky130_fd_sc_hd__or2_1
X_08188_ _03214_ _03215_ _03227_ cell0.CB_1.config_dataA\[9\] vssd1 vssd1 vccd1 vccd1
+ _03228_ sky130_fd_sc_hd__a211oi_1
XFILLER_134_810 vssd1 vssd1 vccd1 vccd1 sky130_fd_sc_hd__fill_2
XTAP_TAPCELL_ROW_95_1732 vssd1 vccd1 sky130_fd_sc_hd__tapvpwrvgnd_1
X_07139_ _01862_ _02027_ vssd1 vssd1 vccd1 vccd1 _02201_ sky130_fd_sc_hd__nor2_1
XANTENNA_fanout892_A net898 vssd1 vssd1 vccd1 vccd1 sky130_fd_sc_hd__diode_2
XFILLER_3_105 vssd1 vssd1 vccd1 vccd1 sky130_fd_sc_hd__fill_4
XPHY_EDGE_ROW_83_Right_83 vssd1 vssd1 vccd1 vccd1 sky130_fd_sc_hd__decap_3
XFILLER_3_149 vccd1 vssd1 vccd1 vssd1 sky130_ef_sc_hd__decap_40_12
X_10150_ _01582_ cell2.SB0.route_sel\[14\] cell2.SB0.route_sel\[13\] _01583_ _05150_
+ vssd1 vssd1 vccd1 vccd1 _05151_ sky130_fd_sc_hd__o221a_1
XTAP_TAPCELL_ROW_7_411 vssd1 vccd1 sky130_fd_sc_hd__tapvpwrvgnd_1
XFILLER_102_740 vssd1 vssd1 vccd1 vccd1 sky130_fd_sc_hd__fill_1
X_10081_ cell2.SB0.route_sel\[91\] cell2.SB0.route_sel\[90\] vssd1 vssd1 vccd1 vccd1
+ _05082_ sky130_fd_sc_hd__nor2_1
XANTENNA__11495__X net239 vssd1 vssd1 vccd1 vccd1 sky130_fd_sc_hd__diode_2
XFILLER_0_845 vssd1 vssd1 vccd1 vccd1 sky130_fd_sc_hd__fill_1
XANTENNA__09406__A bus3_2\[5\] vssd1 vssd1 vccd1 vccd1 sky130_fd_sc_hd__diode_2
XFILLER_58_67 vssd1 vssd1 vccd1 vccd1 sky130_fd_sc_hd__fill_1
X_13840_ clknet_leaf_114_clk _00812_ net673 vssd1 vssd1 vccd1 vccd1 cell1.SB0.route_sel\[117\]
+ sky130_fd_sc_hd__dfstp_1
X_10983_ net53 net54 net56 net57 net377 net376 vssd1 vssd1 vccd1 vccd1 _05937_ sky130_fd_sc_hd__mux4_1
XTAP_TAPCELL_ROW_122_2139 vssd1 vccd1 sky130_fd_sc_hd__tapvpwrvgnd_1
XFILLER_90_616 vssd1 vssd1 vccd1 vccd1 sky130_fd_sc_hd__fill_1
XFILLER_74_44 vssd1 vssd1 vccd1 vccd1 sky130_fd_sc_hd__fill_1
XANTENNA__12095__A1 cell0.SB0.config_data_out vssd1 vssd1 vccd1 vccd1 sky130_fd_sc_hd__diode_2
X_13771_ clknet_leaf_110_clk _00743_ net656 vssd1 vssd1 vccd1 vccd1 cell1.SB0.route_sel\[48\]
+ sky130_fd_sc_hd__dfstp_1
X_12722_ cell3.CB_0.config_dataB\[14\] cell3.CB_0.config_dataB\[13\] net932 vssd1
+ vssd1 vccd1 vccd1 _01151_ sky130_fd_sc_hd__mux2_1
XPHY_EDGE_ROW_92_Right_92 vssd1 vssd1 vccd1 vccd1 sky130_fd_sc_hd__decap_3
XPHY_EDGE_ROW_133_Right_133 vssd1 vssd1 vccd1 vccd1 sky130_fd_sc_hd__decap_3
XTAP_TAPCELL_ROW_104_1861 vssd1 vccd1 sky130_fd_sc_hd__tapvpwrvgnd_1
XFILLER_90_21 vssd1 vssd1 vccd1 vccd1 sky130_fd_sc_hd__fill_4
XANTENNA__06765__A bus2_0\[8\] vssd1 vssd1 vccd1 vccd1 sky130_fd_sc_hd__diode_2
XANTENNA_input109_X net109 vssd1 vssd1 vccd1 vccd1 sky130_fd_sc_hd__diode_2
XANTENNA__11390__B net267 vssd1 vssd1 vccd1 vccd1 sky130_fd_sc_hd__diode_2
XANTENNA__08309__X _03347_ vssd1 vssd1 vccd1 vccd1 sky130_fd_sc_hd__diode_2
XTAP_TAPCELL_ROW_104_1872 vssd1 vccd1 sky130_fd_sc_hd__tapvpwrvgnd_1
X_12653_ cell3.SB0.route_sel\[118\] cell3.SB0.route_sel\[117\] net921 vssd1 vssd1
+ vccd1 vccd1 _01082_ sky130_fd_sc_hd__mux2_1
XFILLER_90_43 vssd1 vssd1 vccd1 vccd1 sky130_fd_sc_hd__fill_1
X_12584_ cell3.SB0.route_sel\[49\] cell3.SB0.route_sel\[48\] net921 vssd1 vssd1 vccd1
+ vccd1 _01013_ sky130_fd_sc_hd__mux2_1
X_11604_ net533 cell0.CB_0.config_dataA\[24\] net779 vssd1 vssd1 vccd1 vccd1 _00045_
+ sky130_fd_sc_hd__mux2_1
XTAP_TAPCELL_ROW_137_2360 vssd1 vccd1 sky130_fd_sc_hd__tapvpwrvgnd_1
X_14323_ clknet_leaf_21_clk _01295_ net612 vssd1 vssd1 vccd1 vccd1 cell2.SB0.route_sel\[108\]
+ sky130_fd_sc_hd__dfstp_1
XANTENNA__12706__S net940 vssd1 vssd1 vccd1 vccd1 sky130_fd_sc_hd__diode_2
X_11535_ _01815_ cell0.SB0.route_sel\[0\] vssd1 vssd1 vccd1 vccd1 _06357_ sky130_fd_sc_hd__nand2_1
XFILLER_139_81 vccd1 vssd1 vccd1 vssd1 sky130_ef_sc_hd__decap_40_12
X_14254_ clknet_leaf_19_clk _01226_ net615 vssd1 vssd1 vccd1 vccd1 cell2.SB0.route_sel\[39\]
+ sky130_fd_sc_hd__dfstp_1
XANTENNA__11610__S net773 vssd1 vssd1 vccd1 vccd1 sky130_fd_sc_hd__diode_2
XFILLER_109_372 vssd1 vssd1 vccd1 vccd1 sky130_fd_sc_hd__fill_1
XFILLER_99_74 vssd1 vssd1 vccd1 vccd1 sky130_fd_sc_hd__fill_1
XANTENNA__07026__A1 net301 vssd1 vssd1 vccd1 vccd1 sky130_fd_sc_hd__diode_2
X_13205_ clknet_leaf_23_clk _00177_ net603 vssd1 vssd1 vccd1 vccd1 cell0.LE_0A.config_data\[12\]
+ sky130_fd_sc_hd__dfrtp_1
X_11466_ _01529_ cell1.SB0.route_sel\[75\] vssd1 vssd1 vccd1 vccd1 _06311_ sky130_fd_sc_hd__nand2_1
X_10417_ _05414_ _05415_ _05309_ vssd1 vssd1 vccd1 vccd1 _05416_ sky130_fd_sc_hd__mux2_1
X_14185_ clknet_leaf_58_clk _01157_ net720 vssd1 vssd1 vccd1 vccd1 cell3.CB_0.config_dataB\[20\]
+ sky130_fd_sc_hd__dfstp_1
X_11397_ cell0.SB0.route_sel\[73\] cell0.SB0.route_sel\[72\] vssd1 vssd1 vccd1 vccd1
+ _06265_ sky130_fd_sc_hd__nand2b_1
XFILLER_140_813 vccd1 vssd1 vccd1 vssd1 sky130_ef_sc_hd__decap_40_12
X_10348_ net428 _05128_ _05346_ vssd1 vssd1 vccd1 vccd1 _05347_ sky130_fd_sc_hd__a21o_1
X_13136_ clknet_leaf_127_clk _00108_ net581 vssd1 vssd1 vccd1 vccd1 cell0.CB_1.config_dataB\[13\]
+ sky130_fd_sc_hd__dfstp_1
XANTENNA__06785__B1 bus1_0\[6\] vssd1 vssd1 vccd1 vccd1 sky130_fd_sc_hd__diode_2
X_10279_ net431 _05128_ vssd1 vssd1 vccd1 vccd1 _05278_ sky130_fd_sc_hd__nand2_1
X_13067_ clknet_leaf_125_clk _00039_ net583 vssd1 vssd1 vccd1 vccd1 cell0.CB_1.config_dataA\[19\]
+ sky130_fd_sc_hd__dfstp_1
XANTENNA__09723__A0 net57 vssd1 vssd1 vccd1 vccd1 sky130_fd_sc_hd__diode_2
X_12018_ cell0.SB0.route_sel\[124\] cell0.SB0.route_sel\[123\] net791 vssd1 vssd1
+ vccd1 vccd1 _00455_ sky130_fd_sc_hd__mux2_1
XFILLER_2_193 vssd1 vssd1 vccd1 vccd1 sky130_fd_sc_hd__fill_2
XFILLER_19_551 vssd1 vssd1 vccd1 vccd1 sky130_fd_sc_hd__fill_8
X_13969_ clknet_leaf_34_clk net1317 net638 vssd1 vssd1 vccd1 vccd1 cell2.LEI0.config_data\[26\]
+ sky130_fd_sc_hd__dfrtp_1
XFILLER_80_115 vssd1 vssd1 vccd1 vccd1 sky130_fd_sc_hd__fill_2
XTAP_TAPCELL_ROW_66_1300 vssd1 vccd1 sky130_fd_sc_hd__tapvpwrvgnd_1
XFILLER_0_41 vccd1 vssd1 vccd1 vssd1 sky130_ef_sc_hd__decap_40_12
X_06510_ cell2.SB0.route_sel\[11\] vssd1 vssd1 vccd1 vccd1 _01580_ sky130_fd_sc_hd__inv_2
XANTENNA__13578__RESET_B net751 vssd1 vssd1 vccd1 vccd1 sky130_fd_sc_hd__diode_2
X_07490_ net349 _01931_ _02323_ vssd1 vssd1 vccd1 vccd1 _02542_ sky130_fd_sc_hd__and3_1
X_06441_ cell1.SB0.route_sel\[30\] vssd1 vssd1 vccd1 vccd1 _01511_ sky130_fd_sc_hd__inv_2
XPHY_EDGE_ROW_100_Right_100 vssd1 vssd1 vccd1 vccd1 sky130_fd_sc_hd__decap_3
XFILLER_61_395 vssd1 vssd1 vccd1 vccd1 sky130_fd_sc_hd__fill_1
X_09160_ _02094_ _04187_ vssd1 vssd1 vccd1 vccd1 _04188_ sky130_fd_sc_hd__nand2_1
XANTENNA__08057__A3 bus2_0\[11\] vssd1 vssd1 vccd1 vccd1 sky130_fd_sc_hd__diode_2
X_08111_ cell0.LE_0B.config_data\[1\] cell0.LE_0B.config_data\[0\] _03087_ vssd1 vssd1
+ vccd1 vccd1 _03153_ sky130_fd_sc_hd__mux2_1
X_09091_ _04120_ vssd1 vssd1 vccd1 vccd1 _04121_ sky130_fd_sc_hd__inv_2
XANTENNA__07777__Y bus1_0\[4\] vssd1 vssd1 vccd1 vccd1 sky130_fd_sc_hd__diode_2
XTAP_TAPCELL_ROW_32_788 vssd1 vccd1 sky130_fd_sc_hd__tapvpwrvgnd_1
XANTENNA__10925__A net274 vssd1 vssd1 vccd1 vccd1 sky130_fd_sc_hd__diode_2
X_08042_ _03077_ _03083_ _01557_ _03070_ vssd1 vssd1 vccd1 vccd1 _03084_ sky130_fd_sc_hd__o211a_1
XTAP_TAPCELL_ROW_12_490 vssd1 vccd1 sky130_fd_sc_hd__tapvpwrvgnd_1
XTAP_TAPCELL_ROW_77_1462 vssd1 vccd1 sky130_fd_sc_hd__tapvpwrvgnd_1
X_09993_ net404 net402 vssd1 vssd1 vccd1 vccd1 _04997_ sky130_fd_sc_hd__nor2_1
XFILLER_1_609 vssd1 vssd1 vccd1 vccd1 sky130_fd_sc_hd__fill_4
XFILLER_135_39 vccd1 vssd1 vccd1 vssd1 sky130_ef_sc_hd__decap_40_12
XTAP_TAPCELL_ROW_90_1651 vssd1 vccd1 sky130_fd_sc_hd__tapvpwrvgnd_1
X_08944_ cell1.CB_0.config_dataA\[18\] cell1.CB_0.config_dataA\[17\] _03975_ vssd1
+ vssd1 vccd1 vccd1 _03976_ sky130_fd_sc_hd__o21ai_1
XTAP_TAPCELL_ROW_90_1662 vssd1 vccd1 sky130_fd_sc_hd__tapvpwrvgnd_1
XFILLER_111_592 vccd1 vssd1 vccd1 vssd1 sky130_ef_sc_hd__decap_40_12
XFILLER_111_581 vssd1 vssd1 vccd1 vccd1 sky130_fd_sc_hd__fill_4
XANTENNA__11521__B1 cell2.SB0.route_sel\[92\] vssd1 vssd1 vccd1 vccd1 sky130_fd_sc_hd__diode_2
X_08875_ _03849_ _03905_ _03906_ _03853_ cell1.CB_0.config_dataA\[2\] vssd1 vssd1
+ vccd1 vccd1 _03907_ sky130_fd_sc_hd__a221o_1
X_07826_ net517 net518 vssd1 vssd1 vccd1 vccd1 _02870_ sky130_fd_sc_hd__and2b_1
XANTENNA_fanout640_A net650 vssd1 vssd1 vccd1 vccd1 sky130_fd_sc_hd__diode_2
X_07757_ _02799_ _02802_ _02790_ vssd1 vssd1 vccd1 vccd1 _02803_ sky130_fd_sc_hd__o21ai_1
X_06708_ net371 vssd1 vssd1 vccd1 vccd1 _01778_ sky130_fd_sc_hd__inv_2
X_07688_ _02734_ _02735_ _02733_ vssd1 vssd1 vccd1 vccd1 _02736_ sky130_fd_sc_hd__a21oi_1
X_06639_ cell3.SB0.route_sel\[49\] vssd1 vssd1 vccd1 vccd1 _01709_ sky130_fd_sc_hd__inv_2
X_09427_ _04228_ _04403_ vssd1 vssd1 vccd1 vccd1 _04450_ sky130_fd_sc_hd__nor2_1
XANTENNA_fanout905_A net907 vssd1 vssd1 vccd1 vccd1 sky130_fd_sc_hd__diode_2
XFILLER_9_709 vccd1 vssd1 vccd1 vssd1 sky130_ef_sc_hd__decap_40_12
XFILLER_13_727 vssd1 vssd1 vccd1 vccd1 sky130_fd_sc_hd__fill_1
X_09358_ _01868_ _02031_ _02804_ _02886_ vssd1 vssd1 vccd1 vccd1 _04382_ sky130_fd_sc_hd__o211a_1
XFILLER_12_248 vssd1 vssd1 vccd1 vccd1 sky130_fd_sc_hd__fill_2
X_08309_ _03327_ _03341_ _03346_ vssd1 vssd1 vccd1 vccd1 _03347_ sky130_fd_sc_hd__a21o_2
XTAP_TAPCELL_ROW_119_2090 vssd1 vccd1 sky130_fd_sc_hd__tapvpwrvgnd_1
X_09289_ cell3.CB_0.config_dataA\[24\] cell3.CB_0.config_dataA\[20\] cell3.CB_0.config_dataA\[21\]
+ vssd1 vssd1 vccd1 vccd1 _04315_ sky130_fd_sc_hd__or3b_2
X_11320_ net296 _04650_ _04651_ _06225_ vssd1 vssd1 vccd1 vccd1 net154 sky130_fd_sc_hd__a22o_1
XFILLER_20_270 vssd1 vssd1 vccd1 vccd1 sky130_fd_sc_hd__fill_1
X_11251_ net306 _05156_ _04188_ vssd1 vssd1 vccd1 vccd1 _06193_ sky130_fd_sc_hd__mux2_1
XANTENNA__10012__A0 bus3_2\[0\] vssd1 vssd1 vccd1 vccd1 sky130_fd_sc_hd__diode_2
XFILLER_140_109 vssd1 vssd1 vccd1 vccd1 sky130_fd_sc_hd__fill_1
X_11182_ net384 _06132_ _06133_ cell3.CB_0.config_dataB\[12\] vssd1 vssd1 vccd1 vccd1
+ _06134_ sky130_fd_sc_hd__a211o_1
XTAP_TAPCELL_ROW_132_2290 vssd1 vccd1 sky130_fd_sc_hd__tapvpwrvgnd_1
X_10202_ _05111_ _05200_ _05202_ _05199_ vssd1 vssd1 vccd1 vccd1 _05203_ sky130_fd_sc_hd__a211o_1
XFILLER_106_375 vssd1 vssd1 vccd1 vccd1 sky130_fd_sc_hd__fill_1
XFILLER_69_55 vssd1 vssd1 vccd1 vccd1 sky130_fd_sc_hd__fill_1
XFILLER_4_469 vssd1 vssd1 vccd1 vccd1 sky130_fd_sc_hd__fill_4
X_10133_ cell2.SB0.route_sel\[45\] cell2.SB0.route_sel\[44\] vssd1 vssd1 vccd1 vccd1
+ _05134_ sky130_fd_sc_hd__nand2b_1
XANTENNA_input34_A CBnorth_in[10] vssd1 vssd1 vccd1 vccd1 sky130_fd_sc_hd__diode_2
X_10064_ cell2.LE_1B.config_data\[0\] cell2.LE_1B.config_data\[1\] _04956_ vssd1 vssd1
+ vccd1 vccd1 _05068_ sky130_fd_sc_hd__mux2_1
XFILLER_88_793 vssd1 vssd1 vccd1 vccd1 sky130_fd_sc_hd__fill_1
XFILLER_87_270 vssd1 vssd1 vccd1 vccd1 sky130_fd_sc_hd__fill_1
XFILLER_47_101 vssd1 vssd1 vccd1 vccd1 sky130_fd_sc_hd__fill_1
XFILLER_0_697 vssd1 vssd1 vccd1 vccd1 sky130_fd_sc_hd__fill_1
XTAP_TAPCELL_ROW_106_1901 vssd1 vccd1 sky130_fd_sc_hd__tapvpwrvgnd_1
XFILLER_75_487 vssd1 vssd1 vccd1 vccd1 sky130_fd_sc_hd__fill_2
X_13823_ clknet_leaf_104_clk _00795_ net662 vssd1 vssd1 vccd1 vccd1 cell1.SB0.route_sel\[100\]
+ sky130_fd_sc_hd__dfstp_1
XFILLER_62_137 vssd1 vssd1 vccd1 vccd1 sky130_fd_sc_hd__fill_1
XTAP_TAPCELL_ROW_48_1030 vssd1 vccd1 sky130_fd_sc_hd__tapvpwrvgnd_1
X_10966_ _01686_ _01687_ _01688_ cell3.SB0.route_sel\[15\] _05919_ vssd1 vssd1 vccd1
+ vccd1 _05920_ sky130_fd_sc_hd__a221o_1
XFILLER_71_671 vssd1 vssd1 vccd1 vccd1 sky130_fd_sc_hd__fill_1
XANTENNA__11815__A1 net1514 vssd1 vssd1 vccd1 vccd1 sky130_fd_sc_hd__diode_2
X_13754_ clknet_leaf_108_clk _00726_ net652 vssd1 vssd1 vccd1 vccd1 cell1.SB0.route_sel\[31\]
+ sky130_fd_sc_hd__dfstp_1
XTAP_TAPCELL_ROW_139_2400 vssd1 vccd1 sky130_fd_sc_hd__tapvpwrvgnd_1
X_13685_ clknet_leaf_29_clk _00657_ net619 vssd1 vssd1 vccd1 vccd1 cell2.CB_0.config_dataB\[12\]
+ sky130_fd_sc_hd__dfstp_2
X_10897_ net272 _05849_ vssd1 vssd1 vccd1 vccd1 _05851_ sky130_fd_sc_hd__or2_1
X_12705_ cell3.CB_1.config_dataA\[22\] cell3.CB_1.config_dataA\[21\] net940 vssd1
+ vssd1 vccd1 vccd1 _01134_ sky130_fd_sc_hd__mux2_1
X_12636_ cell3.SB0.route_sel\[101\] cell3.SB0.route_sel\[100\] net919 vssd1 vssd1
+ vccd1 vccd1 _01065_ sky130_fd_sc_hd__mux2_1
XTAP_TAPCELL_ROW_61_1230 vssd1 vccd1 sky130_fd_sc_hd__tapvpwrvgnd_1
X_12567_ cell3.SB0.route_sel\[32\] cell3.SB0.route_sel\[31\] net911 vssd1 vssd1 vccd1
+ vccd1 _00996_ sky130_fd_sc_hd__mux2_1
X_14306_ clknet_leaf_17_clk _01278_ net626 vssd1 vssd1 vccd1 vccd1 cell2.SB0.route_sel\[91\]
+ sky130_fd_sc_hd__dfstp_1
XANTENNA__08995__A1 _03868_ vssd1 vssd1 vccd1 vccd1 sky130_fd_sc_hd__diode_2
Xhold208 cell2.LE_1A.config_data\[8\] vssd1 vssd1 vccd1 vccd1 net1167 sky130_fd_sc_hd__dlygate4sd3_1
X_12498_ net1549 cell2.LEI0.config_data\[11\] net838 vssd1 vssd1 vccd1 vccd1 _00927_
+ sky130_fd_sc_hd__mux2_1
X_11518_ cell2.SB0.route_sel\[80\] cell2.SB0.route_sel\[81\] cell2.SB0.route_sel\[84\]
+ _01633_ _06345_ vssd1 vssd1 vccd1 vccd1 _06346_ sky130_fd_sc_hd__o221a_1
XANTENNA__08995__B2 _03871_ vssd1 vssd1 vccd1 vccd1 sky130_fd_sc_hd__diode_2
X_14237_ clknet_leaf_20_clk _01209_ net611 vssd1 vssd1 vccd1 vccd1 cell2.SB0.route_sel\[22\]
+ sky130_fd_sc_hd__dfstp_1
Xhold219 _00538_ vssd1 vssd1 vccd1 vccd1 net1178 sky130_fd_sc_hd__dlygate4sd3_1
X_11449_ cell1.SB0.route_sel\[26\] _01509_ cell1.SB0.route_sel\[30\] cell1.SB0.route_sel\[31\]
+ _06299_ vssd1 vssd1 vccd1 vccd1 _06300_ sky130_fd_sc_hd__o221a_1
XFILLER_7_285 vssd1 vssd1 vccd1 vccd1 sky130_fd_sc_hd__fill_2
X_14168_ clknet_leaf_52_clk _01140_ net716 vssd1 vssd1 vccd1 vccd1 cell3.CB_0.config_dataB\[3\]
+ sky130_fd_sc_hd__dfstp_1
XANTENNA__10003__B1 _04555_ vssd1 vssd1 vccd1 vccd1 sky130_fd_sc_hd__diode_2
XTAP_TAPCELL_ROW_59_1192 vssd1 vccd1 sky130_fd_sc_hd__tapvpwrvgnd_1
X_13119_ clknet_leaf_9_clk _00091_ net574 vssd1 vssd1 vccd1 vccd1 cell0.CB_0.config_dataA\[21\]
+ sky130_fd_sc_hd__dfstp_1
XFILLER_112_367 vssd1 vssd1 vccd1 vccd1 sky130_fd_sc_hd__fill_1
X_14099_ clknet_leaf_50_clk _01071_ net712 vssd1 vssd1 vccd1 vccd1 cell3.SB0.route_sel\[107\]
+ sky130_fd_sc_hd__dfstp_1
X_06990_ cell1.SB0.route_sel\[66\] cell1.SB0.route_sel\[67\] _02044_ _02045_ _02055_
+ vssd1 vssd1 vccd1 vccd1 _02056_ sky130_fd_sc_hd__a41o_1
XTAP_TAPCELL_ROW_72_1392 vssd1 vccd1 sky130_fd_sc_hd__tapvpwrvgnd_1
XTAP_TAPCELL_ROW_72_1381 vssd1 vccd1 sky130_fd_sc_hd__tapvpwrvgnd_1
XFILLER_66_421 vssd1 vssd1 vccd1 vccd1 sky130_fd_sc_hd__fill_4
XANTENNA__09172__A1 net318 vssd1 vssd1 vccd1 vccd1 sky130_fd_sc_hd__diode_2
XFILLER_38_145 vssd1 vssd1 vccd1 vccd1 sky130_fd_sc_hd__fill_1
X_08660_ net457 net458 _03498_ _03693_ cell1.CB_1.config_dataB\[7\] vssd1 vssd1 vccd1
+ vccd1 _03694_ sky130_fd_sc_hd__o311a_1
XFILLER_81_402 vssd1 vssd1 vccd1 vccd1 sky130_fd_sc_hd__fill_2
X_07611_ net338 net355 net353 vssd1 vssd1 vccd1 vccd1 _02660_ sky130_fd_sc_hd__or3_1
XFILLER_81_435 vssd1 vssd1 vccd1 vccd1 sky130_fd_sc_hd__fill_1
X_08591_ _03625_ _03626_ vssd1 vssd1 vccd1 vccd1 _03627_ sky130_fd_sc_hd__and2b_1
XTAP_TAPCELL_ROW_37_858 vssd1 vccd1 sky130_fd_sc_hd__tapvpwrvgnd_1
X_07542_ net301 _02591_ vssd1 vssd1 vccd1 vccd1 _02593_ sky130_fd_sc_hd__nor2_1
XTAP_TAPCELL_ROW_37_869 vssd1 vccd1 sky130_fd_sc_hd__tapvpwrvgnd_1
X_07473_ _02491_ _02525_ vssd1 vssd1 vccd1 vccd1 _02526_ sky130_fd_sc_hd__and2_2
XTAP_TAPCELL_ROW_17_560 vssd1 vccd1 sky130_fd_sc_hd__tapvpwrvgnd_1
X_06424_ cell0.LE_1B.config_data\[16\] vssd1 vssd1 vccd1 vccd1 _01494_ sky130_fd_sc_hd__inv_2
X_09212_ net330 _02692_ _04238_ vssd1 vssd1 vccd1 vccd1 _04239_ sky130_fd_sc_hd__o21ai_1
X_09143_ _01672_ cell1.LE_0B.dff_out vssd1 vssd1 vccd1 vccd1 _04172_ sky130_fd_sc_hd__or2_1
XFILLER_135_415 vssd1 vssd1 vccd1 vccd1 sky130_fd_sc_hd__fill_1
XANTENNA__10793__A1 _05513_ vssd1 vssd1 vccd1 vccd1 sky130_fd_sc_hd__diode_2
X_09074_ _03868_ _04090_ _04091_ _03871_ cell1.CB_0.config_dataB\[12\] vssd1 vssd1
+ vccd1 vccd1 _04104_ sky130_fd_sc_hd__a221o_1
X_08025_ bus2_0\[8\] bus2_0\[9\] bus2_0\[10\] bus2_0\[11\] net534 net532 vssd1 vssd1
+ vccd1 vccd1 _03067_ sky130_fd_sc_hd__mux4_1
XFILLER_104_813 vssd1 vssd1 vccd1 vccd1 sky130_fd_sc_hd__fill_4
XANTENNA__12534__A2 net549 vssd1 vssd1 vccd1 vccd1 sky130_fd_sc_hd__diode_2
XFILLER_100_9 vccd1 vssd1 vccd1 vssd1 sky130_ef_sc_hd__decap_40_12
XFILLER_1_417 vccd1 vssd1 vccd1 vssd1 sky130_ef_sc_hd__decap_40_12
XFILLER_103_323 vssd1 vssd1 vccd1 vccd1 sky130_fd_sc_hd__fill_1
XFILLER_89_557 vssd1 vssd1 vccd1 vccd1 sky130_fd_sc_hd__fill_2
XANTENNA__08202__A3 bus1_0\[11\] vssd1 vssd1 vccd1 vccd1 sky130_fd_sc_hd__diode_2
XANTENNA__09950__A3 net302 vssd1 vssd1 vccd1 vccd1 sky130_fd_sc_hd__diode_2
X_09976_ _04979_ vssd1 vssd1 vccd1 vccd1 _04980_ sky130_fd_sc_hd__inv_2
XANTENNA_fanout855_A net130 vssd1 vssd1 vccd1 vccd1 sky130_fd_sc_hd__diode_2
XANTENNA__07961__A2 bus2_0\[14\] vssd1 vssd1 vccd1 vccd1 sky130_fd_sc_hd__diode_2
X_08927_ bus3_1\[12\] bus3_1\[13\] bus3_1\[14\] bus3_1\[15\] net468 net466 vssd1 vssd1
+ vccd1 vccd1 _03959_ sky130_fd_sc_hd__mux4_1
XFILLER_39_69 vssd1 vssd1 vccd1 vccd1 sky130_fd_sc_hd__fill_1
XANTENNA__12298__A1 cell1.SB0.route_sel\[35\] vssd1 vssd1 vccd1 vccd1 sky130_fd_sc_hd__diode_2
XANTENNA__09163__A1 net33 vssd1 vssd1 vccd1 vccd1 sky130_fd_sc_hd__diode_2
XFILLER_69_281 vssd1 vssd1 vccd1 vccd1 sky130_fd_sc_hd__fill_1
X_08858_ _03887_ _03888_ _03889_ _02866_ vssd1 vssd1 vccd1 vccd1 _03890_ sky130_fd_sc_hd__a31o_4
XANTENNA__08910__B2 _03894_ vssd1 vssd1 vccd1 vccd1 sky130_fd_sc_hd__diode_2
X_07809_ net28 _02853_ vssd1 vssd1 vccd1 vccd1 _02854_ sky130_fd_sc_hd__or2_1
XFILLER_29_167 vssd1 vssd1 vccd1 vccd1 sky130_fd_sc_hd__fill_1
XANTENNA__08910__A1 _03890_ vssd1 vssd1 vccd1 vccd1 sky130_fd_sc_hd__diode_2
XFILLER_72_446 vssd1 vssd1 vccd1 vccd1 sky130_fd_sc_hd__fill_1
X_08789_ net470 _03820_ vssd1 vssd1 vccd1 vccd1 _03821_ sky130_fd_sc_hd__nand2_1
X_10820_ _05774_ _05775_ _05765_ _05772_ vssd1 vssd1 vccd1 vccd1 _05776_ sky130_fd_sc_hd__o211a_1
XFILLER_72_468 vssd1 vssd1 vccd1 vccd1 sky130_fd_sc_hd__fill_4
XFILLER_111_63 vssd1 vssd1 vccd1 vccd1 sky130_fd_sc_hd__fill_1
X_10751_ cell3.CB_1.config_dataB\[3\] cell3.CB_1.config_dataB\[2\] vssd1 vssd1 vccd1
+ vccd1 _05707_ sky130_fd_sc_hd__nor2_1
XTAP_TAPCELL_ROW_101_1820 vssd1 vccd1 sky130_fd_sc_hd__tapvpwrvgnd_1
XANTENNA_fanout908_X net908 vssd1 vssd1 vccd1 vccd1 sky130_fd_sc_hd__diode_2
X_13470_ clknet_leaf_1_clk _00442_ net554 vssd1 vssd1 vccd1 vccd1 cell0.SB0.route_sel\[111\]
+ sky130_fd_sc_hd__dfstp_1
X_12421_ cell2.LE_1A.config_data\[4\] net1174 net925 vssd1 vssd1 vccd1 vccd1 _00853_
+ sky130_fd_sc_hd__mux2_1
X_10682_ _05601_ _05639_ _05562_ vssd1 vssd1 vccd1 vccd1 _05640_ sky130_fd_sc_hd__mux2_1
XANTENNA__10565__A net272 vssd1 vssd1 vccd1 vccd1 sky130_fd_sc_hd__diode_2
XANTENNA__07858__B _02901_ vssd1 vssd1 vccd1 vccd1 sky130_fd_sc_hd__diode_2
XANTENNA__10784__A1 _05489_ vssd1 vssd1 vccd1 vccd1 sky130_fd_sc_hd__diode_2
X_12352_ cell1.SB0.route_sel\[90\] cell1.SB0.route_sel\[89\] net871 vssd1 vssd1 vccd1
+ vccd1 _00785_ sky130_fd_sc_hd__mux2_1
XANTENNA__10784__B2 _05483_ vssd1 vssd1 vccd1 vccd1 sky130_fd_sc_hd__diode_2
X_11303_ _04450_ _05483_ vssd1 vssd1 vccd1 vccd1 _06216_ sky130_fd_sc_hd__or2_1
X_12283_ cell1.SB0.route_sel\[21\] cell1.SB0.route_sel\[20\] net864 vssd1 vssd1 vccd1
+ vccd1 _00716_ sky130_fd_sc_hd__mux2_1
X_11234_ cell3.LE_0B.config_data\[6\] cell3.LE_0B.config_data\[7\] _06076_ vssd1 vssd1
+ vccd1 vccd1 _06186_ sky130_fd_sc_hd__mux2_1
XANTENNA__09926__A0 bus3_2\[6\] vssd1 vssd1 vccd1 vccd1 sky130_fd_sc_hd__diode_2
X_14022_ clknet_leaf_81_clk _00994_ net702 vssd1 vssd1 vccd1 vccd1 cell3.SB0.route_sel\[30\]
+ sky130_fd_sc_hd__dfstp_1
XANTENNA__10536__A1 net16 vssd1 vssd1 vccd1 vccd1 sky130_fd_sc_hd__diode_2
XFILLER_4_277 vccd1 vssd1 vccd1 vssd1 sky130_ef_sc_hd__decap_40_12
X_11165_ net53 net54 net56 net57 cell3.CB_0.config_dataB\[10\] cell3.CB_0.config_dataB\[11\]
+ vssd1 vssd1 vccd1 vccd1 _06117_ sky130_fd_sc_hd__mux4_1
XFILLER_136_93 vssd1 vssd1 vccd1 vccd1 sky130_fd_sc_hd__fill_1
XFILLER_122_665 vssd1 vssd1 vccd1 vccd1 sky130_fd_sc_hd__fill_1
XANTENNA__09941__A3 bus3_2\[15\] vssd1 vssd1 vccd1 vccd1 sky130_fd_sc_hd__diode_2
XANTENNA_input37_X net37 vssd1 vssd1 vccd1 vccd1 sky130_fd_sc_hd__diode_2
XFILLER_121_164 vssd1 vssd1 vccd1 vccd1 sky130_fd_sc_hd__fill_1
X_10116_ cell2.CB_0.config_dataA\[7\] _05089_ _05100_ _05116_ vssd1 vssd1 vccd1 vccd1
+ _05117_ sky130_fd_sc_hd__o31a_1
XTAP_TAPCELL_ROW_112_1993 vssd1 vccd1 sky130_fd_sc_hd__tapvpwrvgnd_1
X_11096_ _01796_ cell3.CB_0.config_dataB\[1\] vssd1 vssd1 vccd1 vccd1 _06048_ sky130_fd_sc_hd__nor2_1
XTAP_TAPCELL_ROW_112_1982 vssd1 vccd1 sky130_fd_sc_hd__tapvpwrvgnd_1
XANTENNA_output238_A net238 vssd1 vssd1 vccd1 vccd1 sky130_fd_sc_hd__diode_2
X_10047_ cell2.CB_1.config_dataB\[18\] cell2.CB_1.config_dataB\[17\] _05050_ vssd1
+ vssd1 vccd1 vccd1 _05051_ sky130_fd_sc_hd__o21ai_1
XFILLER_76_741 vssd1 vssd1 vccd1 vccd1 sky130_fd_sc_hd__fill_1
Xhold80 cell2.LE_0A.config_data\[13\] vssd1 vssd1 vccd1 vccd1 net1039 sky130_fd_sc_hd__dlygate4sd3_1
Xhold91 cell1.LE_0B.config_data\[3\] vssd1 vssd1 vccd1 vccd1 net1050 sky130_fd_sc_hd__dlygate4sd3_1
XFILLER_63_446 vssd1 vssd1 vccd1 vccd1 sky130_fd_sc_hd__fill_2
XPHY_EDGE_ROW_11_Left_154 vssd1 vssd1 vccd1 vccd1 sky130_fd_sc_hd__decap_3
XFILLER_32_800 vssd1 vssd1 vccd1 vccd1 sky130_fd_sc_hd__fill_1
X_11998_ cell0.SB0.route_sel\[104\] cell0.SB0.route_sel\[103\] net765 vssd1 vssd1
+ vccd1 vccd1 _00435_ sky130_fd_sc_hd__mux2_1
XTAP_TAPCELL_ROW_34_817 vssd1 vccd1 sky130_fd_sc_hd__tapvpwrvgnd_1
X_13806_ clknet_leaf_111_clk _00778_ net656 vssd1 vssd1 vccd1 vccd1 cell1.SB0.route_sel\[83\]
+ sky130_fd_sc_hd__dfstp_1
X_10949_ _05862_ _05898_ _05901_ _05858_ vssd1 vssd1 vccd1 vccd1 _05903_ sky130_fd_sc_hd__o2bb2a_1
XANTENNA__07468__A1 bus3_2\[14\] vssd1 vssd1 vccd1 vccd1 sky130_fd_sc_hd__diode_2
X_13737_ clknet_leaf_106_clk _00709_ net658 vssd1 vssd1 vccd1 vccd1 cell1.SB0.route_sel\[14\]
+ sky130_fd_sc_hd__dfstp_1
Xclkbuf_leaf_70_clk clknet_4_14_0_clk vssd1 vssd1 vccd1 vccd1 clknet_leaf_70_clk sky130_fd_sc_hd__clkbuf_8
X_13668_ clknet_leaf_45_clk _00640_ net629 vssd1 vssd1 vccd1 vccd1 cell2.CB_1.config_dataA\[20\]
+ sky130_fd_sc_hd__dfstp_1
XANTENNA__10224__A0 net33 vssd1 vssd1 vccd1 vccd1 sky130_fd_sc_hd__diode_2
XANTENNA_max_cap274_X net274 vssd1 vssd1 vccd1 vccd1 sky130_fd_sc_hd__diode_2
XFILLER_77_3 vssd1 vssd1 vccd1 vccd1 sky130_fd_sc_hd__fill_1
X_12619_ cell3.SB0.route_sel\[84\] cell3.SB0.route_sel\[83\] net880 vssd1 vssd1 vccd1
+ vccd1 _01048_ sky130_fd_sc_hd__mux2_1
X_13599_ clknet_leaf_89_clk net1104 net696 vssd1 vssd1 vccd1 vccd1 cell1.LEI0.config_data\[20\]
+ sky130_fd_sc_hd__dfrtp_1
XANTENNA__10775__A1 net22 vssd1 vssd1 vccd1 vccd1 sky130_fd_sc_hd__diode_2
XANTENNA__08968__A1 net327 vssd1 vssd1 vccd1 vccd1 sky130_fd_sc_hd__diode_2
XTAP_TAPCELL_ROW_74_1421 vssd1 vccd1 sky130_fd_sc_hd__tapvpwrvgnd_1
XPHY_EDGE_ROW_20_Left_163 vssd1 vssd1 vccd1 vccd1 sky130_fd_sc_hd__decap_3
XFILLER_112_131 vssd1 vssd1 vccd1 vccd1 sky130_fd_sc_hd__fill_1
X_09830_ net441 net440 vssd1 vssd1 vccd1 vccd1 _04836_ sky130_fd_sc_hd__nor2_1
Xfanout529 cell0.CB_0.config_dataB\[6\] vssd1 vssd1 vccd1 vccd1 net529 sky130_fd_sc_hd__buf_2
Xfanout518 cell0.CB_0.config_dataA\[5\] vssd1 vssd1 vccd1 vccd1 net518 sky130_fd_sc_hd__buf_2
Xfanout507 cell0.CB_1.config_dataB\[5\] vssd1 vssd1 vccd1 vccd1 net507 sky130_fd_sc_hd__clkbuf_2
X_09761_ _04671_ _04757_ _04759_ _04641_ vssd1 vssd1 vccd1 vccd1 _04767_ sky130_fd_sc_hd__o2bb2a_1
XFILLER_98_376 vssd1 vssd1 vccd1 vccd1 sky130_fd_sc_hd__fill_1
XFILLER_58_229 vssd1 vssd1 vccd1 vccd1 sky130_fd_sc_hd__fill_1
X_06973_ cell0.SB0.route_sel\[64\] _01466_ cell0.SB0.route_sel\[69\] cell0.SB0.route_sel\[68\]
+ _02038_ vssd1 vssd1 vccd1 vccd1 _02039_ sky130_fd_sc_hd__o221a_2
X_08712_ net455 _03529_ vssd1 vssd1 vccd1 vccd1 _03746_ sky130_fd_sc_hd__nand2_1
XFILLER_132_29 vccd1 vssd1 vccd1 vssd1 sky130_ef_sc_hd__decap_40_12
X_09692_ cell3.SB0.route_sel\[115\] cell3.SB0.route_sel\[114\] _04693_ _04699_ _04705_
+ vssd1 vssd1 vccd1 vccd1 _04706_ sky130_fd_sc_hd__a41o_1
XFILLER_82_744 vssd1 vssd1 vccd1 vccd1 sky130_fd_sc_hd__fill_2
X_08643_ net28 _03670_ _03671_ net27 cell1.CB_1.config_dataB\[8\] vssd1 vssd1 vccd1
+ vccd1 _03677_ sky130_fd_sc_hd__a221o_1
XFILLER_25_27 vccd1 vssd1 vccd1 vssd1 sky130_ef_sc_hd__decap_40_12
X_08574_ _03477_ _03587_ _03588_ _03473_ cell1.CB_1.config_dataA\[12\] vssd1 vssd1
+ vccd1 vccd1 _03610_ sky130_fd_sc_hd__a221o_1
XTAP_TAPCELL_ROW_85_1583 vssd1 vccd1 sky130_fd_sc_hd__tapvpwrvgnd_1
X_07525_ net328 _02573_ _02575_ _02576_ vssd1 vssd1 vccd1 vccd1 _02577_ sky130_fd_sc_hd__o22a_1
Xclkbuf_leaf_61_clk clknet_4_15_0_clk vssd1 vssd1 vccd1 vccd1 clknet_leaf_61_clk sky130_fd_sc_hd__clkbuf_8
X_07456_ _01888_ _02367_ vssd1 vssd1 vccd1 vccd1 _02510_ sky130_fd_sc_hd__nor2_1
XANTENNA__12076__S net940 vssd1 vssd1 vccd1 vccd1 sky130_fd_sc_hd__diode_2
X_07387_ cell1.SB0.route_sel\[105\] cell1.SB0.route_sel\[104\] _02442_ vssd1 vssd1
+ vccd1 vccd1 _02443_ sky130_fd_sc_hd__a21oi_1
XFILLER_41_15 vccd1 vssd1 vccd1 vssd1 sky130_ef_sc_hd__decap_40_12
X_06407_ cell0.SB0.route_sel\[100\] vssd1 vssd1 vccd1 vccd1 _01477_ sky130_fd_sc_hd__inv_2
X_09126_ _04154_ _04155_ cell1.CB_0.config_dataB\[18\] _04152_ vssd1 vssd1 vccd1 vccd1
+ _04156_ sky130_fd_sc_hd__o211a_1
XFILLER_136_757 vccd1 vssd1 vccd1 vssd1 sky130_ef_sc_hd__decap_40_12
X_09057_ cell1.LE_0B.config_data\[1\] cell1.LE_0B.config_data\[0\] _04086_ vssd1 vssd1
+ vccd1 vccd1 _04087_ sky130_fd_sc_hd__mux2_1
X_08008_ net529 _03048_ _03049_ vssd1 vssd1 vccd1 vccd1 _03050_ sky130_fd_sc_hd__a21o_1
XANTENNA__07694__A _01931_ vssd1 vssd1 vccd1 vccd1 sky130_fd_sc_hd__diode_2
Xhold550 cell3.LEI0.config_data\[12\] vssd1 vssd1 vccd1 vccd1 net1509 sky130_fd_sc_hd__dlygate4sd3_1
Xhold561 _00521_ vssd1 vssd1 vccd1 vccd1 net1520 sky130_fd_sc_hd__dlygate4sd3_1
Xhold572 cell1.LE_0B.config_data\[15\] vssd1 vssd1 vccd1 vccd1 net1531 sky130_fd_sc_hd__dlygate4sd3_1
XFILLER_2_737 vccd1 vssd1 vccd1 vssd1 sky130_ef_sc_hd__decap_40_12
XFILLER_1_225 vccd1 vssd1 vccd1 vssd1 sky130_ef_sc_hd__decap_40_12
Xhold583 cell2.LEI0.config_data\[36\] vssd1 vssd1 vccd1 vccd1 net1542 sky130_fd_sc_hd__dlygate4sd3_1
XFILLER_89_343 vssd1 vssd1 vccd1 vccd1 sky130_fd_sc_hd__fill_1
Xhold594 cell1.LE_1B.config_data\[8\] vssd1 vssd1 vccd1 vccd1 net1553 sky130_fd_sc_hd__dlygate4sd3_1
X_09959_ bus3_2\[6\] bus3_2\[7\] net406 vssd1 vssd1 vccd1 vccd1 _04963_ sky130_fd_sc_hd__mux2_1
XANTENNA__07981__X _03025_ vssd1 vssd1 vccd1 vccd1 sky130_fd_sc_hd__diode_2
XFILLER_106_85 vssd1 vssd1 vccd1 vccd1 sky130_fd_sc_hd__fill_2
X_12970_ net1206 net1130 net928 vssd1 vssd1 vccd1 vccd1 _01398_ sky130_fd_sc_hd__mux2_1
X_11921_ cell0.SB0.route_sel\[27\] cell0.SB0.route_sel\[26\] net760 vssd1 vssd1 vccd1
+ vccd1 _00358_ sky130_fd_sc_hd__mux2_1
X_11852_ cell1.CB_0.config_dataB\[8\] cell1.CB_0.config_dataB\[7\] net895 vssd1 vssd1
+ vccd1 vccd1 _00289_ sky130_fd_sc_hd__mux2_1
XANTENNA__08493__B1_N _01979_ vssd1 vssd1 vccd1 vccd1 sky130_fd_sc_hd__diode_2
XANTENNA__10279__B _05128_ vssd1 vssd1 vccd1 vccd1 sky130_fd_sc_hd__diode_2
X_10803_ cell3.LE_1B.config_data\[6\] cell3.LE_1B.config_data\[7\] net292 vssd1 vssd1
+ vccd1 vccd1 _05759_ sky130_fd_sc_hd__mux2_1
XFILLER_82_33 vssd1 vssd1 vccd1 vccd1 sky130_fd_sc_hd__fill_2
Xclkbuf_leaf_52_clk clknet_4_13_0_clk vssd1 vssd1 vccd1 vccd1 clknet_leaf_52_clk sky130_fd_sc_hd__clkbuf_8
X_11783_ cell0.LEI0.config_data\[33\] net1464 net800 vssd1 vssd1 vccd1 vccd1 _00220_
+ sky130_fd_sc_hd__mux2_1
X_13522_ clknet_leaf_100_clk net1009 net679 vssd1 vssd1 vccd1 vccd1 cell1.LE_1A.config_data\[9\]
+ sky130_fd_sc_hd__dfrtp_1
XTAP_TAPCELL_ROW_0_291 vssd1 vccd1 sky130_fd_sc_hd__tapvpwrvgnd_1
X_10734_ net371 _05519_ _05689_ net370 vssd1 vssd1 vccd1 vccd1 _05690_ sky130_fd_sc_hd__o211a_1
XFILLER_9_314 vssd1 vssd1 vccd1 vccd1 sky130_fd_sc_hd__fill_1
X_10665_ net8 net9 net10 net11 net393 net392 vssd1 vssd1 vccd1 vccd1 _05623_ sky130_fd_sc_hd__mux4_1
X_13453_ clknet_leaf_123_clk _00425_ net579 vssd1 vssd1 vccd1 vccd1 cell0.SB0.route_sel\[94\]
+ sky130_fd_sc_hd__dfstp_1
X_12404_ cell2.CB_1.config_dataB\[14\] cell2.CB_1.config_dataB\[13\] net832 vssd1
+ vssd1 vccd1 vccd1 _00837_ sky130_fd_sc_hd__mux2_1
X_13384_ clknet_leaf_133_clk _00356_ net556 vssd1 vssd1 vccd1 vccd1 cell0.SB0.route_sel\[25\]
+ sky130_fd_sc_hd__dfstp_1
XANTENNA_output188_A net188 vssd1 vssd1 vccd1 vccd1 sky130_fd_sc_hd__diode_2
X_10596_ _05553_ vssd1 vssd1 vccd1 vccd1 _05554_ sky130_fd_sc_hd__inv_2
XANTENNA__07622__A1 net354 vssd1 vssd1 vccd1 vccd1 sky130_fd_sc_hd__diode_2
X_12335_ cell1.SB0.route_sel\[73\] cell1.SB0.route_sel\[72\] net868 vssd1 vssd1 vccd1
+ vccd1 _00768_ sky130_fd_sc_hd__mux2_1
XFILLER_142_727 vssd1 vssd1 vccd1 vccd1 sky130_fd_sc_hd__fill_1
XANTENNA__10582__X _05540_ vssd1 vssd1 vccd1 vccd1 sky130_fd_sc_hd__diode_2
XFILLER_107_470 vssd1 vssd1 vccd1 vccd1 sky130_fd_sc_hd__fill_8
XFILLER_49_7 vssd1 vssd1 vccd1 vccd1 sky130_fd_sc_hd__fill_1
X_12266_ cell1.SB0.route_sel\[4\] cell1.SB0.route_sel\[3\] net886 vssd1 vssd1 vccd1
+ vccd1 _00699_ sky130_fd_sc_hd__mux2_1
XANTENNA__10509__A1 net322 vssd1 vssd1 vccd1 vccd1 sky130_fd_sc_hd__diode_2
X_11217_ net382 _06167_ _06168_ vssd1 vssd1 vccd1 vccd1 _06169_ sky130_fd_sc_hd__a21bo_1
X_12197_ net442 cell2.CB_1.config_dataA\[9\] net913 vssd1 vssd1 vccd1 vccd1 _00630_
+ sky130_fd_sc_hd__mux2_1
X_14005_ clknet_leaf_75_clk _00977_ net725 vssd1 vssd1 vccd1 vccd1 cell3.SB0.route_sel\[13\]
+ sky130_fd_sc_hd__dfstp_1
XTAP_TAPCELL_ROW_56_1151 vssd1 vccd1 sky130_fd_sc_hd__tapvpwrvgnd_1
XANTENNA__07386__A0 net330 vssd1 vssd1 vccd1 vccd1 sky130_fd_sc_hd__diode_2
XANTENNA__08178__A2 _02424_ vssd1 vssd1 vccd1 vccd1 sky130_fd_sc_hd__diode_2
X_11148_ _06094_ _06097_ _06099_ cell3.CB_0.config_dataB\[7\] vssd1 vssd1 vccd1 vccd1
+ _06100_ sky130_fd_sc_hd__o22a_1
XFILLER_96_847 vssd1 vssd1 vccd1 vccd1 sky130_fd_sc_hd__fill_1
XANTENNA__07925__A2 _02235_ vssd1 vssd1 vccd1 vccd1 sky130_fd_sc_hd__diode_2
XANTENNA__07109__A _02132_ vssd1 vssd1 vccd1 vccd1 sky130_fd_sc_hd__diode_2
XFILLER_110_635 vssd1 vssd1 vccd1 vccd1 sky130_fd_sc_hd__fill_1
XFILLER_95_335 vssd1 vssd1 vccd1 vccd1 sky130_fd_sc_hd__fill_1
X_11079_ _06032_ _06029_ _05994_ vssd1 vssd1 vccd1 vccd1 _06033_ sky130_fd_sc_hd__mux2_1
XFILLER_49_785 vssd1 vssd1 vccd1 vccd1 sky130_fd_sc_hd__fill_4
XTAP_TAPCELL_ROW_19_600 vssd1 vccd1 sky130_fd_sc_hd__tapvpwrvgnd_1
XFILLER_36_435 vssd1 vssd1 vccd1 vccd1 sky130_fd_sc_hd__fill_1
XANTENNA__08350__A2 bus1_0\[10\] vssd1 vssd1 vccd1 vccd1 sky130_fd_sc_hd__diode_2
Xclkbuf_leaf_43_clk clknet_4_6_0_clk vssd1 vssd1 vccd1 vccd1 clknet_leaf_43_clk sky130_fd_sc_hd__clkbuf_8
XANTENNA__08102__A2 bus2_0\[10\] vssd1 vssd1 vccd1 vccd1 sky130_fd_sc_hd__diode_2
X_07310_ _02062_ _02367_ vssd1 vssd1 vccd1 vccd1 _02368_ sky130_fd_sc_hd__or2_1
XANTENNA_clkbuf_leaf_9_clk_A clknet_4_1_0_clk vssd1 vssd1 vccd1 vccd1 sky130_fd_sc_hd__diode_2
X_08290_ net506 _02761_ vssd1 vssd1 vccd1 vccd1 _03328_ sky130_fd_sc_hd__nand2_1
X_07241_ cell0.SB0.route_sel\[93\] cell0.SB0.route_sel\[92\] vssd1 vssd1 vccd1 vccd1
+ _02300_ sky130_fd_sc_hd__nand2b_1
XANTENNA__09063__A0 bus3_1\[12\] vssd1 vssd1 vccd1 vccd1 sky130_fd_sc_hd__diode_2
X_07172_ cell0.SB0.route_sel\[83\] cell0.SB0.route_sel\[82\] vssd1 vssd1 vccd1 vccd1
+ _02233_ sky130_fd_sc_hd__nor2_1
XANTENNA__07613__A1 net355 vssd1 vssd1 vccd1 vccd1 sky130_fd_sc_hd__diode_2
XANTENNA__10492__X net160 vssd1 vssd1 vccd1 vccd1 sky130_fd_sc_hd__diode_2
XANTENNA__11748__B _03024_ vssd1 vssd1 vccd1 vccd1 sky130_fd_sc_hd__diode_2
Xfanout304 cell2.CB_1.le_outB vssd1 vssd1 vccd1 vccd1 net304 sky130_fd_sc_hd__dlymetal6s2s_1
XANTENNA__11384__A_N _06256_ vssd1 vssd1 vccd1 vccd1 sky130_fd_sc_hd__diode_2
XANTENNA__09218__B _02675_ vssd1 vssd1 vccd1 vccd1 sky130_fd_sc_hd__diode_2
Xfanout315 net316 vssd1 vssd1 vccd1 vccd1 net315 sky130_fd_sc_hd__buf_2
X_09813_ net447 _04498_ vssd1 vssd1 vccd1 vccd1 _04819_ sky130_fd_sc_hd__nand2_1
XFILLER_87_847 vssd1 vssd1 vccd1 vccd1 sky130_fd_sc_hd__fill_1
XFILLER_59_505 vssd1 vssd1 vccd1 vccd1 sky130_fd_sc_hd__fill_1
Xfanout337 cell1.CB_1.le_outA vssd1 vssd1 vccd1 vccd1 net337 sky130_fd_sc_hd__buf_2
Xfanout326 net327 vssd1 vssd1 vccd1 vccd1 net326 sky130_fd_sc_hd__clkbuf_2
Xfanout348 net349 vssd1 vssd1 vccd1 vccd1 net348 sky130_fd_sc_hd__clkbuf_2
XFILLER_100_112 vssd1 vssd1 vccd1 vccd1 sky130_fd_sc_hd__fill_1
XFILLER_98_195 vssd1 vssd1 vccd1 vccd1 sky130_fd_sc_hd__fill_1
Xfanout359 _01868_ vssd1 vssd1 vccd1 vccd1 net359 sky130_fd_sc_hd__buf_2
XANTENNA__09118__A1 _03830_ vssd1 vssd1 vccd1 vccd1 sky130_fd_sc_hd__diode_2
X_09744_ _01599_ cell2.SB0.route_sel\[34\] cell2.SB0.route_sel\[38\] cell2.SB0.route_sel\[39\]
+ _04751_ vssd1 vssd1 vccd1 vccd1 _04752_ sky130_fd_sc_hd__o221a_1
XTAP_TAPCELL_ROW_87_1612 vssd1 vccd1 sky130_fd_sc_hd__tapvpwrvgnd_1
X_06956_ cell0.SB0.route_sel\[70\] cell0.SB0.route_sel\[71\] vssd1 vssd1 vccd1 vccd1
+ _02022_ sky130_fd_sc_hd__nand2_1
X_09675_ _01741_ cell3.SB0.route_sel\[106\] cell3.SB0.route_sel\[110\] cell3.SB0.route_sel\[111\]
+ _04689_ vssd1 vssd1 vccd1 vccd1 _04690_ sky130_fd_sc_hd__o221a_1
XFILLER_67_582 vssd1 vssd1 vccd1 vccd1 sky130_fd_sc_hd__fill_1
X_06887_ _01461_ cell0.SB0.route_sel\[57\] cell0.SB0.route_sel\[62\] _01464_ _01954_
+ vssd1 vssd1 vccd1 vccd1 _01955_ sky130_fd_sc_hd__a221o_1
XFILLER_36_26 vssd1 vssd1 vccd1 vccd1 sky130_fd_sc_hd__fill_2
X_08626_ cell1.LE_1A.config_data\[3\] cell1.LE_1A.config_data\[2\] _03546_ vssd1 vssd1
+ vccd1 vccd1 _03662_ sky130_fd_sc_hd__mux2_1
XFILLER_82_585 vssd1 vssd1 vccd1 vccd1 sky130_fd_sc_hd__fill_1
XANTENNA_fanout720_A net723 vssd1 vssd1 vccd1 vccd1 sky130_fd_sc_hd__diode_2
Xclkbuf_leaf_34_clk clknet_4_7_0_clk vssd1 vssd1 vccd1 vccd1 clknet_leaf_34_clk sky130_fd_sc_hd__clkbuf_8
X_08557_ net490 _03591_ _03592_ vssd1 vssd1 vccd1 vccd1 _03593_ sky130_fd_sc_hd__a21oi_1
XANTENNA__10987__A1 _05871_ vssd1 vssd1 vccd1 vccd1 sky130_fd_sc_hd__diode_2
X_08488_ net29 net30 net498 vssd1 vssd1 vccd1 vccd1 _03524_ sky130_fd_sc_hd__mux2_1
X_07508_ _02557_ _02559_ vssd1 vssd1 vccd1 vccd1 _02560_ sky130_fd_sc_hd__nor2_4
XANTENNA__07041__X _02106_ vssd1 vssd1 vccd1 vccd1 sky130_fd_sc_hd__diode_2
X_07439_ _01482_ cell0.SB0.route_sel\[113\] cell0.SB0.route_sel\[118\] _01485_ _02492_
+ vssd1 vssd1 vccd1 vccd1 _02493_ sky130_fd_sc_hd__a221o_2
XFILLER_10_313 vssd1 vssd1 vccd1 vccd1 sky130_fd_sc_hd__fill_1
XFILLER_22_184 vssd1 vssd1 vccd1 vccd1 sky130_fd_sc_hd__fill_2
X_10450_ _05440_ _04521_ vssd1 vssd1 vccd1 vccd1 bus3_2\[7\] sky130_fd_sc_hd__and2b_2
XTAP_TAPCELL_ROW_114_2019 vssd1 vccd1 sky130_fd_sc_hd__tapvpwrvgnd_1
XTAP_TAPCELL_ROW_98_1774 vssd1 vccd1 sky130_fd_sc_hd__tapvpwrvgnd_1
XANTENNA__10739__A1 net18 vssd1 vssd1 vccd1 vccd1 sky130_fd_sc_hd__diode_2
XANTENNA__11498__X net240 vssd1 vssd1 vccd1 vccd1 sky130_fd_sc_hd__diode_2
X_09109_ cell1.CB_0.config_dataB\[18\] cell1.CB_0.config_dataB\[17\] _04138_ vssd1
+ vssd1 vccd1 vccd1 _04139_ sky130_fd_sc_hd__o21ai_1
X_10381_ cell2.LEI0.config_data\[29\] _05379_ _05378_ _05377_ vssd1 vssd1 vccd1 vccd1
+ _05380_ sky130_fd_sc_hd__o211ai_2
XTAP_TAPCELL_ROW_98_1785 vssd1 vccd1 sky130_fd_sc_hd__tapvpwrvgnd_1
XANTENNA__08801__A0 bus3_1\[12\] vssd1 vssd1 vccd1 vccd1 sky130_fd_sc_hd__diode_2
XFILLER_136_587 vssd1 vssd1 vccd1 vccd1 sky130_fd_sc_hd__fill_1
X_12120_ net1375 cell1.LEI0.config_data\[1\] net904 vssd1 vssd1 vccd1 vccd1 _00553_
+ sky130_fd_sc_hd__mux2_1
XFILLER_2_501 vccd1 vssd1 vccd1 vssd1 sky130_ef_sc_hd__decap_40_12
XFILLER_117_51 vssd1 vssd1 vccd1 vccd1 sky130_fd_sc_hd__fill_4
Xhold380 _00574_ vssd1 vssd1 vccd1 vccd1 net1339 sky130_fd_sc_hd__dlygate4sd3_1
XFILLER_7_3 vccd1 vssd1 vccd1 vssd1 sky130_ef_sc_hd__decap_40_12
XFILLER_2_545 vccd1 vssd1 vccd1 vssd1 sky130_ef_sc_hd__decap_40_12
X_12051_ net1093 cell1.LE_1A.config_data\[1\] net890 vssd1 vssd1 vccd1 vccd1 _00487_
+ sky130_fd_sc_hd__mux2_1
Xhold391 _00953_ vssd1 vssd1 vccd1 vccd1 net1350 sky130_fd_sc_hd__dlygate4sd3_1
X_11002_ _05924_ _05934_ vssd1 vssd1 vccd1 vccd1 _05956_ sky130_fd_sc_hd__nor2_1
XFILLER_104_473 vssd1 vssd1 vccd1 vccd1 sky130_fd_sc_hd__fill_2
XANTENNA__08032__B _02897_ vssd1 vssd1 vccd1 vccd1 sky130_fd_sc_hd__diode_2
XFILLER_2_589 vccd1 vssd1 vccd1 vssd1 sky130_ef_sc_hd__decap_40_12
XTAP_TAPCELL_ROW_129_2240 vssd1 vccd1 sky130_fd_sc_hd__tapvpwrvgnd_1
XFILLER_89_195 vssd1 vssd1 vccd1 vccd1 sky130_fd_sc_hd__fill_2
XFILLER_77_335 vssd1 vssd1 vccd1 vccd1 sky130_fd_sc_hd__fill_1
Xfanout860 net862 vssd1 vssd1 vccd1 vccd1 net860 sky130_fd_sc_hd__clkbuf_2
Xfanout882 net883 vssd1 vssd1 vccd1 vccd1 net882 sky130_fd_sc_hd__clkbuf_2
Xfanout893 net894 vssd1 vssd1 vccd1 vccd1 net893 sky130_fd_sc_hd__clkbuf_4
XTAP_TAPCELL_ROW_51_1070 vssd1 vccd1 sky130_fd_sc_hd__tapvpwrvgnd_1
Xfanout871 net884 vssd1 vssd1 vccd1 vccd1 net871 sky130_fd_sc_hd__clkbuf_2
X_12953_ cell3.LE_0B.reset_val cell3.LE_0B.edge_mode net951 vssd1 vssd1 vccd1 vccd1
+ _01381_ sky130_fd_sc_hd__mux2_1
XTAP_TAPCELL_ROW_5_383 vssd1 vccd1 sky130_fd_sc_hd__tapvpwrvgnd_1
XTAP_TAPCELL_ROW_142_2451 vssd1 vccd1 sky130_fd_sc_hd__tapvpwrvgnd_1
XTAP_TAPCELL_ROW_142_2440 vssd1 vccd1 sky130_fd_sc_hd__tapvpwrvgnd_1
X_11904_ cell0.SB0.route_sel\[10\] cell0.SB0.route_sel\[9\] net762 vssd1 vssd1 vccd1
+ vccd1 _00341_ sky130_fd_sc_hd__mux2_1
XANTENNA__08332__A2 bus1_0\[10\] vssd1 vssd1 vccd1 vccd1 sky130_fd_sc_hd__diode_2
X_12884_ cell2.SB0.route_sel\[126\] cell2.SB0.route_sel\[125\] net832 vssd1 vssd1
+ vccd1 vccd1 _01313_ sky130_fd_sc_hd__mux2_1
XANTENNA__09431__X _04454_ vssd1 vssd1 vccd1 vccd1 sky130_fd_sc_hd__diode_2
XFILLER_18_479 vssd1 vssd1 vccd1 vccd1 sky130_fd_sc_hd__fill_1
Xclkbuf_leaf_25_clk clknet_4_5_0_clk vssd1 vssd1 vccd1 vccd1 clknet_leaf_25_clk sky130_fd_sc_hd__clkbuf_8
XANTENNA__10690__A3 net20 vssd1 vssd1 vccd1 vccd1 sky130_fd_sc_hd__diode_2
XANTENNA__11613__S net773 vssd1 vssd1 vccd1 vccd1 sky130_fd_sc_hd__diode_2
XTAP_TAPCELL_ROW_44_967 vssd1 vccd1 sky130_fd_sc_hd__tapvpwrvgnd_1
X_11835_ cell1.CB_1.config_dataA\[16\] net488 net889 vssd1 vssd1 vccd1 vccd1 _00272_
+ sky130_fd_sc_hd__mux2_1
XFILLER_33_449 vssd1 vssd1 vccd1 vccd1 sky130_fd_sc_hd__fill_1
XANTENNA__09293__B1 _04318_ vssd1 vssd1 vccd1 vccd1 sky130_fd_sc_hd__diode_2
XANTENNA__08096__A1 bus2_0\[13\] vssd1 vssd1 vccd1 vccd1 sky130_fd_sc_hd__diode_2
X_11766_ net1092 net1334 net775 vssd1 vssd1 vccd1 vccd1 _00203_ sky130_fd_sc_hd__mux2_1
X_10717_ cell3.LE_1A.config_data\[2\] cell3.LE_1A.config_data\[3\] _05600_ vssd1 vssd1
+ vccd1 vccd1 _05675_ sky130_fd_sc_hd__mux2_1
X_13505_ clknet_leaf_96_clk _00477_ net685 vssd1 vssd1 vccd1 vccd1 cell1.CB_1.config_dataB\[18\]
+ sky130_fd_sc_hd__dfstp_1
XFILLER_9_111 vssd1 vssd1 vccd1 vccd1 sky130_fd_sc_hd__fill_1
X_11697_ cell0.LE_1A.config_data\[16\] net1068 net877 vssd1 vssd1 vccd1 vccd1 _00137_
+ sky130_fd_sc_hd__mux2_1
X_13436_ clknet_leaf_129_clk _00408_ net577 vssd1 vssd1 vccd1 vccd1 cell0.SB0.route_sel\[77\]
+ sky130_fd_sc_hd__dfstp_1
X_10648_ _05519_ _05523_ net393 vssd1 vssd1 vccd1 vccd1 _05606_ sky130_fd_sc_hd__mux2_1
X_10579_ _01787_ _05534_ _05536_ vssd1 vssd1 vccd1 vccd1 _05537_ sky130_fd_sc_hd__a21o_1
X_13367_ clknet_leaf_127_clk _00339_ net576 vssd1 vssd1 vccd1 vccd1 cell0.SB0.route_sel\[8\]
+ sky130_fd_sc_hd__dfstp_1
XFILLER_127_598 vssd1 vssd1 vccd1 vccd1 sky130_fd_sc_hd__fill_1
X_12318_ cell1.SB0.route_sel\[56\] cell1.SB0.route_sel\[55\] net863 vssd1 vssd1 vccd1
+ vccd1 _00751_ sky130_fd_sc_hd__mux2_1
X_13298_ clknet_leaf_103_clk _00270_ net677 vssd1 vssd1 vccd1 vccd1 cell1.CB_1.config_dataA\[14\]
+ sky130_fd_sc_hd__dfstp_1
X_12249_ cell2.CB_0.config_dataA\[12\] net414 net822 vssd1 vssd1 vccd1 vccd1 _00682_
+ sky130_fd_sc_hd__mux2_1
XANTENNA__09899__A2 net315 vssd1 vssd1 vccd1 vccd1 sky130_fd_sc_hd__diode_2
XANTENNA__08020__A1 _02074_ vssd1 vssd1 vccd1 vccd1 sky130_fd_sc_hd__diode_2
XFILLER_110_410 vssd1 vssd1 vccd1 vccd1 sky130_fd_sc_hd__fill_1
XFILLER_69_847 vssd1 vssd1 vccd1 vccd1 sky130_fd_sc_hd__fill_1
XANTENNA__08020__B2 _02172_ vssd1 vssd1 vccd1 vccd1 sky130_fd_sc_hd__diode_2
XFILLER_96_699 vssd1 vssd1 vccd1 vccd1 sky130_fd_sc_hd__fill_1
X_07790_ _02834_ vssd1 vssd1 vccd1 vccd1 _02835_ sky130_fd_sc_hd__inv_2
X_06810_ cell1.SB0.route_sel\[54\] cell1.SB0.route_sel\[55\] _01854_ _01879_ vssd1
+ vssd1 vccd1 vccd1 _01880_ sky130_fd_sc_hd__a211o_1
X_06741_ cell3.LEI0.config_data\[38\] vssd1 vssd1 vccd1 vccd1 _01811_ sky130_fd_sc_hd__inv_2
XANTENNA__07126__X bus2_0\[9\] vssd1 vssd1 vccd1 vccd1 sky130_fd_sc_hd__diode_2
X_09460_ net295 _04478_ vssd1 vssd1 vccd1 vccd1 _04482_ sky130_fd_sc_hd__and2b_1
XTAP_TAPCELL_ROW_69_1342 vssd1 vccd1 sky130_fd_sc_hd__tapvpwrvgnd_1
X_06672_ cell3.SB0.route_sel\[110\] vssd1 vssd1 vccd1 vccd1 _01742_ sky130_fd_sc_hd__inv_2
XANTENNA__07531__B1 net121 vssd1 vssd1 vccd1 vccd1 sky130_fd_sc_hd__diode_2
X_08411_ cell0.CB_1.config_dataB\[19\] _03422_ _03437_ _03448_ vssd1 vssd1 vccd1 vccd1
+ _03449_ sky130_fd_sc_hd__a31o_1
XFILLER_36_287 vssd1 vssd1 vccd1 vccd1 sky130_fd_sc_hd__fill_1
X_09391_ _04218_ _04414_ vssd1 vssd1 vccd1 vccd1 _04415_ sky130_fd_sc_hd__nor2_1
XTAP_TAPCELL_ROW_82_1542 vssd1 vccd1 sky130_fd_sc_hd__tapvpwrvgnd_1
XTAP_TAPCELL_ROW_82_1531 vssd1 vccd1 sky130_fd_sc_hd__tapvpwrvgnd_1
Xclkbuf_leaf_16_clk clknet_4_6_0_clk vssd1 vssd1 vccd1 vccd1 clknet_leaf_16_clk sky130_fd_sc_hd__clkbuf_8
X_08342_ cell0.CB_1.config_dataB\[4\] _03350_ _03355_ _03379_ vssd1 vssd1 vccd1 vccd1
+ _03380_ sky130_fd_sc_hd__a31oi_4
XANTENNA__07834__A1 _02074_ vssd1 vssd1 vccd1 vccd1 sky130_fd_sc_hd__diode_2
X_08273_ _01501_ cell0.LE_1A.dff_out vssd1 vssd1 vccd1 vccd1 _03312_ sky130_fd_sc_hd__or2_1
XTAP_TAPCELL_ROW_22_639 vssd1 vccd1 sky130_fd_sc_hd__tapvpwrvgnd_1
XANTENNA__07834__B2 _02172_ vssd1 vssd1 vccd1 vccd1 sky130_fd_sc_hd__diode_2
X_07224_ _01964_ _02051_ vssd1 vssd1 vccd1 vccd1 _02284_ sky130_fd_sc_hd__nor2_1
XANTENNA_fanout301_A net302 vssd1 vssd1 vccd1 vccd1 sky130_fd_sc_hd__diode_2
XANTENNA__07956__B _02585_ vssd1 vssd1 vccd1 vccd1 sky130_fd_sc_hd__diode_2
X_07155_ net83 _02213_ _02216_ vssd1 vssd1 vccd1 vccd1 _02217_ sky130_fd_sc_hd__a21oi_1
XFILLER_118_587 vssd1 vssd1 vccd1 vccd1 sky130_fd_sc_hd__fill_1
X_07086_ _02140_ _02142_ _02149_ _02141_ vssd1 vssd1 vccd1 vccd1 _02150_ sky130_fd_sc_hd__a22o_1
XANTENNA__11146__A1 net41 vssd1 vssd1 vccd1 vccd1 sky130_fd_sc_hd__diode_2
XANTENNA_fanout291_X net291 vssd1 vssd1 vccd1 vccd1 sky130_fd_sc_hd__diode_2
XFILLER_59_335 vssd1 vssd1 vccd1 vccd1 sky130_fd_sc_hd__fill_1
X_07988_ net529 net530 vssd1 vssd1 vccd1 vccd1 _03030_ sky130_fd_sc_hd__and2b_1
XANTENNA__08562__A2 _03504_ vssd1 vssd1 vccd1 vccd1 sky130_fd_sc_hd__diode_2
XANTENNA_fanout768_A net807 vssd1 vssd1 vccd1 vccd1 sky130_fd_sc_hd__diode_2
X_06939_ _02005_ net311 _02004_ vssd1 vssd1 vccd1 vccd1 _02006_ sky130_fd_sc_hd__mux2_1
XPHY_EDGE_ROW_114_Right_114 vssd1 vssd1 vccd1 vccd1 sky130_fd_sc_hd__decap_3
X_09727_ cell3.SB0.route_sel\[120\] cell3.SB0.route_sel\[121\] _04733_ _04739_ vssd1
+ vssd1 vccd1 vccd1 _04740_ sky130_fd_sc_hd__a31o_1
XFILLER_75_839 vssd1 vssd1 vccd1 vccd1 sky130_fd_sc_hd__fill_1
XTAP_TAPCELL_ROW_2_331 vssd1 vccd1 sky130_fd_sc_hd__tapvpwrvgnd_1
XANTENNA__10657__A0 _05475_ vssd1 vssd1 vccd1 vccd1 sky130_fd_sc_hd__diode_2
XANTENNA_fanout935_A net936 vssd1 vssd1 vccd1 vccd1 sky130_fd_sc_hd__diode_2
XFILLER_67_390 vssd1 vssd1 vccd1 vccd1 sky130_fd_sc_hd__fill_2
XTAP_TAPCELL_ROW_2_342 vssd1 vccd1 sky130_fd_sc_hd__tapvpwrvgnd_1
XFILLER_27_232 vssd1 vssd1 vccd1 vccd1 sky130_fd_sc_hd__fill_1
XTAP_TAPCELL_ROW_124_2170 vssd1 vccd1 sky130_fd_sc_hd__tapvpwrvgnd_1
XFILLER_103_53 vssd1 vssd1 vccd1 vccd1 sky130_fd_sc_hd__fill_2
X_09658_ cell3.SB0.route_sel\[110\] cell3.SB0.route_sel\[111\] net316 _02447_ _04666_
+ vssd1 vssd1 vccd1 vccd1 _04673_ sky130_fd_sc_hd__a221o_1
XANTENNA_fanout723_X net723 vssd1 vssd1 vccd1 vccd1 sky130_fd_sc_hd__diode_2
XANTENNA__10409__A0 net33 vssd1 vssd1 vccd1 vccd1 sky130_fd_sc_hd__diode_2
X_09589_ _01635_ cell2.SB0.route_sel\[95\] cell2.SB0.route_sel\[92\] cell2.SB0.route_sel\[93\]
+ _04605_ vssd1 vssd1 vccd1 vccd1 _04606_ sky130_fd_sc_hd__o221a_1
X_08609_ _03477_ _03623_ _03624_ _03473_ cell1.CB_1.config_dataA\[17\] vssd1 vssd1
+ vccd1 vccd1 _03645_ sky130_fd_sc_hd__a221o_1
X_11620_ net523 net524 net774 vssd1 vssd1 vccd1 vccd1 _00061_ sky130_fd_sc_hd__mux2_1
XTAP_TAPCELL_ROW_41_926 vssd1 vccd1 sky130_fd_sc_hd__tapvpwrvgnd_1
X_11551_ cell0.SB0.route_sel\[20\] _01591_ cell0.SB0.route_sel\[17\] cell0.SB0.route_sel\[16\]
+ _06367_ vssd1 vssd1 vccd1 vccd1 _06368_ sky130_fd_sc_hd__o221a_1
XANTENNA__09027__A0 bus3_1\[0\] vssd1 vssd1 vccd1 vccd1 sky130_fd_sc_hd__diode_2
X_10502_ net333 _02147_ _02148_ _05466_ vssd1 vssd1 vccd1 vccd1 net165 sky130_fd_sc_hd__a22o_1
X_14270_ clknet_leaf_24_clk _01242_ net606 vssd1 vssd1 vccd1 vccd1 cell2.SB0.route_sel\[55\]
+ sky130_fd_sc_hd__dfstp_1
X_11482_ cell1.SB0.route_sel\[114\] _01548_ cell1.SB0.route_sel\[119\] cell1.SB0.route_sel\[118\]
+ _06321_ vssd1 vssd1 vccd1 vccd1 _06322_ sky130_fd_sc_hd__o221a_1
X_10433_ _01691_ cell3.SB0.route_sel\[18\] vssd1 vssd1 vccd1 vccd1 _05429_ sky130_fd_sc_hd__nand2_1
X_13221_ clknet_leaf_13_clk _00193_ net589 vssd1 vssd1 vccd1 vccd1 cell0.LEI0.config_data\[6\]
+ sky130_fd_sc_hd__dfrtp_1
XANTENNA_input64_A CBnorth_in[9] vssd1 vssd1 vccd1 vccd1 sky130_fd_sc_hd__diode_2
X_10364_ net429 _05107_ net426 vssd1 vssd1 vccd1 vccd1 _05363_ sky130_fd_sc_hd__o21ai_1
XFILLER_88_21 vssd1 vssd1 vccd1 vccd1 sky130_fd_sc_hd__fill_4
X_13152_ clknet_leaf_120_clk net1312 net595 vssd1 vssd1 vccd1 vccd1 cell0.LE_1A.config_data\[3\]
+ sky130_fd_sc_hd__dfrtp_1
XFILLER_3_821 vssd1 vssd1 vccd1 vccd1 sky130_fd_sc_hd__fill_2
XFILLER_12_83 vssd1 vssd1 vccd1 vccd1 sky130_fd_sc_hd__fill_1
X_12103_ net1308 net1291 net876 vssd1 vssd1 vccd1 vccd1 _00537_ sky130_fd_sc_hd__mux2_1
X_10295_ _05284_ _05288_ _05293_ _01757_ _05292_ vssd1 vssd1 vccd1 vccd1 _05294_ sky130_fd_sc_hd__a221o_1
X_13083_ clknet_leaf_7_clk _00055_ net568 vssd1 vssd1 vccd1 vccd1 cell0.CB_0.config_dataB\[10\]
+ sky130_fd_sc_hd__dfstp_1
XTAP_TAPCELL_ROW_53_1110 vssd1 vccd1 sky130_fd_sc_hd__tapvpwrvgnd_1
X_12034_ cell1.CB_1.config_dataB\[12\] cell1.CB_1.config_dataB\[11\] net891 vssd1
+ vssd1 vccd1 vccd1 _00471_ sky130_fd_sc_hd__mux2_1
XANTENNA__12637__A1 cell3.SB0.route_sel\[101\] vssd1 vssd1 vccd1 vccd1 sky130_fd_sc_hd__diode_2
Xfanout690 net691 vssd1 vssd1 vccd1 vccd1 net690 sky130_fd_sc_hd__buf_2
XFILLER_19_722 vssd1 vssd1 vccd1 vccd1 sky130_fd_sc_hd__fill_1
X_13985_ clknet_leaf_33_clk _00957_ net634 vssd1 vssd1 vccd1 vccd1 cell2.LEI0.config_data\[42\]
+ sky130_fd_sc_hd__dfrtp_1
XTAP_TAPCELL_ROW_109_1943 vssd1 vccd1 sky130_fd_sc_hd__tapvpwrvgnd_1
XANTENNA__10648__A0 _05519_ vssd1 vssd1 vccd1 vccd1 sky130_fd_sc_hd__diode_2
XANTENNA_output220_A net220 vssd1 vssd1 vccd1 vccd1 sky130_fd_sc_hd__diode_2
X_12936_ net1330 cell3.LE_0B.config_data\[0\] net949 vssd1 vssd1 vccd1 vccd1 _01364_
+ sky130_fd_sc_hd__mux2_1
XFILLER_92_168 vssd1 vssd1 vccd1 vccd1 sky130_fd_sc_hd__fill_2
XTAP_TAPCELL_ROW_29_750 vssd1 vccd1 sky130_fd_sc_hd__tapvpwrvgnd_1
X_12867_ cell2.SB0.route_sel\[109\] cell2.SB0.route_sel\[108\] net809 vssd1 vssd1
+ vccd1 vccd1 _01296_ sky130_fd_sc_hd__mux2_1
XTAP_TAPCELL_ROW_64_1261 vssd1 vccd1 sky130_fd_sc_hd__tapvpwrvgnd_1
X_11818_ cell1.LE_1B.reset_mode cell1.LE_1B.reset_val net905 vssd1 vssd1 vccd1 vccd1
+ _00255_ sky130_fd_sc_hd__mux2_1
X_12798_ cell2.SB0.route_sel\[40\] cell2.SB0.route_sel\[39\] net819 vssd1 vssd1 vccd1
+ vccd1 _01227_ sky130_fd_sc_hd__mux2_1
XTAP_TAPCELL_ROW_64_1272 vssd1 vccd1 sky130_fd_sc_hd__tapvpwrvgnd_1
XANTENNA__08608__A3 net7 vssd1 vssd1 vccd1 vccd1 sky130_fd_sc_hd__diode_2
X_11749_ net961 net548 _06376_ vssd1 vssd1 vccd1 vccd1 _00186_ sky130_fd_sc_hd__a21bo_1
X_14468_ clknet_leaf_64_clk _01440_ net747 vssd1 vssd1 vccd1 vccd1 cell3.LEI0.config_data\[33\]
+ sky130_fd_sc_hd__dfrtp_1
X_14399_ clknet_leaf_57_clk net1062 net722 vssd1 vssd1 vccd1 vccd1 cell3.LE_0B.config_data\[8\]
+ sky130_fd_sc_hd__dfrtp_1
X_13419_ clknet_leaf_133_clk _00391_ net557 vssd1 vssd1 vccd1 vccd1 cell0.SB0.route_sel\[60\]
+ sky130_fd_sc_hd__dfstp_1
XANTENNA__10179__A2 net55 vssd1 vssd1 vccd1 vccd1 sky130_fd_sc_hd__diode_2
XFILLER_6_681 vccd1 vssd1 vccd1 vssd1 sky130_ef_sc_hd__decap_40_12
XFILLER_142_343 vssd1 vssd1 vccd1 vccd1 sky130_fd_sc_hd__fill_1
XFILLER_127_395 vssd1 vssd1 vccd1 vccd1 sky130_fd_sc_hd__fill_1
XANTENNA__07595__A3 _02637_ vssd1 vssd1 vccd1 vccd1 sky130_fd_sc_hd__diode_2
Xclkbuf_leaf_5_clk clknet_4_1_0_clk vssd1 vssd1 vccd1 vccd1 clknet_leaf_5_clk sky130_fd_sc_hd__clkbuf_8
X_08960_ bus3_1\[8\] bus3_1\[9\] bus3_1\[10\] bus3_1\[11\] net465 net463 vssd1 vssd1
+ vccd1 vccd1 _03992_ sky130_fd_sc_hd__mux4_1
XFILLER_124_19 vssd1 vssd1 vccd1 vccd1 sky130_fd_sc_hd__fill_8
X_08891_ cell1.CB_0.config_dataA\[3\] cell1.CB_0.config_dataA\[2\] vssd1 vssd1 vccd1
+ vccd1 _03923_ sky130_fd_sc_hd__nor2_1
X_07911_ net515 _01913_ _02954_ cell0.CB_0.config_dataA\[11\] vssd1 vssd1 vccd1 vccd1
+ _02955_ sky130_fd_sc_hd__o211a_1
XANTENNA__08544__A2 _01821_ vssd1 vssd1 vccd1 vccd1 sky130_fd_sc_hd__diode_2
X_07842_ _02885_ vssd1 vssd1 vccd1 vccd1 _02886_ sky130_fd_sc_hd__inv_2
XFILLER_84_625 vssd1 vssd1 vccd1 vccd1 sky130_fd_sc_hd__fill_1
XFILLER_83_113 vssd1 vssd1 vccd1 vccd1 sky130_fd_sc_hd__fill_1
XFILLER_57_839 vssd1 vssd1 vccd1 vccd1 sky130_fd_sc_hd__fill_1
XANTENNA__10639__A0 net286 vssd1 vssd1 vccd1 vccd1 sky130_fd_sc_hd__diode_2
XFILLER_83_146 vccd1 vssd1 vccd1 vssd1 sky130_ef_sc_hd__decap_40_12
XPHY_EDGE_ROW_3_Left_146 vssd1 vssd1 vccd1 vccd1 sky130_fd_sc_hd__decap_3
XTAP_TAPCELL_ROW_27_709 vssd1 vccd1 sky130_fd_sc_hd__tapvpwrvgnd_1
X_09512_ _03850_ _03851_ _03852_ _02069_ _02064_ vssd1 vssd1 vccd1 vccd1 _04532_ sky130_fd_sc_hd__a311o_1
X_07773_ cell1.SB0.route_sel\[32\] cell1.SB0.route_sel\[33\] _02815_ _02818_ vssd1
+ vssd1 vccd1 vccd1 _02819_ sky130_fd_sc_hd__o2bb2a_1
XFILLER_140_29 vccd1 vssd1 vccd1 vssd1 sky130_ef_sc_hd__decap_40_12
X_06724_ cell3.LEI0.config_data\[5\] vssd1 vssd1 vccd1 vccd1 _01794_ sky130_fd_sc_hd__inv_2
XFILLER_17_39 vccd1 vssd1 vccd1 vssd1 sky130_ef_sc_hd__decap_40_12
XFILLER_25_703 vssd1 vssd1 vccd1 vccd1 sky130_fd_sc_hd__fill_1
X_09443_ _04463_ _04465_ vssd1 vssd1 vccd1 vccd1 bus3_1\[5\] sky130_fd_sc_hd__and2_4
XFILLER_80_831 vssd1 vssd1 vccd1 vccd1 sky130_fd_sc_hd__fill_1
X_06655_ cell3.SB0.route_sel\[74\] vssd1 vssd1 vccd1 vccd1 _01725_ sky130_fd_sc_hd__inv_2
XFILLER_24_213 vssd1 vssd1 vccd1 vccd1 sky130_fd_sc_hd__fill_1
X_09374_ _01600_ cell2.SB0.route_sel\[39\] cell2.SB0.route_sel\[36\] cell2.SB0.route_sel\[37\]
+ _04397_ vssd1 vssd1 vccd1 vccd1 _04398_ sky130_fd_sc_hd__o221a_1
XANTENNA_fanout349_A net350 vssd1 vssd1 vccd1 vccd1 sky130_fd_sc_hd__diode_2
X_06586_ cell1.CB_1.config_dataB\[7\] vssd1 vssd1 vccd1 vccd1 _01656_ sky130_fd_sc_hd__inv_2
X_08325_ _03361_ _03362_ cell0.CB_1.config_dataB\[2\] vssd1 vssd1 vccd1 vccd1 _03363_
+ sky130_fd_sc_hd__or3b_1
XFILLER_33_27 vccd1 vssd1 vccd1 vssd1 sky130_ef_sc_hd__decap_40_12
XFILLER_130_9 vccd1 vssd1 vccd1 vssd1 sky130_ef_sc_hd__decap_40_12
XANTENNA__10811__A0 net15 vssd1 vssd1 vccd1 vccd1 sky130_fd_sc_hd__diode_2
XANTENNA__07807__A1 net78 vssd1 vssd1 vccd1 vccd1 sky130_fd_sc_hd__diode_2
XFILLER_119_841 vssd1 vssd1 vccd1 vccd1 sky130_fd_sc_hd__fill_1
X_08256_ cell0.CB_1.config_dataA\[18\] _03274_ _03278_ _03280_ cell0.CB_1.config_dataA\[19\]
+ vssd1 vssd1 vccd1 vccd1 _03296_ sky130_fd_sc_hd__a41o_1
XANTENNA__12084__S net905 vssd1 vssd1 vccd1 vccd1 sky130_fd_sc_hd__diode_2
X_08187_ _03219_ _03222_ _03226_ cell0.CB_1.config_dataA\[8\] vssd1 vssd1 vccd1 vccd1
+ _03227_ sky130_fd_sc_hd__and4bb_1
X_07207_ _02265_ _02266_ _02262_ _02263_ vssd1 vssd1 vccd1 vccd1 _02267_ sky130_fd_sc_hd__a2bb2o_1
XTAP_TAPCELL_ROW_95_1733 vssd1 vccd1 sky130_fd_sc_hd__tapvpwrvgnd_1
XANTENNA_clkbuf_leaf_81_clk_A clknet_4_12_0_clk vssd1 vssd1 vccd1 vccd1 sky130_fd_sc_hd__diode_2
XANTENNA__08232__A1 _02422_ vssd1 vssd1 vccd1 vccd1 sky130_fd_sc_hd__diode_2
X_07138_ _02198_ _02199_ _02195_ _02196_ vssd1 vssd1 vccd1 vccd1 _02200_ sky130_fd_sc_hd__a2bb2o_1
XFILLER_106_535 vssd1 vssd1 vccd1 vccd1 sky130_fd_sc_hd__fill_1
XANTENNA__11119__A1 _05924_ vssd1 vssd1 vccd1 vccd1 sky130_fd_sc_hd__diode_2
XANTENNA__09980__A1 _04555_ vssd1 vssd1 vccd1 vccd1 sky130_fd_sc_hd__diode_2
Xoutput260 net260 vssd1 vssd1 vccd1 vccd1 SBwest_out[8] sky130_fd_sc_hd__buf_2
XTAP_TAPCELL_ROW_7_412 vssd1 vccd1 sky130_fd_sc_hd__tapvpwrvgnd_1
XFILLER_0_813 vssd1 vssd1 vccd1 vccd1 sky130_fd_sc_hd__fill_1
X_07069_ cell0.SB0.route_sel\[79\] cell0.SB0.route_sel\[78\] vssd1 vssd1 vccd1 vccd1
+ _02133_ sky130_fd_sc_hd__nand2b_1
X_10080_ _05081_ _04225_ vssd1 vssd1 vccd1 vccd1 bus3_2\[0\] sky130_fd_sc_hd__and2b_4
XANTENNA_clkbuf_leaf_96_clk_A clknet_4_10_0_clk vssd1 vssd1 vccd1 vccd1 sky130_fd_sc_hd__diode_2
XFILLER_75_603 vssd1 vssd1 vccd1 vccd1 sky130_fd_sc_hd__fill_4
XFILLER_114_41 vssd1 vssd1 vccd1 vccd1 sky130_fd_sc_hd__fill_8
X_10982_ _05856_ _05933_ _05935_ _05861_ _01809_ vssd1 vssd1 vccd1 vccd1 _05936_ sky130_fd_sc_hd__a221o_1
XFILLER_114_96 vssd1 vssd1 vccd1 vccd1 sky130_fd_sc_hd__fill_1
XFILLER_15_202 vssd1 vssd1 vccd1 vccd1 sky130_fd_sc_hd__fill_2
XFILLER_16_714 vssd1 vssd1 vccd1 vccd1 sky130_fd_sc_hd__fill_1
X_13770_ clknet_leaf_110_clk _00742_ net656 vssd1 vssd1 vccd1 vccd1 cell1.SB0.route_sel\[47\]
+ sky130_fd_sc_hd__dfstp_1
X_12721_ cell3.CB_0.config_dataB\[13\] cell3.CB_0.config_dataB\[12\] net932 vssd1
+ vssd1 vccd1 vccd1 _01150_ sky130_fd_sc_hd__mux2_1
XANTENNA__09422__A _04442_ vssd1 vssd1 vccd1 vccd1 sky130_fd_sc_hd__diode_2
XTAP_TAPCELL_ROW_104_1862 vssd1 vccd1 sky130_fd_sc_hd__tapvpwrvgnd_1
X_12652_ cell3.SB0.route_sel\[117\] cell3.SB0.route_sel\[116\] net917 vssd1 vssd1
+ vccd1 vccd1 _01081_ sky130_fd_sc_hd__mux2_1
XANTENNA_clkbuf_leaf_34_clk_A clknet_4_7_0_clk vssd1 vssd1 vccd1 vccd1 sky130_fd_sc_hd__diode_2
XTAP_TAPCELL_ROW_104_1873 vssd1 vccd1 sky130_fd_sc_hd__tapvpwrvgnd_1
X_11603_ cell0.CB_1.config_dataA\[24\] cell0.CB_1.config_dataA\[23\] net859 vssd1
+ vssd1 vccd1 vccd1 _00044_ sky130_fd_sc_hd__mux2_1
X_12583_ cell3.SB0.route_sel\[48\] cell3.SB0.route_sel\[47\] net915 vssd1 vssd1 vccd1
+ vccd1 _01012_ sky130_fd_sc_hd__mux2_1
XTAP_TAPCELL_ROW_137_2361 vssd1 vccd1 sky130_fd_sc_hd__tapvpwrvgnd_1
X_11534_ _06356_ _02603_ vssd1 vssd1 vccd1 vccd1 net254 sky130_fd_sc_hd__and2b_2
X_14322_ clknet_leaf_21_clk _01294_ net612 vssd1 vssd1 vccd1 vccd1 cell2.SB0.route_sel\[107\]
+ sky130_fd_sc_hd__dfstp_1
XANTENNA_clkbuf_leaf_49_clk_A clknet_4_12_0_clk vssd1 vssd1 vccd1 vccd1 sky130_fd_sc_hd__diode_2
X_14253_ clknet_leaf_19_clk _01225_ net613 vssd1 vssd1 vccd1 vccd1 cell2.SB0.route_sel\[38\]
+ sky130_fd_sc_hd__dfstp_1
X_11465_ _02069_ _06310_ vssd1 vssd1 vccd1 vccd1 net214 sky130_fd_sc_hd__nor2_1
XANTENNA__11399__A _02132_ vssd1 vssd1 vccd1 vccd1 sky130_fd_sc_hd__diode_2
X_10416_ cell2.LE_0B.config_data\[7\] cell2.LE_0B.config_data\[6\] _05344_ vssd1 vssd1
+ vccd1 vccd1 _05415_ sky130_fd_sc_hd__mux2_1
XFILLER_139_93 vccd1 vssd1 vccd1 vssd1 sky130_ef_sc_hd__decap_40_12
XFILLER_137_671 vssd1 vssd1 vccd1 vccd1 sky130_fd_sc_hd__fill_1
X_13204_ clknet_leaf_23_clk _00176_ net603 vssd1 vssd1 vccd1 vccd1 cell0.LE_0A.config_data\[11\]
+ sky130_fd_sc_hd__dfrtp_1
XANTENNA_output170_A net170 vssd1 vssd1 vccd1 vccd1 sky130_fd_sc_hd__diode_2
X_14184_ clknet_leaf_58_clk _01156_ net721 vssd1 vssd1 vccd1 vccd1 cell3.CB_0.config_dataB\[19\]
+ sky130_fd_sc_hd__dfstp_1
X_11396_ _02037_ _06264_ vssd1 vssd1 vccd1 vccd1 net260 sky130_fd_sc_hd__and2b_1
XANTENNA_input67_X net67 vssd1 vssd1 vccd1 vccd1 sky130_fd_sc_hd__diode_2
XFILLER_140_825 vccd1 vssd1 vccd1 vssd1 sky130_ef_sc_hd__decap_40_12
XANTENNA__12722__S net932 vssd1 vssd1 vccd1 vccd1 sky130_fd_sc_hd__diode_2
X_10347_ net428 _05131_ net426 vssd1 vssd1 vccd1 vccd1 _05346_ sky130_fd_sc_hd__o21ai_1
X_13135_ clknet_leaf_127_clk _00107_ net581 vssd1 vssd1 vccd1 vccd1 cell0.CB_1.config_dataB\[12\]
+ sky130_fd_sc_hd__dfstp_2
XFILLER_3_673 vccd1 vssd1 vccd1 vssd1 sky130_ef_sc_hd__decap_40_12
XANTENNA__06785__A1 net361 vssd1 vssd1 vccd1 vccd1 sky130_fd_sc_hd__diode_2
XFILLER_140_847 vssd1 vssd1 vccd1 vccd1 sky130_fd_sc_hd__fill_1
X_10278_ cell2.LE_0A.config_data\[16\] _05276_ _05277_ net351 vssd1 vssd1 vccd1 vccd1
+ cell2.CB_0.le_outA sky130_fd_sc_hd__o211a_1
X_13066_ clknet_leaf_125_clk _00038_ net583 vssd1 vssd1 vccd1 vccd1 cell0.CB_1.config_dataA\[18\]
+ sky130_fd_sc_hd__dfstp_1
XANTENNA__10869__A0 net286 vssd1 vssd1 vccd1 vccd1 sky130_fd_sc_hd__diode_2
XFILLER_78_463 vssd1 vssd1 vccd1 vccd1 sky130_fd_sc_hd__fill_4
X_12017_ cell0.SB0.route_sel\[123\] cell0.SB0.route_sel\[122\] net776 vssd1 vssd1
+ vccd1 vccd1 _00454_ sky130_fd_sc_hd__mux2_1
XANTENNA_clkbuf_leaf_107_clk_A clknet_4_8_0_clk vssd1 vssd1 vccd1 vccd1 sky130_fd_sc_hd__diode_2
XANTENNA__10333__A2 _05088_ vssd1 vssd1 vccd1 vccd1 sky130_fd_sc_hd__diode_2
XFILLER_38_338 vssd1 vssd1 vccd1 vccd1 sky130_fd_sc_hd__fill_1
X_13968_ clknet_leaf_34_clk _00940_ net638 vssd1 vssd1 vccd1 vccd1 cell2.LEI0.config_data\[25\]
+ sky130_fd_sc_hd__dfrtp_1
XTAP_TAPCELL_ROW_66_1301 vssd1 vccd1 sky130_fd_sc_hd__tapvpwrvgnd_1
XFILLER_0_53 vssd1 vssd1 vccd1 vccd1 sky130_fd_sc_hd__fill_2
X_12919_ net1488 net1467 net954 vssd1 vssd1 vccd1 vccd1 _01348_ sky130_fd_sc_hd__mux2_1
XANTENNA__13850__Q cell1.SB0.config_data_out vssd1 vssd1 vccd1 vccd1 sky130_fd_sc_hd__diode_2
XFILLER_19_596 vssd1 vssd1 vccd1 vccd1 sky130_fd_sc_hd__fill_4
XFILLER_34_522 vssd1 vssd1 vccd1 vccd1 sky130_fd_sc_hd__fill_1
XFILLER_34_533 vssd1 vssd1 vccd1 vccd1 sky130_fd_sc_hd__fill_2
XANTENNA__11073__S _05930_ vssd1 vssd1 vccd1 vccd1 sky130_fd_sc_hd__diode_2
X_13899_ clknet_leaf_37_clk _00871_ net639 vssd1 vssd1 vccd1 vccd1 cell2.LE_0B.config_data\[0\]
+ sky130_fd_sc_hd__dfrtp_1
X_06440_ cell1.SB0.route_sel\[28\] vssd1 vssd1 vccd1 vccd1 _01510_ sky130_fd_sc_hd__inv_2
XANTENNA__10197__B _05103_ vssd1 vssd1 vccd1 vccd1 sky130_fd_sc_hd__diode_2
XFILLER_9_51 vssd1 vssd1 vccd1 vccd1 sky130_fd_sc_hd__fill_4
X_08110_ cell0.LE_0B.config_data\[3\] cell0.LE_0B.config_data\[2\] _03087_ vssd1 vssd1
+ vccd1 vccd1 _03152_ sky130_fd_sc_hd__mux2_1
X_09090_ cell1.CB_0.config_dataB\[14\] _04101_ _04116_ _04119_ vssd1 vssd1 vccd1 vccd1
+ _04120_ sky130_fd_sc_hd__o31a_1
XANTENNA__11801__S net902 vssd1 vssd1 vccd1 vccd1 sky130_fd_sc_hd__diode_2
XTAP_TAPCELL_ROW_32_789 vssd1 vccd1 sky130_fd_sc_hd__tapvpwrvgnd_1
X_08041_ _03078_ _03081_ _03082_ _01556_ vssd1 vssd1 vccd1 vccd1 _03083_ sky130_fd_sc_hd__a2bb2o_1
XANTENNA__11349__A1 _05871_ vssd1 vssd1 vccd1 vccd1 sky130_fd_sc_hd__diode_2
XTAP_TAPCELL_ROW_12_491 vssd1 vccd1 sky130_fd_sc_hd__tapvpwrvgnd_1
XANTENNA__10021__A1 cell2.CB_0.le_outB vssd1 vssd1 vccd1 vccd1 sky130_fd_sc_hd__diode_2
XANTENNA_clkbuf_4_6_0_clk_A clknet_0_clk vssd1 vssd1 vccd1 vccd1 sky130_fd_sc_hd__diode_2
XTAP_TAPCELL_ROW_77_1463 vssd1 vccd1 sky130_fd_sc_hd__tapvpwrvgnd_1
X_09992_ net402 net404 vssd1 vssd1 vccd1 vccd1 _04996_ sky130_fd_sc_hd__and2b_2
XANTENNA__07568__A3 net97 vssd1 vssd1 vccd1 vccd1 sky130_fd_sc_hd__diode_2
XTAP_TAPCELL_ROW_90_1652 vssd1 vccd1 sky130_fd_sc_hd__tapvpwrvgnd_1
XANTENNA__09507__A _02106_ vssd1 vssd1 vccd1 vccd1 sky130_fd_sc_hd__diode_2
X_08943_ net463 _03971_ _03974_ vssd1 vssd1 vccd1 vccd1 _03975_ sky130_fd_sc_hd__a21o_1
Xclkbuf_4_15_0_clk clknet_0_clk vssd1 vssd1 vccd1 vccd1 clknet_4_15_0_clk sky130_fd_sc_hd__clkbuf_8
XANTENNA__09714__A1 _02592_ vssd1 vssd1 vccd1 vccd1 sky130_fd_sc_hd__diode_2
XTAP_TAPCELL_ROW_90_1663 vssd1 vccd1 sky130_fd_sc_hd__tapvpwrvgnd_1
XFILLER_97_783 vssd1 vssd1 vccd1 vccd1 sky130_fd_sc_hd__fill_1
X_08874_ net473 net472 vssd1 vssd1 vccd1 vccd1 _03906_ sky130_fd_sc_hd__nor2_1
XANTENNA__07027__A cell2.CB_1.le_outA vssd1 vssd1 vccd1 vccd1 sky130_fd_sc_hd__diode_2
X_07825_ net518 net517 vssd1 vssd1 vccd1 vccd1 _02869_ sky130_fd_sc_hd__nor2_1
XANTENNA__09478__B1 _02008_ vssd1 vssd1 vccd1 vccd1 sky130_fd_sc_hd__diode_2
X_07756_ _02800_ _02801_ vssd1 vssd1 vccd1 vccd1 _02802_ sky130_fd_sc_hd__nor2_1
X_06707_ cell3.CB_1.config_dataB\[2\] vssd1 vssd1 vccd1 vccd1 _01777_ sky130_fd_sc_hd__inv_2
XANTENNA_fanout633_A net635 vssd1 vssd1 vccd1 vccd1 sky130_fd_sc_hd__diode_2
X_09426_ _04427_ _04446_ _04448_ vssd1 vssd1 vccd1 vccd1 _04449_ sky130_fd_sc_hd__o21ai_1
XFILLER_80_650 vssd1 vssd1 vccd1 vccd1 sky130_fd_sc_hd__fill_1
X_07687_ _01831_ _01888_ _02650_ _02646_ _01884_ vssd1 vssd1 vccd1 vccd1 _02735_ sky130_fd_sc_hd__o32a_1
X_06638_ cell3.SB0.route_sel\[44\] vssd1 vssd1 vccd1 vccd1 _01708_ sky130_fd_sc_hd__inv_2
XFILLER_100_21 vssd1 vssd1 vccd1 vccd1 sky130_fd_sc_hd__fill_4
XFILLER_52_374 vssd1 vssd1 vccd1 vccd1 sky130_fd_sc_hd__fill_1
XFILLER_12_227 vssd1 vssd1 vccd1 vccd1 sky130_fd_sc_hd__fill_1
X_06569_ net117 vssd1 vssd1 vccd1 vccd1 _01639_ sky130_fd_sc_hd__inv_2
X_09357_ _01600_ _01601_ net109 cell2.SB0.route_sel\[36\] cell2.SB0.route_sel\[37\]
+ vssd1 vssd1 vccd1 vccd1 _04381_ sky130_fd_sc_hd__o2111a_1
XANTENNA_fanout800_A net806 vssd1 vssd1 vccd1 vccd1 sky130_fd_sc_hd__diode_2
X_09288_ cell3.CB_0.config_dataB\[22\] net380 _04313_ vssd1 vssd1 vccd1 vccd1 _04314_
+ sky130_fd_sc_hd__or3_1
XANTENNA__08989__C1 net351 vssd1 vssd1 vccd1 vccd1 sky130_fd_sc_hd__diode_2
X_08308_ cell0.CB_1.config_dataB\[9\] _03315_ _03332_ _03345_ vssd1 vssd1 vccd1 vccd1
+ _03346_ sky130_fd_sc_hd__a31o_1
X_08239_ bus1_0\[8\] bus1_0\[9\] bus1_0\[10\] bus1_0\[11\] net536 net535 vssd1 vssd1
+ vccd1 vccd1 _03279_ sky130_fd_sc_hd__mux4_1
XFILLER_119_671 vssd1 vssd1 vccd1 vccd1 sky130_fd_sc_hd__fill_1
XTAP_TAPCELL_ROW_119_2091 vssd1 vccd1 sky130_fd_sc_hd__tapvpwrvgnd_1
XFILLER_107_822 vssd1 vssd1 vccd1 vccd1 sky130_fd_sc_hd__fill_1
XFILLER_4_415 vssd1 vssd1 vccd1 vccd1 sky130_fd_sc_hd__fill_4
XANTENNA__12416__B1_N _06381_ vssd1 vssd1 vccd1 vccd1 sky130_fd_sc_hd__diode_2
XFILLER_107_3 vccd1 vssd1 vccd1 vssd1 sky130_ef_sc_hd__decap_40_12
XANTENNA__10548__C1 _05503_ vssd1 vssd1 vccd1 vccd1 sky130_fd_sc_hd__diode_2
X_11250_ net698 cell1.LE_0A.reset_mode vssd1 vssd1 vccd1 vccd1 _11250_/X sky130_fd_sc_hd__xor2_2
XANTENNA_fanout790_X net790 vssd1 vssd1 vccd1 vccd1 sky130_fd_sc_hd__diode_2
XTAP_TAPCELL_ROW_132_2291 vssd1 vccd1 sky130_fd_sc_hd__tapvpwrvgnd_1
X_11181_ _05924_ _06109_ _06110_ _05921_ vssd1 vssd1 vccd1 vccd1 _06133_ sky130_fd_sc_hd__a2bb2o_1
X_10201_ net319 _05113_ _05201_ _01770_ vssd1 vssd1 vccd1 vccd1 _05202_ sky130_fd_sc_hd__a31o_1
XANTENNA__10012__A1 bus3_2\[2\] vssd1 vssd1 vccd1 vccd1 sky130_fd_sc_hd__diode_2
XFILLER_121_335 vssd1 vssd1 vccd1 vccd1 sky130_fd_sc_hd__fill_1
X_10132_ net418 _05128_ _05132_ vssd1 vssd1 vccd1 vccd1 _05133_ sky130_fd_sc_hd__a21o_1
XFILLER_125_51 vssd1 vssd1 vccd1 vccd1 sky130_fd_sc_hd__fill_4
XPHY_EDGE_ROW_66_Left_209 vssd1 vssd1 vccd1 vccd1 sky130_fd_sc_hd__decap_3
XANTENNA__08508__A2 net336 vssd1 vssd1 vccd1 vccd1 sky130_fd_sc_hd__diode_2
XFILLER_125_73 vssd1 vssd1 vccd1 vccd1 sky130_fd_sc_hd__fill_2
X_10063_ cell2.LE_1B.config_data\[2\] cell2.LE_1B.config_data\[3\] _04956_ vssd1 vssd1
+ vccd1 vccd1 _05067_ sky130_fd_sc_hd__mux2_1
XFILLER_85_11 vccd1 vssd1 vccd1 vssd1 sky130_ef_sc_hd__decap_40_12
XFILLER_87_293 vssd1 vssd1 vccd1 vccd1 sky130_fd_sc_hd__fill_1
XFILLER_85_55 vssd1 vssd1 vccd1 vccd1 sky130_fd_sc_hd__fill_1
XANTENNA_input27_A CBeast_in[4] vssd1 vssd1 vccd1 vccd1 sky130_fd_sc_hd__diode_2
XTAP_TAPCELL_ROW_106_1902 vssd1 vccd1 sky130_fd_sc_hd__tapvpwrvgnd_1
XANTENNA_input121_X net121 vssd1 vssd1 vccd1 vccd1 sky130_fd_sc_hd__diode_2
X_13822_ clknet_leaf_104_clk _00794_ net678 vssd1 vssd1 vccd1 vccd1 cell1.SB0.route_sel\[99\]
+ sky130_fd_sc_hd__dfstp_1
XTAP_TAPCELL_ROW_48_1031 vssd1 vccd1 sky130_fd_sc_hd__tapvpwrvgnd_1
X_13753_ clknet_leaf_108_clk _00725_ net652 vssd1 vssd1 vccd1 vccd1 cell1.SB0.route_sel\[30\]
+ sky130_fd_sc_hd__dfstp_1
X_10965_ cell3.SB0.route_sel\[13\] cell3.SB0.route_sel\[12\] vssd1 vssd1 vccd1 vccd1
+ _05919_ sky130_fd_sc_hd__and2b_1
X_12704_ cell3.CB_1.config_dataA\[21\] cell3.CB_1.config_dataA\[20\] net940 vssd1
+ vssd1 vccd1 vccd1 _01133_ sky130_fd_sc_hd__mux2_1
XFILLER_16_555 vssd1 vssd1 vccd1 vccd1 sky130_fd_sc_hd__fill_1
X_13684_ clknet_leaf_29_clk _00656_ net619 vssd1 vssd1 vccd1 vccd1 cell2.CB_0.config_dataB\[11\]
+ sky130_fd_sc_hd__dfstp_1
XANTENNA__11028__A0 net47 vssd1 vssd1 vccd1 vccd1 sky130_fd_sc_hd__diode_2
X_10896_ net272 _05849_ vssd1 vssd1 vccd1 vccd1 _05850_ sky130_fd_sc_hd__nor2_1
XPHY_EDGE_ROW_75_Left_218 vssd1 vssd1 vccd1 vccd1 sky130_fd_sc_hd__decap_3
XFILLER_71_694 vssd1 vssd1 vccd1 vccd1 sky130_fd_sc_hd__fill_1
X_12635_ cell3.SB0.route_sel\[100\] cell3.SB0.route_sel\[99\] net922 vssd1 vssd1 vccd1
+ vccd1 _01064_ sky130_fd_sc_hd__mux2_1
XTAP_TAPCELL_ROW_61_1220 vssd1 vccd1 sky130_fd_sc_hd__tapvpwrvgnd_1
XFILLER_34_81 vssd1 vssd1 vccd1 vccd1 sky130_fd_sc_hd__fill_2
X_12566_ cell3.SB0.route_sel\[31\] cell3.SB0.route_sel\[30\] net910 vssd1 vssd1 vccd1
+ vccd1 _00995_ sky130_fd_sc_hd__mux2_1
XANTENNA__11579__A1 cell0.CB_0.config_dataB\[24\] vssd1 vssd1 vccd1 vccd1 sky130_fd_sc_hd__diode_2
XANTENNA__10251__A1 net319 vssd1 vssd1 vccd1 vccd1 sky130_fd_sc_hd__diode_2
X_14305_ clknet_leaf_17_clk _01277_ net627 vssd1 vssd1 vccd1 vccd1 cell2.SB0.route_sel\[90\]
+ sky130_fd_sc_hd__dfstp_1
X_11517_ _01630_ cell2.SB0.route_sel\[82\] vssd1 vssd1 vccd1 vccd1 _06345_ sky130_fd_sc_hd__nand2_1
X_12497_ cell2.LEI0.config_data\[11\] net1321 net846 vssd1 vssd1 vccd1 vccd1 _00926_
+ sky130_fd_sc_hd__mux2_1
Xhold209 cell2.LE_1B.config_data\[11\] vssd1 vssd1 vccd1 vccd1 net1168 sky130_fd_sc_hd__dlygate4sd3_1
X_14236_ clknet_leaf_20_clk _01208_ net611 vssd1 vssd1 vccd1 vccd1 cell2.SB0.route_sel\[21\]
+ sky130_fd_sc_hd__dfstp_1
X_11448_ cell1.SB0.route_sel\[25\] cell1.SB0.route_sel\[24\] vssd1 vssd1 vccd1 vccd1
+ _06299_ sky130_fd_sc_hd__nand2b_1
X_14167_ clknet_leaf_52_clk _01139_ net716 vssd1 vssd1 vccd1 vccd1 cell3.CB_0.config_dataB\[2\]
+ sky130_fd_sc_hd__dfstp_1
XTAP_TAPCELL_ROW_59_1193 vssd1 vccd1 sky130_fd_sc_hd__tapvpwrvgnd_1
X_11379_ cell0.SB0.route_sel\[54\] cell0.SB0.route_sel\[55\] vssd1 vssd1 vccd1 vccd1
+ _06253_ sky130_fd_sc_hd__or2_1
XPHY_EDGE_ROW_84_Left_227 vssd1 vssd1 vccd1 vccd1 sky130_fd_sc_hd__decap_3
X_13118_ clknet_leaf_7_clk _00090_ net568 vssd1 vssd1 vccd1 vccd1 cell0.CB_0.config_dataA\[20\]
+ sky130_fd_sc_hd__dfstp_1
X_14098_ clknet_leaf_51_clk _01070_ net712 vssd1 vssd1 vccd1 vccd1 cell3.SB0.route_sel\[106\]
+ sky130_fd_sc_hd__dfstp_1
XTAP_TAPCELL_ROW_72_1393 vssd1 vccd1 sky130_fd_sc_hd__tapvpwrvgnd_1
XTAP_TAPCELL_ROW_72_1382 vssd1 vccd1 sky130_fd_sc_hd__tapvpwrvgnd_1
XANTENNA__07707__B1 bus2_0\[3\] vssd1 vssd1 vccd1 vccd1 sky130_fd_sc_hd__diode_2
X_13049_ clknet_leaf_126_clk _00021_ net582 vssd1 vssd1 vccd1 vccd1 cell0.CB_1.config_dataA\[1\]
+ sky130_fd_sc_hd__dfstp_1
XFILLER_120_390 vssd1 vssd1 vccd1 vccd1 sky130_fd_sc_hd__fill_1
XFILLER_94_764 vssd1 vssd1 vccd1 vccd1 sky130_fd_sc_hd__fill_1
XANTENNA__09172__A2 _04174_ vssd1 vssd1 vccd1 vccd1 sky130_fd_sc_hd__diode_2
X_07610_ net355 net353 vssd1 vssd1 vccd1 vccd1 _02659_ sky130_fd_sc_hd__nor2_1
X_08590_ _03517_ _03514_ _03504_ _03510_ net488 net487 vssd1 vssd1 vccd1 vccd1 _03626_
+ sky130_fd_sc_hd__mux4_1
X_07541_ _01995_ _02376_ vssd1 vssd1 vccd1 vccd1 _02592_ sky130_fd_sc_hd__nor2_1
XFILLER_19_393 vssd1 vssd1 vccd1 vccd1 sky130_fd_sc_hd__fill_8
XPHY_EDGE_ROW_93_Left_236 vssd1 vssd1 vccd1 vccd1 sky130_fd_sc_hd__decap_3
XANTENNA__08132__A0 bus1_0\[12\] vssd1 vssd1 vccd1 vccd1 sky130_fd_sc_hd__diode_2
XTAP_TAPCELL_ROW_37_859 vssd1 vccd1 sky130_fd_sc_hd__tapvpwrvgnd_1
X_07472_ _01483_ cell0.SB0.route_sel\[116\] _01484_ cell0.SB0.route_sel\[119\] _02524_
+ vssd1 vssd1 vccd1 vccd1 _02525_ sky130_fd_sc_hd__a221o_1
XTAP_TAPCELL_ROW_17_561 vssd1 vccd1 sky130_fd_sc_hd__tapvpwrvgnd_1
XANTENNA__06973__X _02039_ vssd1 vssd1 vccd1 vccd1 sky130_fd_sc_hd__diode_2
X_09211_ cell3.SB0.route_sel\[12\] cell3.SB0.route_sel\[13\] vssd1 vssd1 vccd1 vccd1
+ _04238_ sky130_fd_sc_hd__nand2_1
XFILLER_14_29 vccd1 vssd1 vccd1 vssd1 sky130_ef_sc_hd__decap_40_12
X_06423_ cell0.CB_1.config_dataB\[17\] vssd1 vssd1 vccd1 vccd1 _01493_ sky130_fd_sc_hd__inv_2
X_09142_ cell1.LE_0B.dff0_out cell1.LE_0B.dff1_out cell1.LE_0B.reset_val vssd1 vssd1
+ vccd1 vccd1 cell1.LE_0B.dff_out sky130_fd_sc_hd__mux2_1
X_09073_ net479 _03858_ _04102_ net478 vssd1 vssd1 vccd1 vccd1 _04103_ sky130_fd_sc_hd__o211a_1
XANTENNA__08125__B _02277_ vssd1 vssd1 vccd1 vccd1 sky130_fd_sc_hd__diode_2
X_08024_ _03059_ _03062_ _03064_ _03065_ vssd1 vssd1 vccd1 vccd1 _03066_ sky130_fd_sc_hd__o22a_1
XFILLER_103_302 vssd1 vssd1 vccd1 vccd1 sky130_fd_sc_hd__fill_1
XFILLER_39_15 vccd1 vssd1 vccd1 vssd1 sky130_ef_sc_hd__decap_40_12
XFILLER_1_429 vccd1 vssd1 vccd1 vssd1 sky130_ef_sc_hd__decap_40_12
XANTENNA__10390__B _05084_ vssd1 vssd1 vccd1 vccd1 sky130_fd_sc_hd__diode_2
X_09975_ _04978_ _04977_ cell2.CB_1.config_dataB\[7\] vssd1 vssd1 vccd1 vccd1 _04979_
+ sky130_fd_sc_hd__mux2_1
XANTENNA_fanout583_A net584 vssd1 vssd1 vccd1 vccd1 sky130_fd_sc_hd__diode_2
XFILLER_76_208 vssd1 vssd1 vccd1 vccd1 sky130_fd_sc_hd__fill_2
XANTENNA__07961__A3 bus2_0\[15\] vssd1 vssd1 vccd1 vccd1 sky130_fd_sc_hd__diode_2
X_08926_ bus3_1\[8\] bus3_1\[9\] bus3_1\[10\] bus3_1\[11\] net468 net466 vssd1 vssd1
+ vccd1 vccd1 _03958_ sky130_fd_sc_hd__mux4_1
XANTENNA_fanout750_A net133 vssd1 vssd1 vccd1 vccd1 sky130_fd_sc_hd__diode_2
XFILLER_85_753 vssd1 vssd1 vccd1 vccd1 sky130_fd_sc_hd__fill_1
X_08857_ cell1.SB0.route_sel\[45\] cell1.SB0.route_sel\[44\] vssd1 vssd1 vccd1 vccd1
+ _03889_ sky130_fd_sc_hd__nand2b_1
XANTENNA_fanout848_A net854 vssd1 vssd1 vccd1 vccd1 sky130_fd_sc_hd__diode_2
X_07808_ _01838_ _02143_ vssd1 vssd1 vccd1 vccd1 _02853_ sky130_fd_sc_hd__nor2_1
XANTENNA__07044__X bus2_0\[8\] vssd1 vssd1 vccd1 vccd1 sky130_fd_sc_hd__diode_2
X_08788_ _02579_ _03819_ vssd1 vssd1 vccd1 vccd1 _03820_ sky130_fd_sc_hd__and2_2
X_07739_ _01842_ _02050_ vssd1 vssd1 vccd1 vccd1 _02785_ sky130_fd_sc_hd__nor2_1
X_10750_ _05489_ _05692_ _05693_ _05484_ vssd1 vssd1 vccd1 vccd1 _05706_ sky130_fd_sc_hd__a2bb2o_1
XANTENNA__09320__C1 net551 vssd1 vssd1 vccd1 vccd1 sky130_fd_sc_hd__diode_2
XANTENNA__06883__X _01951_ vssd1 vssd1 vccd1 vccd1 sky130_fd_sc_hd__diode_2
XFILLER_13_503 vssd1 vssd1 vccd1 vccd1 sky130_fd_sc_hd__fill_1
X_10681_ cell3.LE_1A.config_data\[6\] cell3.LE_1A.config_data\[7\] _05600_ vssd1 vssd1
+ vccd1 vccd1 _05639_ sky130_fd_sc_hd__mux2_1
XTAP_TAPCELL_ROW_101_1821 vssd1 vccd1 sky130_fd_sc_hd__tapvpwrvgnd_1
X_09409_ _02836_ _02842_ _02889_ vssd1 vssd1 vccd1 vccd1 _04432_ sky130_fd_sc_hd__or3_2
X_12420_ cell2.LE_1A.config_data\[3\] net984 net849 vssd1 vssd1 vccd1 vccd1 _00852_
+ sky130_fd_sc_hd__mux2_1
XFILLER_13_569 vccd1 vssd1 vccd1 vssd1 sky130_ef_sc_hd__decap_40_12
XANTENNA__10565__B _05521_ vssd1 vssd1 vccd1 vccd1 sky130_fd_sc_hd__diode_2
XTAP_TAPCELL_ROW_134_2320 vssd1 vccd1 sky130_fd_sc_hd__tapvpwrvgnd_1
X_12351_ cell1.SB0.route_sel\[89\] cell1.SB0.route_sel\[88\] net871 vssd1 vssd1 vccd1
+ vccd1 _00784_ sky130_fd_sc_hd__mux2_1
X_11302_ _06215_ net294 _04407_ vssd1 vssd1 vccd1 vccd1 net146 sky130_fd_sc_hd__mux2_1
XFILLER_4_212 vssd1 vssd1 vccd1 vccd1 sky130_fd_sc_hd__fill_2
XFILLER_4_201 vssd1 vssd1 vccd1 vccd1 sky130_fd_sc_hd__fill_2
X_12282_ cell1.SB0.route_sel\[20\] cell1.SB0.route_sel\[19\] net864 vssd1 vssd1 vccd1
+ vccd1 _00715_ sky130_fd_sc_hd__mux2_1
X_11233_ _06184_ _06183_ _06107_ vssd1 vssd1 vccd1 vccd1 _06185_ sky130_fd_sc_hd__mux2_1
XANTENNA__09926__A1 bus3_2\[7\] vssd1 vssd1 vccd1 vccd1 sky130_fd_sc_hd__diode_2
X_14021_ clknet_leaf_82_clk _00993_ net670 vssd1 vssd1 vccd1 vccd1 cell3.SB0.route_sel\[29\]
+ sky130_fd_sc_hd__dfstp_1
XFILLER_20_61 vssd1 vssd1 vccd1 vccd1 sky130_fd_sc_hd__fill_2
XFILLER_4_289 vccd1 vssd1 vccd1 vssd1 sky130_ef_sc_hd__decap_40_12
XFILLER_20_83 vssd1 vssd1 vccd1 vccd1 sky130_fd_sc_hd__fill_1
XFILLER_20_94 vssd1 vssd1 vccd1 vccd1 sky130_fd_sc_hd__fill_2
XFILLER_136_83 vssd1 vssd1 vccd1 vccd1 sky130_fd_sc_hd__fill_1
X_11164_ net384 _06114_ _06115_ vssd1 vssd1 vccd1 vccd1 _06116_ sky130_fd_sc_hd__a21o_1
XFILLER_96_21 vssd1 vssd1 vccd1 vccd1 sky130_fd_sc_hd__fill_4
XFILLER_0_440 vssd1 vssd1 vccd1 vccd1 sky130_fd_sc_hd__fill_2
X_10115_ _05094_ _05111_ _05115_ _05108_ vssd1 vssd1 vccd1 vccd1 _05116_ sky130_fd_sc_hd__a211o_1
XTAP_TAPCELL_ROW_112_1994 vssd1 vccd1 sky130_fd_sc_hd__tapvpwrvgnd_1
XTAP_TAPCELL_ROW_112_1983 vssd1 vccd1 sky130_fd_sc_hd__tapvpwrvgnd_1
X_11095_ net389 net388 vssd1 vssd1 vccd1 vccd1 _06047_ sky130_fd_sc_hd__or2_1
XFILLER_0_451 vssd1 vssd1 vccd1 vccd1 sky130_fd_sc_hd__fill_1
XFILLER_0_473 vssd1 vssd1 vccd1 vccd1 sky130_fd_sc_hd__fill_1
X_10046_ net399 _05048_ _05049_ vssd1 vssd1 vccd1 vccd1 _05050_ sky130_fd_sc_hd__a21o_1
Xhold70 cell2.LE_0A.config_data\[15\] vssd1 vssd1 vccd1 vccd1 net1029 sky130_fd_sc_hd__dlygate4sd3_1
Xhold81 _00906_ vssd1 vssd1 vccd1 vccd1 net1040 sky130_fd_sc_hd__dlygate4sd3_1
XANTENNA__08901__A2 net337 vssd1 vssd1 vccd1 vccd1 sky130_fd_sc_hd__diode_2
XFILLER_75_252 vssd1 vssd1 vccd1 vccd1 sky130_fd_sc_hd__fill_1
Xhold92 cell1.LE_1A.config_data\[11\] vssd1 vssd1 vccd1 vccd1 net1051 sky130_fd_sc_hd__dlygate4sd3_1
XANTENNA__07704__A3 net122 vssd1 vssd1 vccd1 vccd1 sky130_fd_sc_hd__diode_2
XFILLER_36_628 vssd1 vssd1 vccd1 vccd1 sky130_fd_sc_hd__fill_1
XFILLER_75_274 vssd1 vssd1 vccd1 vccd1 sky130_fd_sc_hd__fill_1
XFILLER_63_469 vssd1 vssd1 vccd1 vccd1 sky130_fd_sc_hd__fill_1
X_13805_ clknet_leaf_111_clk _00777_ net656 vssd1 vssd1 vccd1 vccd1 cell1.SB0.route_sel\[82\]
+ sky130_fd_sc_hd__dfstp_1
X_11997_ cell0.SB0.route_sel\[103\] cell0.SB0.route_sel\[102\] net767 vssd1 vssd1
+ vccd1 vccd1 _00434_ sky130_fd_sc_hd__mux2_1
X_10948_ _05901_ vssd1 vssd1 vccd1 vccd1 _05902_ sky130_fd_sc_hd__inv_2
X_13736_ clknet_leaf_106_clk _00708_ net658 vssd1 vssd1 vccd1 vccd1 cell1.SB0.route_sel\[13\]
+ sky130_fd_sc_hd__dfstp_1
XTAP_TAPCELL_ROW_34_818 vssd1 vccd1 sky130_fd_sc_hd__tapvpwrvgnd_1
XTAP_TAPCELL_ROW_14_520 vssd1 vccd1 sky130_fd_sc_hd__tapvpwrvgnd_1
X_10879_ _05795_ _05834_ _05793_ vssd1 vssd1 vccd1 vccd1 _05835_ sky130_fd_sc_hd__mux2_1
X_13667_ clknet_leaf_45_clk _00639_ net630 vssd1 vssd1 vccd1 vccd1 cell2.CB_1.config_dataA\[19\]
+ sky130_fd_sc_hd__dfstp_1
XANTENNA__07401__Y _02456_ vssd1 vssd1 vccd1 vccd1 sky130_fd_sc_hd__diode_2
XANTENNA__10224__A1 net44 vssd1 vssd1 vccd1 vccd1 sky130_fd_sc_hd__diode_2
X_12618_ cell3.SB0.route_sel\[83\] cell3.SB0.route_sel\[82\] net880 vssd1 vssd1 vccd1
+ vccd1 _01047_ sky130_fd_sc_hd__mux2_1
X_13598_ clknet_leaf_89_clk _00570_ net696 vssd1 vssd1 vccd1 vccd1 cell1.LEI0.config_data\[19\]
+ sky130_fd_sc_hd__dfrtp_1
X_12549_ cell3.SB0.route_sel\[14\] cell3.SB0.route_sel\[13\] net919 vssd1 vssd1 vccd1
+ vccd1 _00978_ sky130_fd_sc_hd__mux2_1
XANTENNA_max_cap267_X net267 vssd1 vssd1 vccd1 vccd1 sky130_fd_sc_hd__diode_2
XANTENNA__10775__A2 net24 vssd1 vssd1 vccd1 vccd1 sky130_fd_sc_hd__diode_2
XANTENNA_1 CBeast_in[11] vssd1 vssd1 vccd1 vccd1 sky130_fd_sc_hd__diode_2
XFILLER_8_584 vssd1 vssd1 vccd1 vccd1 sky130_fd_sc_hd__fill_1
XFILLER_6_41 vccd1 vssd1 vccd1 vssd1 sky130_ef_sc_hd__decap_40_12
XFILLER_132_419 vssd1 vssd1 vccd1 vccd1 sky130_fd_sc_hd__fill_1
XTAP_TAPCELL_ROW_74_1422 vssd1 vccd1 sky130_fd_sc_hd__tapvpwrvgnd_1
XTAP_TAPCELL_ROW_74_1411 vssd1 vccd1 sky130_fd_sc_hd__tapvpwrvgnd_1
X_14219_ clknet_leaf_12_clk _01191_ net588 vssd1 vssd1 vccd1 vccd1 cell2.SB0.route_sel\[4\]
+ sky130_fd_sc_hd__dfstp_1
XFILLER_6_85 vccd1 vssd1 vccd1 vssd1 sky130_ef_sc_hd__decap_40_12
XANTENNA__07928__A0 bus2_0\[8\] vssd1 vssd1 vccd1 vccd1 sky130_fd_sc_hd__diode_2
Xfanout519 cell0.CB_0.config_dataA\[5\] vssd1 vssd1 vccd1 vccd1 net519 sky130_fd_sc_hd__dlymetal6s2s_1
XANTENNA__08196__A3 _02560_ vssd1 vssd1 vccd1 vccd1 sky130_fd_sc_hd__diode_2
Xfanout508 cell0.CB_1.config_dataB\[1\] vssd1 vssd1 vccd1 vccd1 net508 sky130_fd_sc_hd__clkbuf_2
X_09760_ net445 _04724_ _04765_ vssd1 vssd1 vccd1 vccd1 _04766_ sky130_fd_sc_hd__a21o_1
XANTENNA__12910__S net936 vssd1 vssd1 vccd1 vccd1 sky130_fd_sc_hd__diode_2
X_06972_ cell0.SB0.route_sel\[71\] cell0.SB0.route_sel\[70\] vssd1 vssd1 vccd1 vccd1
+ _02038_ sky130_fd_sc_hd__nand2b_1
X_09691_ _04701_ _04703_ _04704_ vssd1 vssd1 vccd1 vccd1 _04705_ sky130_fd_sc_hd__a21oi_1
X_08711_ cell1.CB_1.config_dataB\[13\] cell1.CB_1.config_dataB\[12\] _03744_ vssd1
+ vssd1 vccd1 vccd1 _03745_ sky130_fd_sc_hd__o21ai_1
XFILLER_132_19 vssd1 vssd1 vccd1 vccd1 sky130_fd_sc_hd__fill_8
X_08642_ net29 net30 net459 vssd1 vssd1 vccd1 vccd1 _03676_ sky130_fd_sc_hd__mux2_1
XFILLER_82_723 vssd1 vssd1 vccd1 vccd1 sky130_fd_sc_hd__fill_2
X_08573_ net491 _03465_ _03608_ net490 vssd1 vssd1 vccd1 vccd1 _03609_ sky130_fd_sc_hd__o211a_1
XTAP_TAPCELL_ROW_85_1584 vssd1 vccd1 sky130_fd_sc_hd__tapvpwrvgnd_1
X_07524_ net325 _02574_ _02573_ vssd1 vssd1 vccd1 vccd1 _02576_ sky130_fd_sc_hd__o21ai_1
XANTENNA__13059__SET_B net584 vssd1 vssd1 vccd1 vccd1 sky130_fd_sc_hd__diode_2
XFILLER_25_39 vccd1 vssd1 vccd1 vssd1 sky130_ef_sc_hd__decap_40_12
X_07455_ net330 _02508_ vssd1 vssd1 vccd1 vccd1 _02509_ sky130_fd_sc_hd__nor2_1
X_06406_ cell0.SB0.route_sel\[97\] vssd1 vssd1 vccd1 vccd1 _01476_ sky130_fd_sc_hd__inv_2
XANTENNA__07040__A _02080_ vssd1 vssd1 vccd1 vccd1 sky130_fd_sc_hd__diode_2
X_07386_ net330 _02441_ _02438_ vssd1 vssd1 vccd1 vccd1 _02442_ sky130_fd_sc_hd__mux2_1
XFILLER_41_27 vccd1 vssd1 vccd1 vssd1 sky130_ef_sc_hd__decap_40_12
XFILLER_108_405 vssd1 vssd1 vccd1 vccd1 sky130_fd_sc_hd__fill_1
X_09125_ _03853_ _04128_ _04129_ _03849_ cell1.CB_0.config_dataB\[17\] vssd1 vssd1
+ vccd1 vccd1 _04155_ sky130_fd_sc_hd__a221o_1
XFILLER_136_769 vccd1 vssd1 vccd1 vssd1 sky130_ef_sc_hd__decap_40_12
XTAP_TAPCELL_ROW_116_2050 vssd1 vccd1 sky130_fd_sc_hd__tapvpwrvgnd_1
X_09056_ _04079_ _04084_ _04085_ vssd1 vssd1 vccd1 vccd1 _04086_ sky130_fd_sc_hd__and3_2
XANTENNA_fanout798_A net806 vssd1 vssd1 vccd1 vccd1 sky130_fd_sc_hd__diode_2
X_08007_ bus2_0\[4\] _03029_ _03030_ bus2_0\[5\] cell0.CB_0.config_dataB\[8\] vssd1
+ vssd1 vccd1 vccd1 _03049_ sky130_fd_sc_hd__a221o_1
Xhold551 cell3.LE_1A.config_data\[0\] vssd1 vssd1 vccd1 vccd1 net1510 sky130_fd_sc_hd__dlygate4sd3_1
Xhold540 cell3.LEI0.config_data\[3\] vssd1 vssd1 vccd1 vccd1 net1499 sky130_fd_sc_hd__dlygate4sd3_1
XANTENNA__07919__A0 bus2_0\[0\] vssd1 vssd1 vccd1 vccd1 sky130_fd_sc_hd__diode_2
Xhold562 cell1.LEI0.config_data\[22\] vssd1 vssd1 vccd1 vccd1 net1521 sky130_fd_sc_hd__dlygate4sd3_1
XFILLER_2_749 vssd1 vssd1 vccd1 vccd1 sky130_fd_sc_hd__fill_4
Xmax_cap270 _02159_ vssd1 vssd1 vccd1 vccd1 net270 sky130_fd_sc_hd__clkbuf_2
Xmax_cap292 _05722_ vssd1 vssd1 vccd1 vccd1 net292 sky130_fd_sc_hd__clkbuf_2
Xhold595 cell2.LEI0.config_data\[36\] vssd1 vssd1 vccd1 vccd1 net1554 sky130_fd_sc_hd__dlygate4sd3_1
XANTENNA__07395__A1 net302 vssd1 vssd1 vccd1 vccd1 sky130_fd_sc_hd__diode_2
Xhold573 cell1.LE_0B.config_data\[14\] vssd1 vssd1 vccd1 vccd1 net1532 sky130_fd_sc_hd__dlygate4sd3_1
Xhold584 cell1.LE_1B.dff1_out vssd1 vssd1 vccd1 vccd1 net1543 sky130_fd_sc_hd__dlygate4sd3_1
XFILLER_1_237 vccd1 vssd1 vccd1 vssd1 sky130_ef_sc_hd__decap_40_12
X_09958_ cell2.CB_1.config_dataB\[8\] cell2.CB_1.config_dataB\[7\] vssd1 vssd1 vccd1
+ vccd1 _04962_ sky130_fd_sc_hd__nor2_1
XFILLER_77_517 vssd1 vssd1 vccd1 vccd1 sky130_fd_sc_hd__fill_1
X_08909_ net466 net467 vssd1 vssd1 vccd1 vccd1 _03941_ sky130_fd_sc_hd__nor2_1
X_09889_ bus3_2\[5\] _04875_ _04876_ bus3_2\[4\] cell2.CB_1.config_dataA\[18\] vssd1
+ vssd1 vccd1 vccd1 _04895_ sky130_fd_sc_hd__a221o_1
XANTENNA_fanout753_X net753 vssd1 vssd1 vccd1 vccd1 sky130_fd_sc_hd__diode_2
XANTENNA_input129_A config_data_in vssd1 vssd1 vccd1 vccd1 sky130_fd_sc_hd__diode_2
XANTENNA__14433__SET_B net754 vssd1 vssd1 vccd1 vccd1 sky130_fd_sc_hd__diode_2
XFILLER_122_41 vccd1 vssd1 vccd1 vssd1 sky130_ef_sc_hd__decap_40_12
X_11920_ cell0.SB0.route_sel\[26\] cell0.SB0.route_sel\[25\] net760 vssd1 vssd1 vccd1
+ vccd1 _00357_ sky130_fd_sc_hd__mux2_1
X_11851_ cell1.CB_0.config_dataB\[7\] net481 net895 vssd1 vssd1 vccd1 vccd1 _00288_
+ sky130_fd_sc_hd__mux2_1
XFILLER_45_447 vssd1 vssd1 vccd1 vccd1 sky130_fd_sc_hd__fill_1
X_10802_ _01781_ _05727_ _05742_ _05752_ _05757_ vssd1 vssd1 vccd1 vccd1 _05758_ sky130_fd_sc_hd__o311a_2
X_11782_ cell0.LEI0.config_data\[32\] net1361 net800 vssd1 vssd1 vccd1 vccd1 _00219_
+ sky130_fd_sc_hd__mux2_1
XANTENNA__08647__A1 _03514_ vssd1 vssd1 vccd1 vccd1 sky130_fd_sc_hd__diode_2
X_10733_ _01778_ _04740_ _05521_ vssd1 vssd1 vccd1 vccd1 _05689_ sky130_fd_sc_hd__or3_1
X_13521_ clknet_leaf_100_clk net1116 net680 vssd1 vssd1 vccd1 vccd1 cell1.LE_1A.config_data\[8\]
+ sky130_fd_sc_hd__dfrtp_1
XTAP_TAPCELL_ROW_0_292 vssd1 vccd1 sky130_fd_sc_hd__tapvpwrvgnd_1
XANTENNA__08647__B2 _03517_ vssd1 vssd1 vccd1 vccd1 sky130_fd_sc_hd__diode_2
XFILLER_25_171 vssd1 vssd1 vccd1 vccd1 sky130_fd_sc_hd__fill_2
X_10664_ net392 _05620_ _05621_ vssd1 vssd1 vccd1 vccd1 _05622_ sky130_fd_sc_hd__a21o_1
XANTENNA_clkbuf_4_14_0_clk_A clknet_0_clk vssd1 vssd1 vccd1 vccd1 sky130_fd_sc_hd__diode_2
XFILLER_40_174 vssd1 vssd1 vccd1 vccd1 sky130_fd_sc_hd__fill_1
X_13452_ clknet_leaf_123_clk _00424_ net580 vssd1 vssd1 vccd1 vccd1 cell0.SB0.route_sel\[93\]
+ sky130_fd_sc_hd__dfstp_1
XANTENNA_input94_A SBsouth_in[7] vssd1 vssd1 vccd1 vccd1 sky130_fd_sc_hd__diode_2
X_12403_ cell2.CB_1.config_dataB\[13\] cell2.CB_1.config_dataB\[12\] net833 vssd1
+ vssd1 vccd1 vccd1 _00836_ sky130_fd_sc_hd__mux2_1
X_10595_ _04563_ _04569_ _04575_ _05552_ vssd1 vssd1 vccd1 vccd1 _05553_ sky130_fd_sc_hd__o211a_4
X_13383_ clknet_leaf_132_clk _00355_ net558 vssd1 vssd1 vccd1 vccd1 cell0.SB0.route_sel\[24\]
+ sky130_fd_sc_hd__dfstp_1
X_12334_ cell1.SB0.route_sel\[72\] cell1.SB0.route_sel\[71\] net868 vssd1 vssd1 vccd1
+ vccd1 _00767_ sky130_fd_sc_hd__mux2_1
XPHY_EDGE_ROW_128_Right_128 vssd1 vssd1 vccd1 vccd1 sky130_fd_sc_hd__decap_3
X_14004_ clknet_leaf_76_clk _00976_ net725 vssd1 vssd1 vccd1 vccd1 cell3.SB0.route_sel\[12\]
+ sky130_fd_sc_hd__dfstp_1
XTAP_TAPCELL_ROW_56_1141 vssd1 vccd1 sky130_fd_sc_hd__tapvpwrvgnd_1
X_12265_ cell1.SB0.route_sel\[3\] cell1.SB0.route_sel\[2\] net885 vssd1 vssd1 vccd1
+ vccd1 _00698_ sky130_fd_sc_hd__mux2_1
X_11216_ _05879_ _06146_ _06148_ _05883_ _01801_ vssd1 vssd1 vccd1 vccd1 _06168_ sky130_fd_sc_hd__o221a_1
X_12196_ cell2.CB_1.config_dataA\[9\] cell2.CB_1.config_dataA\[8\] net913 vssd1 vssd1
+ vccd1 vccd1 _00629_ sky130_fd_sc_hd__mux2_1
XTAP_TAPCELL_ROW_56_1152 vssd1 vccd1 sky130_fd_sc_hd__tapvpwrvgnd_1
X_11147_ _06098_ vssd1 vssd1 vccd1 vccd1 _06099_ sky130_fd_sc_hd__inv_2
XANTENNA__12730__S net933 vssd1 vssd1 vccd1 vccd1 sky130_fd_sc_hd__diode_2
XANTENNA__07109__B _02171_ vssd1 vssd1 vccd1 vccd1 sky130_fd_sc_hd__diode_2
XANTENNA__09164__X _04192_ vssd1 vssd1 vccd1 vccd1 sky130_fd_sc_hd__diode_2
XFILLER_0_281 vssd1 vssd1 vccd1 vccd1 sky130_fd_sc_hd__fill_4
X_11078_ _06030_ _06031_ _05961_ vssd1 vssd1 vccd1 vccd1 _06032_ sky130_fd_sc_hd__mux2_1
XFILLER_76_561 vccd1 vssd1 vccd1 vssd1 sky130_ef_sc_hd__decap_40_12
XFILLER_0_292 vssd1 vssd1 vccd1 vccd1 sky130_fd_sc_hd__fill_4
X_10029_ cell2.CB_1.config_dataB\[16\] net401 vssd1 vssd1 vccd1 vccd1 _05033_ sky130_fd_sc_hd__nor2_1
XFILLER_48_296 vssd1 vssd1 vccd1 vccd1 sky130_fd_sc_hd__fill_1
XANTENNA__08350__A3 bus1_0\[11\] vssd1 vssd1 vccd1 vccd1 sky130_fd_sc_hd__diode_2
XANTENNA__09835__A0 bus3_2\[12\] vssd1 vssd1 vccd1 vccd1 sky130_fd_sc_hd__diode_2
XANTENNA__08638__A1 _03537_ vssd1 vssd1 vccd1 vccd1 sky130_fd_sc_hd__diode_2
XANTENNA__08102__A3 bus2_0\[11\] vssd1 vssd1 vccd1 vccd1 sky130_fd_sc_hd__diode_2
XANTENNA__06964__A cell0.CB_0.config_dataB\[24\] vssd1 vssd1 vccd1 vccd1 sky130_fd_sc_hd__diode_2
XANTENNA__08638__B2 _03540_ vssd1 vssd1 vccd1 vccd1 sky130_fd_sc_hd__diode_2
XANTENNA__11081__S _05930_ vssd1 vssd1 vccd1 vccd1 sky130_fd_sc_hd__diode_2
X_13719_ clknet_leaf_34_clk _00691_ net636 vssd1 vssd1 vccd1 vccd1 cell2.CB_0.config_dataA\[21\]
+ sky130_fd_sc_hd__dfstp_1
X_07240_ cell0.SB0.route_sel\[91\] cell0.SB0.route_sel\[90\] vssd1 vssd1 vccd1 vccd1
+ _02299_ sky130_fd_sc_hd__or2_1
XFILLER_32_686 vssd1 vssd1 vccd1 vccd1 sky130_fd_sc_hd__fill_1
XANTENNA__09063__A1 bus3_1\[13\] vssd1 vssd1 vccd1 vccd1 sky130_fd_sc_hd__diode_2
X_07171_ _02230_ _02232_ vssd1 vssd1 vccd1 vccd1 bus1_0\[10\] sky130_fd_sc_hd__nor2_2
XANTENNA__07613__A2 net353 vssd1 vssd1 vccd1 vccd1 sky130_fd_sc_hd__diode_2
Xfanout305 _01823_ vssd1 vssd1 vccd1 vccd1 net305 sky130_fd_sc_hd__buf_2
XANTENNA__09218__C _02904_ vssd1 vssd1 vccd1 vccd1 sky130_fd_sc_hd__diode_2
XFILLER_141_783 vssd1 vssd1 vccd1 vccd1 sky130_fd_sc_hd__fill_1
Xfanout316 _01832_ vssd1 vssd1 vccd1 vccd1 net316 sky130_fd_sc_hd__buf_2
X_09812_ cell2.CB_1.config_dataA\[3\] cell2.CB_1.config_dataA\[2\] _04817_ vssd1 vssd1
+ vccd1 vccd1 _04818_ sky130_fd_sc_hd__o21ai_1
XFILLER_98_141 vssd1 vssd1 vccd1 vccd1 sky130_fd_sc_hd__fill_1
Xfanout327 cell1.CB_0.le_outB vssd1 vssd1 vccd1 vccd1 net327 sky130_fd_sc_hd__buf_2
Xfanout338 net340 vssd1 vssd1 vccd1 vccd1 net338 sky130_fd_sc_hd__buf_2
XFILLER_140_282 vssd1 vssd1 vccd1 vccd1 sky130_fd_sc_hd__fill_1
Xfanout349 net350 vssd1 vssd1 vccd1 vccd1 net349 sky130_fd_sc_hd__buf_2
XANTENNA_fanout379_A cell3.CB_0.config_dataA\[0\] vssd1 vssd1 vccd1 vccd1 sky130_fd_sc_hd__diode_2
X_09743_ cell2.SB0.route_sel\[33\] cell2.SB0.route_sel\[32\] vssd1 vssd1 vccd1 vccd1
+ _04751_ sky130_fd_sc_hd__nand2b_1
X_06955_ cell0.SB0.route_sel\[67\] cell0.SB0.route_sel\[66\] vssd1 vssd1 vccd1 vccd1
+ _02021_ sky130_fd_sc_hd__nand2_1
X_09674_ cell3.SB0.route_sel\[105\] cell3.SB0.route_sel\[104\] vssd1 vssd1 vccd1 vccd1
+ _04689_ sky130_fd_sc_hd__nand2b_1
XTAP_TAPCELL_ROW_87_1613 vssd1 vccd1 sky130_fd_sc_hd__tapvpwrvgnd_1
XANTENNA__08877__A1 bus3_1\[9\] vssd1 vssd1 vccd1 vccd1 sky130_fd_sc_hd__diode_2
X_06886_ cell0.SB0.route_sel\[61\] cell0.SB0.route_sel\[60\] vssd1 vssd1 vccd1 vccd1
+ _01954_ sky130_fd_sc_hd__nor2_1
X_08625_ _03618_ _03660_ vssd1 vssd1 vccd1 vccd1 _03661_ sky130_fd_sc_hd__nor2_1
X_08556_ net27 _03587_ _03588_ net28 cell1.CB_1.config_dataA\[13\] vssd1 vssd1 vccd1
+ vccd1 _03592_ sky130_fd_sc_hd__a221o_1
X_07507_ cell0.SB0.route_sel\[120\] _01487_ cell0.SB0.route_sel\[125\] cell0.SB0.route_sel\[124\]
+ _02558_ vssd1 vssd1 vccd1 vccd1 _02559_ sky130_fd_sc_hd__o221a_1
XANTENNA_fanout713_A net724 vssd1 vssd1 vccd1 vccd1 sky130_fd_sc_hd__diode_2
X_08487_ cell1.CB_1.config_dataA\[3\] cell1.CB_1.config_dataA\[2\] vssd1 vssd1 vccd1
+ vccd1 _03523_ sky130_fd_sc_hd__nor2_1
X_07438_ cell0.SB0.route_sel\[117\] cell0.SB0.route_sel\[116\] vssd1 vssd1 vccd1 vccd1
+ _02492_ sky130_fd_sc_hd__nor2_1
XFILLER_11_837 vssd1 vssd1 vccd1 vccd1 sky130_fd_sc_hd__fill_1
XFILLER_10_347 vssd1 vssd1 vccd1 vccd1 sky130_fd_sc_hd__fill_1
X_07369_ _02422_ _02424_ vssd1 vssd1 vccd1 vccd1 _02425_ sky130_fd_sc_hd__nor2_1
XFILLER_136_522 vssd1 vssd1 vccd1 vccd1 sky130_fd_sc_hd__fill_1
XANTENNA__10739__A2 net19 vssd1 vssd1 vccd1 vccd1 sky130_fd_sc_hd__diode_2
XANTENNA__09249__X bus3_1\[1\] vssd1 vssd1 vccd1 vccd1 sky130_fd_sc_hd__diode_2
X_09108_ cell1.CB_0.config_dataB\[16\] _04136_ _04137_ vssd1 vssd1 vccd1 vccd1 _04138_
+ sky130_fd_sc_hd__a21o_1
X_10380_ _01822_ _01823_ net315 net302 cell2.LEI0.config_data\[27\] cell2.LEI0.config_data\[28\]
+ vssd1 vssd1 vccd1 vccd1 _05379_ sky130_fd_sc_hd__mux4_1
XTAP_TAPCELL_ROW_98_1775 vssd1 vccd1 sky130_fd_sc_hd__tapvpwrvgnd_1
XANTENNA__08801__A1 bus3_1\[13\] vssd1 vssd1 vccd1 vccd1 sky130_fd_sc_hd__diode_2
X_09039_ _03826_ _04054_ _04055_ _03830_ _01669_ vssd1 vssd1 vccd1 vccd1 _04069_ sky130_fd_sc_hd__a221o_1
XANTENNA__12116__A net755 vssd1 vssd1 vccd1 vccd1 sky130_fd_sc_hd__diode_2
XFILLER_2_513 vccd1 vssd1 vccd1 vssd1 sky130_ef_sc_hd__decap_40_12
Xhold381 cell3.LE_0A.config_data\[3\] vssd1 vssd1 vccd1 vccd1 net1340 sky130_fd_sc_hd__dlygate4sd3_1
Xhold370 _00216_ vssd1 vssd1 vccd1 vccd1 net1329 sky130_fd_sc_hd__dlygate4sd3_1
XFILLER_2_557 vccd1 vssd1 vccd1 vssd1 sky130_ef_sc_hd__decap_40_12
X_12050_ net1200 cell1.LE_1A.config_data\[0\] net890 vssd1 vssd1 vccd1 vccd1 _00486_
+ sky130_fd_sc_hd__mux2_1
Xhold392 cell3.LE_1B.config_data\[13\] vssd1 vssd1 vccd1 vccd1 net1351 sky130_fd_sc_hd__dlygate4sd3_1
X_11001_ _05912_ _05916_ cell3.CB_0.config_dataA\[5\] vssd1 vssd1 vccd1 vccd1 _05955_
+ sky130_fd_sc_hd__mux2_1
Xfanout850 net854 vssd1 vssd1 vccd1 vccd1 net850 sky130_fd_sc_hd__clkbuf_4
XTAP_TAPCELL_ROW_129_2241 vssd1 vccd1 sky130_fd_sc_hd__tapvpwrvgnd_1
Xfanout861 net862 vssd1 vssd1 vccd1 vccd1 net861 sky130_fd_sc_hd__clkbuf_4
Xfanout883 net884 vssd1 vssd1 vccd1 vccd1 net883 sky130_fd_sc_hd__clkbuf_4
Xfanout894 net898 vssd1 vssd1 vccd1 vccd1 net894 sky130_fd_sc_hd__buf_2
XTAP_TAPCELL_ROW_51_1071 vssd1 vccd1 sky130_fd_sc_hd__tapvpwrvgnd_1
Xfanout872 net875 vssd1 vssd1 vccd1 vccd1 net872 sky130_fd_sc_hd__clkbuf_4
X_12952_ cell3.LE_0B.edge_mode cell3.LE_0B.config_data\[16\] net950 vssd1 vssd1 vccd1
+ vccd1 _01380_ sky130_fd_sc_hd__mux2_1
XFILLER_133_51 vssd1 vssd1 vccd1 vccd1 sky130_fd_sc_hd__fill_4
XFILLER_45_211 vssd1 vssd1 vccd1 vccd1 sky130_fd_sc_hd__fill_1
XTAP_TAPCELL_ROW_5_384 vssd1 vccd1 sky130_fd_sc_hd__tapvpwrvgnd_1
XTAP_TAPCELL_ROW_142_2452 vssd1 vccd1 sky130_fd_sc_hd__tapvpwrvgnd_1
XTAP_TAPCELL_ROW_142_2441 vssd1 vccd1 sky130_fd_sc_hd__tapvpwrvgnd_1
XFILLER_93_55 vssd1 vssd1 vccd1 vccd1 sky130_fd_sc_hd__fill_1
XFILLER_85_391 vssd1 vssd1 vccd1 vccd1 sky130_fd_sc_hd__fill_1
X_11903_ cell0.SB0.route_sel\[9\] cell0.SB0.route_sel\[8\] net782 vssd1 vssd1 vccd1
+ vccd1 _00340_ sky130_fd_sc_hd__mux2_1
XFILLER_18_447 vssd1 vssd1 vccd1 vccd1 sky130_fd_sc_hd__fill_1
XFILLER_18_458 vssd1 vssd1 vccd1 vccd1 sky130_fd_sc_hd__fill_2
XANTENNA__08332__A3 bus1_0\[11\] vssd1 vssd1 vccd1 vccd1 sky130_fd_sc_hd__diode_2
XFILLER_93_88 vssd1 vssd1 vccd1 vccd1 sky130_fd_sc_hd__fill_2
X_12883_ cell2.SB0.route_sel\[125\] cell2.SB0.route_sel\[124\] net831 vssd1 vssd1
+ vccd1 vccd1 _01312_ sky130_fd_sc_hd__mux2_1
XFILLER_73_586 vssd1 vssd1 vccd1 vccd1 sky130_fd_sc_hd__fill_2
XANTENNA__12416__A2 net549 vssd1 vssd1 vccd1 vccd1 sky130_fd_sc_hd__diode_2
X_11834_ net488 cell1.CB_1.config_dataA\[14\] net890 vssd1 vssd1 vccd1 vccd1 _00271_
+ sky130_fd_sc_hd__mux2_1
XANTENNA__08096__A2 bus2_0\[14\] vssd1 vssd1 vccd1 vccd1 sky130_fd_sc_hd__diode_2
X_11765_ net1334 cell0.LEI0.config_data\[14\] net775 vssd1 vssd1 vccd1 vccd1 _00202_
+ sky130_fd_sc_hd__mux2_1
XTAP_TAPCELL_ROW_44_968 vssd1 vccd1 sky130_fd_sc_hd__tapvpwrvgnd_1
XFILLER_14_642 vssd1 vssd1 vccd1 vccd1 sky130_fd_sc_hd__fill_2
XANTENNA__10978__A2 _05847_ vssd1 vssd1 vccd1 vccd1 sky130_fd_sc_hd__diode_2
X_10716_ cell3.LE_1A.config_data\[0\] cell3.LE_1A.config_data\[1\] _05600_ vssd1 vssd1
+ vccd1 vccd1 _05674_ sky130_fd_sc_hd__mux2_1
X_11696_ net1068 cell0.LE_1A.config_data\[14\] net873 vssd1 vssd1 vccd1 vccd1 _00136_
+ sky130_fd_sc_hd__mux2_1
X_13504_ clknet_leaf_96_clk _00476_ net685 vssd1 vssd1 vccd1 vccd1 cell1.CB_1.config_dataB\[17\]
+ sky130_fd_sc_hd__dfstp_1
XANTENNA_input97_X net97 vssd1 vssd1 vccd1 vccd1 sky130_fd_sc_hd__diode_2
XFILLER_13_174 vssd1 vssd1 vccd1 vccd1 sky130_fd_sc_hd__fill_1
XTAP_TAPCELL_ROW_24_670 vssd1 vccd1 sky130_fd_sc_hd__tapvpwrvgnd_1
XFILLER_139_360 vssd1 vssd1 vccd1 vccd1 sky130_fd_sc_hd__fill_1
X_10647_ cell3.CB_1.config_dataA\[12\] _05604_ vssd1 vssd1 vccd1 vccd1 _05605_ sky130_fd_sc_hd__nand2_1
X_13435_ clknet_leaf_130_clk _00407_ net562 vssd1 vssd1 vccd1 vccd1 cell0.SB0.route_sel\[76\]
+ sky130_fd_sc_hd__dfstp_1
XFILLER_139_393 vssd1 vssd1 vccd1 vccd1 sky130_fd_sc_hd__fill_4
X_10578_ cell3.CB_1.config_dataA\[7\] _05535_ cell3.CB_1.config_dataA\[8\] vssd1 vssd1
+ vccd1 vccd1 _05536_ sky130_fd_sc_hd__a21bo_1
X_13366_ clknet_leaf_127_clk _00338_ net576 vssd1 vssd1 vccd1 vccd1 cell0.SB0.route_sel\[7\]
+ sky130_fd_sc_hd__dfstp_1
XFILLER_142_503 vssd1 vssd1 vccd1 vccd1 sky130_fd_sc_hd__fill_1
X_12317_ cell1.SB0.route_sel\[55\] cell1.SB0.route_sel\[54\] net858 vssd1 vssd1 vccd1
+ vccd1 _00750_ sky130_fd_sc_hd__mux2_1
XANTENNA__06803__B1 _01872_ vssd1 vssd1 vccd1 vccd1 sky130_fd_sc_hd__diode_2
X_13297_ clknet_leaf_103_clk _00269_ net677 vssd1 vssd1 vccd1 vccd1 cell1.CB_1.config_dataA\[13\]
+ sky130_fd_sc_hd__dfstp_1
X_12248_ net414 cell2.CB_0.config_dataA\[10\] net822 vssd1 vssd1 vccd1 vccd1 _00681_
+ sky130_fd_sc_hd__mux2_1
Xclkbuf_1_0__f_cell0.LE_1A.sel_clk clknet_0_cell0.LE_1A.sel_clk vssd1 vssd1 vccd1
+ vccd1 clknet_1_0__leaf_cell0.LE_1A.sel_clk sky130_fd_sc_hd__clkbuf_16
X_12179_ net1111 net1168 net853 vssd1 vssd1 vccd1 vccd1 _00612_ sky130_fd_sc_hd__mux2_1
XANTENNA__08510__Y _03546_ vssd1 vssd1 vccd1 vccd1 sky130_fd_sc_hd__diode_2
XANTENNA__11076__S _05930_ vssd1 vssd1 vccd1 vccd1 sky130_fd_sc_hd__diode_2
X_06740_ cell3.CB_0.config_dataA\[12\] vssd1 vssd1 vccd1 vccd1 _01810_ sky130_fd_sc_hd__inv_2
XFILLER_110_488 vssd1 vssd1 vccd1 vccd1 sky130_fd_sc_hd__fill_2
X_06671_ cell3.SB0.route_sel\[107\] vssd1 vssd1 vccd1 vccd1 _01741_ sky130_fd_sc_hd__inv_2
XTAP_TAPCELL_ROW_69_1343 vssd1 vccd1 sky130_fd_sc_hd__tapvpwrvgnd_1
XFILLER_64_531 vssd1 vssd1 vccd1 vccd1 sky130_fd_sc_hd__fill_1
X_08410_ _03432_ _03446_ _03447_ _01492_ vssd1 vssd1 vccd1 vccd1 _03448_ sky130_fd_sc_hd__a22o_1
X_09390_ cell3.CB_0.config_dataA\[23\] cell3.CB_0.config_dataA\[22\] vssd1 vssd1 vccd1
+ vccd1 _04414_ sky130_fd_sc_hd__nand2b_1
XTAP_TAPCELL_ROW_82_1532 vssd1 vccd1 sky130_fd_sc_hd__tapvpwrvgnd_1
XFILLER_51_225 vssd1 vssd1 vccd1 vccd1 sky130_fd_sc_hd__fill_1
XTAP_TAPCELL_ROW_82_1543 vssd1 vccd1 sky130_fd_sc_hd__tapvpwrvgnd_1
XANTENNA__08087__A2 _02894_ vssd1 vssd1 vccd1 vccd1 sky130_fd_sc_hd__diode_2
X_08341_ cell0.CB_1.config_dataB\[4\] _03364_ _03377_ _03378_ cell0.LEI0.config_data\[11\]
+ vssd1 vssd1 vccd1 vccd1 _03379_ sky130_fd_sc_hd__o32ai_4
XFILLER_138_809 vssd1 vssd1 vccd1 vccd1 sky130_fd_sc_hd__fill_2
X_08272_ cell0.LE_1A.dff0_out cell0.LE_1A.dff1_out cell0.LE_1A.reset_val vssd1 vssd1
+ vccd1 vccd1 cell0.LE_1A.dff_out sky130_fd_sc_hd__mux2_1
XANTENNA__07295__B1 _02328_ vssd1 vssd1 vccd1 vccd1 sky130_fd_sc_hd__diode_2
XFILLER_22_29 vccd1 vssd1 vccd1 vssd1 sky130_ef_sc_hd__decap_40_12
X_07223_ net450 _01962_ net449 vssd1 vssd1 vccd1 vccd1 _02283_ sky130_fd_sc_hd__nand3b_1
XFILLER_138_29 vccd1 vssd1 vccd1 vssd1 sky130_ef_sc_hd__decap_40_12
X_07154_ cell1.SB0.route_sel\[82\] cell1.SB0.route_sel\[83\] vssd1 vssd1 vccd1 vccd1
+ _02216_ sky130_fd_sc_hd__nand2_1
X_07085_ net333 _02147_ _02148_ _02145_ vssd1 vssd1 vccd1 vccd1 _02149_ sky130_fd_sc_hd__a22oi_2
XANTENNA__11146__A2 net42 vssd1 vssd1 vccd1 vccd1 sky130_fd_sc_hd__diode_2
XANTENNA_input1_A CBeast_in[0] vssd1 vssd1 vccd1 vccd1 sky130_fd_sc_hd__diode_2
X_07987_ net531 net529 vssd1 vssd1 vccd1 vccd1 _03029_ sky130_fd_sc_hd__nor2_1
X_06938_ net306 net62 _02002_ vssd1 vssd1 vccd1 vccd1 _02005_ sky130_fd_sc_hd__mux2_1
X_09726_ net552 _04738_ vssd1 vssd1 vccd1 vccd1 _04739_ sky130_fd_sc_hd__nand2_1
XTAP_TAPCELL_ROW_2_332 vssd1 vccd1 sky130_fd_sc_hd__tapvpwrvgnd_1
XFILLER_28_712 vssd1 vssd1 vccd1 vccd1 sky130_fd_sc_hd__fill_1
XANTENNA__10657__A1 _05478_ vssd1 vssd1 vccd1 vccd1 sky130_fd_sc_hd__diode_2
XTAP_TAPCELL_ROW_2_343 vssd1 vccd1 sky130_fd_sc_hd__tapvpwrvgnd_1
XANTENNA_fanout928_A net929 vssd1 vssd1 vccd1 vccd1 sky130_fd_sc_hd__diode_2
XANTENNA_fanout549_X net549 vssd1 vssd1 vccd1 vccd1 sky130_fd_sc_hd__diode_2
XTAP_TAPCELL_ROW_124_2171 vssd1 vccd1 sky130_fd_sc_hd__tapvpwrvgnd_1
X_09657_ _02469_ _04670_ _02448_ vssd1 vssd1 vccd1 vccd1 _04672_ sky130_fd_sc_hd__or3b_1
X_06869_ _01934_ _01936_ _01935_ vssd1 vssd1 vccd1 vccd1 _01937_ sky130_fd_sc_hd__o21bai_1
XFILLER_27_277 vssd1 vssd1 vccd1 vccd1 sky130_fd_sc_hd__fill_1
X_09588_ cell2.SB0.route_sel\[88\] cell2.SB0.route_sel\[89\] vssd1 vssd1 vccd1 vccd1
+ _04605_ sky130_fd_sc_hd__nand2b_1
X_08608_ net4 net5 net6 net7 net488 cell1.CB_1.config_dataA\[16\] vssd1 vssd1 vccd1
+ vccd1 _03644_ sky130_fd_sc_hd__mux4_1
XANTENNA__10409__A1 net44 vssd1 vssd1 vccd1 vccd1 sky130_fd_sc_hd__diode_2
XANTENNA__09275__A1 _04279_ vssd1 vssd1 vccd1 vccd1 sky130_fd_sc_hd__diode_2
XTAP_TAPCELL_ROW_41_916 vssd1 vccd1 sky130_fd_sc_hd__tapvpwrvgnd_1
X_08539_ _03574_ _03570_ cell1.CB_1.config_dataA\[8\] vssd1 vssd1 vccd1 vccd1 _03575_
+ sky130_fd_sc_hd__or3b_1
XFILLER_129_809 vssd1 vssd1 vccd1 vccd1 sky130_fd_sc_hd__fill_4
XTAP_TAPCELL_ROW_41_927 vssd1 vccd1 sky130_fd_sc_hd__tapvpwrvgnd_1
X_11550_ _01590_ cell0.SB0.route_sel\[18\] vssd1 vssd1 vccd1 vccd1 _06367_ sky130_fd_sc_hd__nand2_1
XFILLER_137_3 vccd1 vssd1 vccd1 vssd1 sky130_ef_sc_hd__decap_40_12
X_10501_ _02159_ _03472_ _02144_ vssd1 vssd1 vccd1 vccd1 _05466_ sky130_fd_sc_hd__a21o_1
XFILLER_137_831 vssd1 vssd1 vccd1 vccd1 sky130_fd_sc_hd__fill_1
XANTENNA__11302__X net146 vssd1 vssd1 vccd1 vccd1 sky130_fd_sc_hd__diode_2
XANTENNA__09027__A1 bus3_1\[1\] vssd1 vssd1 vccd1 vccd1 sky130_fd_sc_hd__diode_2
X_13220_ clknet_leaf_13_clk net1496 net589 vssd1 vssd1 vccd1 vccd1 cell0.LEI0.config_data\[5\]
+ sky130_fd_sc_hd__dfrtp_1
X_11481_ cell1.SB0.route_sel\[113\] cell1.SB0.route_sel\[112\] vssd1 vssd1 vccd1 vccd1
+ _06321_ sky130_fd_sc_hd__nand2b_1
X_10432_ _04273_ _05428_ vssd1 vssd1 vccd1 vccd1 bus3_2\[1\] sky130_fd_sc_hd__and2_2
XFILLER_6_137 vssd1 vssd1 vccd1 vccd1 sky130_fd_sc_hd__fill_2
X_10363_ _05356_ _05359_ _05361_ cell2.CB_0.config_dataB\[12\] _05355_ vssd1 vssd1
+ vccd1 vccd1 _05362_ sky130_fd_sc_hd__o221a_1
X_13151_ clknet_leaf_119_clk _00123_ net595 vssd1 vssd1 vccd1 vccd1 cell0.LE_1A.config_data\[2\]
+ sky130_fd_sc_hd__dfrtp_1
X_12102_ net1291 cell1.LE_0A.config_data\[6\] net876 vssd1 vssd1 vccd1 vccd1 _00536_
+ sky130_fd_sc_hd__mux2_1
X_13082_ clknet_leaf_7_clk _00054_ net568 vssd1 vssd1 vccd1 vccd1 cell0.CB_0.config_dataB\[9\]
+ sky130_fd_sc_hd__dfstp_1
XFILLER_2_321 vccd1 vssd1 vccd1 vssd1 sky130_ef_sc_hd__decap_40_12
XANTENNA_input57_A CBnorth_in[31] vssd1 vssd1 vccd1 vccd1 sky130_fd_sc_hd__diode_2
X_10294_ net33 net44 net55 net58 net431 net430 vssd1 vssd1 vccd1 vccd1 _05293_ sky130_fd_sc_hd__mux4_1
XFILLER_105_750 vssd1 vssd1 vccd1 vccd1 sky130_fd_sc_hd__fill_1
XFILLER_78_601 vssd1 vssd1 vccd1 vccd1 sky130_fd_sc_hd__fill_1
XTAP_TAPCELL_ROW_53_1100 vssd1 vccd1 sky130_fd_sc_hd__tapvpwrvgnd_1
XFILLER_2_365 vccd1 vssd1 vccd1 vssd1 sky130_ef_sc_hd__decap_40_12
X_12033_ cell1.CB_1.config_dataB\[11\] net456 net891 vssd1 vssd1 vccd1 vccd1 _00470_
+ sky130_fd_sc_hd__mux2_1
XANTENNA__08002__A2 _02894_ vssd1 vssd1 vccd1 vccd1 sky130_fd_sc_hd__diode_2
XANTENNA__09750__A2 _04608_ vssd1 vssd1 vccd1 vccd1 sky130_fd_sc_hd__diode_2
XANTENNA_clkbuf_leaf_8_clk_A clknet_4_1_0_clk vssd1 vssd1 vccd1 vccd1 sky130_fd_sc_hd__diode_2
Xfanout691 net750 vssd1 vssd1 vccd1 vccd1 net691 sky130_fd_sc_hd__clkbuf_2
Xfanout680 net682 vssd1 vssd1 vccd1 vccd1 net680 sky130_fd_sc_hd__clkbuf_4
X_13984_ clknet_leaf_34_clk _00956_ net634 vssd1 vssd1 vccd1 vccd1 cell2.LEI0.config_data\[41\]
+ sky130_fd_sc_hd__dfrtp_1
XTAP_TAPCELL_ROW_109_1944 vssd1 vccd1 sky130_fd_sc_hd__tapvpwrvgnd_1
XANTENNA_input12_X net12 vssd1 vssd1 vccd1 vccd1 sky130_fd_sc_hd__diode_2
XTAP_TAPCELL_ROW_29_740 vssd1 vccd1 sky130_fd_sc_hd__tapvpwrvgnd_1
X_12935_ net1534 cell3.LE_1B.reset_mode net957 vssd1 vssd1 vccd1 vccd1 _01363_ sky130_fd_sc_hd__mux2_1
X_12866_ cell2.SB0.route_sel\[108\] cell2.SB0.route_sel\[107\] net817 vssd1 vssd1
+ vccd1 vccd1 _01295_ sky130_fd_sc_hd__mux2_1
XFILLER_73_372 vssd1 vssd1 vccd1 vccd1 sky130_fd_sc_hd__fill_1
XANTENNA__08839__A_N _03870_ vssd1 vssd1 vccd1 vccd1 sky130_fd_sc_hd__diode_2
XANTENNA__09266__A1 net55 vssd1 vssd1 vccd1 vccd1 sky130_fd_sc_hd__diode_2
XANTENNA__10748__B _05478_ vssd1 vssd1 vccd1 vccd1 sky130_fd_sc_hd__diode_2
X_11817_ net1547 cell1.LE_1B.edge_mode net905 vssd1 vssd1 vccd1 vccd1 _00254_ sky130_fd_sc_hd__mux2_1
X_12797_ cell2.SB0.route_sel\[39\] cell2.SB0.route_sel\[38\] net819 vssd1 vssd1 vccd1
+ vccd1 _01226_ sky130_fd_sc_hd__mux2_1
XTAP_TAPCELL_ROW_64_1273 vssd1 vccd1 sky130_fd_sc_hd__tapvpwrvgnd_1
XTAP_TAPCELL_ROW_64_1262 vssd1 vccd1 sky130_fd_sc_hd__tapvpwrvgnd_1
XANTENNA__07277__B1 _02330_ vssd1 vssd1 vccd1 vccd1 sky130_fd_sc_hd__diode_2
X_11748_ net755 _03024_ vssd1 vssd1 vccd1 vccd1 _06376_ sky130_fd_sc_hd__nand2_1
X_14467_ clknet_leaf_64_clk net1283 net747 vssd1 vssd1 vccd1 vccd1 cell3.LEI0.config_data\[32\]
+ sky130_fd_sc_hd__dfrtp_1
X_11679_ net755 _03461_ vssd1 vssd1 vccd1 vccd1 _06373_ sky130_fd_sc_hd__nand2_1
X_14398_ clknet_leaf_57_clk _01370_ net722 vssd1 vssd1 vccd1 vccd1 cell3.LE_0B.config_data\[7\]
+ sky130_fd_sc_hd__dfrtp_1
XANTENNA__12022__A0 cell1.CB_1.config_dataB\[0\] vssd1 vssd1 vccd1 vccd1 sky130_fd_sc_hd__diode_2
X_13418_ clknet_leaf_133_clk _00390_ net557 vssd1 vssd1 vccd1 vccd1 cell0.SB0.route_sel\[59\]
+ sky130_fd_sc_hd__dfstp_1
XANTENNA__10179__A3 net58 vssd1 vssd1 vccd1 vccd1 sky130_fd_sc_hd__diode_2
XFILLER_115_503 vssd1 vssd1 vccd1 vccd1 sky130_fd_sc_hd__fill_1
XANTENNA__12573__A1 cell3.SB0.route_sel\[37\] vssd1 vssd1 vccd1 vccd1 sky130_fd_sc_hd__diode_2
X_13349_ clknet_leaf_85_clk _00321_ net674 vssd1 vssd1 vccd1 vccd1 cell1.CB_0.config_dataA\[15\]
+ sky130_fd_sc_hd__dfstp_1
XFILLER_142_333 vssd1 vssd1 vccd1 vccd1 sky130_fd_sc_hd__fill_1
XANTENNA__09617__X bus3_1\[11\] vssd1 vssd1 vccd1 vccd1 sky130_fd_sc_hd__diode_2
XFILLER_6_693 vssd1 vssd1 vccd1 vccd1 sky130_fd_sc_hd__fill_4
Xclkbuf_1_0__f_cell2.LE_1B.sel_clk clknet_0_cell2.LE_1B.sel_clk vssd1 vssd1 vccd1
+ vccd1 clknet_1_0__leaf_cell2.LE_1B.sel_clk sky130_fd_sc_hd__clkbuf_16
X_08890_ bus3_1\[0\] bus3_1\[1\] bus3_1\[2\] bus3_1\[3\] net474 net472 vssd1 vssd1
+ vccd1 vccd1 _03922_ sky130_fd_sc_hd__mux4_1
X_07910_ net515 _01986_ vssd1 vssd1 vccd1 vccd1 _02954_ sky130_fd_sc_hd__nand2_1
XANTENNA__07201__B1 bus1_0\[11\] vssd1 vssd1 vccd1 vccd1 sky130_fd_sc_hd__diode_2
X_07841_ _01604_ cell0.SB0.route_sel\[37\] _01605_ cell0.SB0.route_sel\[38\] _02884_
+ vssd1 vssd1 vccd1 vccd1 _02885_ sky130_fd_sc_hd__o221a_1
XFILLER_96_475 vssd1 vssd1 vccd1 vccd1 sky130_fd_sc_hd__fill_1
XFILLER_84_637 vssd1 vssd1 vccd1 vccd1 sky130_fd_sc_hd__fill_1
XFILLER_84_615 vssd1 vssd1 vccd1 vccd1 sky130_fd_sc_hd__fill_1
X_07772_ _01836_ _02816_ _02817_ vssd1 vssd1 vccd1 vccd1 _02818_ sky130_fd_sc_hd__o21a_1
XANTENNA__07752__A1 _02793_ vssd1 vssd1 vccd1 vccd1 sky130_fd_sc_hd__diode_2
X_06723_ cell3.LE_1A.config_data\[16\] vssd1 vssd1 vccd1 vccd1 _01793_ sky130_fd_sc_hd__inv_2
XANTENNA__10639__A1 net279 vssd1 vssd1 vccd1 vccd1 sky130_fd_sc_hd__diode_2
X_09511_ _01718_ _01719_ vssd1 vssd1 vccd1 vccd1 _04531_ sky130_fd_sc_hd__nor2_1
XFILLER_83_158 vssd1 vssd1 vccd1 vccd1 sky130_fd_sc_hd__fill_8
X_09442_ cell3.SB0.route_sel\[40\] _01704_ cell3.SB0.route_sel\[43\] _01706_ _04464_
+ vssd1 vssd1 vccd1 vccd1 _04465_ sky130_fd_sc_hd__a221o_1
X_06654_ cell3.SB0.route_sel\[75\] vssd1 vssd1 vccd1 vccd1 _01724_ sky130_fd_sc_hd__inv_2
XFILLER_64_394 vssd1 vssd1 vccd1 vccd1 sky130_fd_sc_hd__fill_1
XANTENNA_clkbuf_4_2_0_clk_A clknet_0_clk vssd1 vssd1 vccd1 vccd1 sky130_fd_sc_hd__diode_2
X_09373_ cell2.SB0.route_sel\[32\] cell2.SB0.route_sel\[33\] vssd1 vssd1 vccd1 vccd1
+ _04397_ sky130_fd_sc_hd__nand2b_1
XANTENNA__09257__A1 net317 vssd1 vssd1 vccd1 vccd1 sky130_fd_sc_hd__diode_2
X_06585_ cell1.CB_1.config_dataB\[8\] vssd1 vssd1 vccd1 vccd1 _01655_ sky130_fd_sc_hd__inv_2
X_08324_ _02846_ _03350_ _03351_ _02807_ vssd1 vssd1 vccd1 vccd1 _03362_ sky130_fd_sc_hd__a22o_1
XFILLER_33_39 vccd1 vssd1 vccd1 vssd1 sky130_ef_sc_hd__decap_40_12
XFILLER_137_105 vssd1 vssd1 vccd1 vccd1 sky130_fd_sc_hd__fill_1
XFILLER_119_831 vssd1 vssd1 vccd1 vccd1 sky130_fd_sc_hd__fill_2
XANTENNA__10811__A1 net16 vssd1 vssd1 vccd1 vccd1 sky130_fd_sc_hd__diode_2
XANTENNA__09009__A1 bus3_1\[9\] vssd1 vssd1 vccd1 vccd1 sky130_fd_sc_hd__diode_2
XFILLER_20_475 vssd1 vssd1 vccd1 vccd1 sky130_fd_sc_hd__fill_1
X_08255_ _03293_ _03294_ _03284_ _03291_ vssd1 vssd1 vccd1 vccd1 _03295_ sky130_fd_sc_hd__o211a_1
XPHY_EDGE_ROW_104_Left_247 vssd1 vssd1 vccd1 vccd1 sky130_fd_sc_hd__decap_3
X_08186_ cell0.CB_1.config_dataA\[7\] _03224_ _03225_ vssd1 vssd1 vccd1 vccd1 _03226_
+ sky130_fd_sc_hd__or3_1
XANTENNA__13758__Q cell1.SB0.route_sel\[35\] vssd1 vssd1 vccd1 vccd1 sky130_fd_sc_hd__diode_2
X_07206_ cell0.SB0.route_sel\[93\] cell0.SB0.route_sel\[92\] net99 _02264_ _02263_
+ vssd1 vssd1 vccd1 vccd1 _02266_ sky130_fd_sc_hd__a41o_1
XTAP_TAPCELL_ROW_95_1734 vssd1 vccd1 sky130_fd_sc_hd__tapvpwrvgnd_1
X_07137_ cell0.SB0.route_sel\[85\] cell0.SB0.route_sel\[84\] net98 _02197_ _02196_
+ vssd1 vssd1 vccd1 vccd1 _02199_ sky130_fd_sc_hd__a41o_1
XANTENNA__10575__B1 _05531_ vssd1 vssd1 vccd1 vccd1 sky130_fd_sc_hd__diode_2
XANTENNA__08232__A2 _02424_ vssd1 vssd1 vccd1 vccd1 sky130_fd_sc_hd__diode_2
Xoutput250 net250 vssd1 vssd1 vccd1 vccd1 SBwest_out[28] sky130_fd_sc_hd__buf_2
XFILLER_106_569 vssd1 vssd1 vccd1 vccd1 sky130_fd_sc_hd__fill_2
Xoutput261 net261 vssd1 vssd1 vccd1 vccd1 SBwest_out[9] sky130_fd_sc_hd__buf_2
XANTENNA_fanout780_A net807 vssd1 vssd1 vccd1 vccd1 sky130_fd_sc_hd__diode_2
XTAP_TAPCELL_ROW_7_413 vssd1 vccd1 sky130_fd_sc_hd__tapvpwrvgnd_1
X_07068_ cell0.SB0.route_sel\[72\] cell0.SB0.route_sel\[73\] _02120_ _02131_ net766
+ vssd1 vssd1 vccd1 vccd1 _02132_ sky130_fd_sc_hd__a311o_4
XANTENNA_input4_X net4 vssd1 vssd1 vccd1 vccd1 sky130_fd_sc_hd__diode_2
XFILLER_87_453 vssd1 vssd1 vccd1 vccd1 sky130_fd_sc_hd__fill_1
XFILLER_59_144 vssd1 vssd1 vccd1 vccd1 sky130_fd_sc_hd__fill_1
XTAP_TAPCELL_ROW_126_2200 vssd1 vccd1 sky130_fd_sc_hd__tapvpwrvgnd_1
XANTENNA__07743__A1 net339 vssd1 vssd1 vccd1 vccd1 sky130_fd_sc_hd__diode_2
XPHY_EDGE_ROW_113_Left_256 vssd1 vssd1 vccd1 vccd1 sky130_fd_sc_hd__decap_3
XFILLER_28_531 vssd1 vssd1 vccd1 vccd1 sky130_fd_sc_hd__fill_1
X_10981_ net376 net377 vssd1 vssd1 vccd1 vccd1 _05935_ sky130_fd_sc_hd__and2b_1
XANTENNA__09496__A1 net48 vssd1 vssd1 vccd1 vccd1 sky130_fd_sc_hd__diode_2
X_09709_ _01651_ cell2.SB0.config_data_out cell2.SB0.route_sel\[125\] cell2.SB0.route_sel\[124\]
+ _04721_ vssd1 vssd1 vccd1 vccd1 _04722_ sky130_fd_sc_hd__o221a_1
X_12720_ cell3.CB_0.config_dataB\[12\] net384 net932 vssd1 vssd1 vccd1 vccd1 _01149_
+ sky130_fd_sc_hd__mux2_1
XANTENNA__09422__B _04444_ vssd1 vssd1 vccd1 vccd1 sky130_fd_sc_hd__diode_2
XANTENNA_input111_A SBwest_in[22] vssd1 vssd1 vccd1 vccd1 sky130_fd_sc_hd__diode_2
XFILLER_15_225 vssd1 vssd1 vccd1 vccd1 sky130_fd_sc_hd__fill_8
XFILLER_130_41 vccd1 vssd1 vccd1 vssd1 sky130_ef_sc_hd__decap_40_12
X_12651_ cell3.SB0.route_sel\[116\] cell3.SB0.route_sel\[115\] net921 vssd1 vssd1
+ vccd1 vccd1 _01080_ sky130_fd_sc_hd__mux2_1
XFILLER_43_556 vssd1 vssd1 vccd1 vccd1 sky130_fd_sc_hd__fill_1
XTAP_TAPCELL_ROW_104_1874 vssd1 vccd1 sky130_fd_sc_hd__tapvpwrvgnd_1
XTAP_TAPCELL_ROW_104_1863 vssd1 vccd1 sky130_fd_sc_hd__tapvpwrvgnd_1
X_11602_ cell0.CB_1.config_dataA\[23\] cell0.CB_1.config_dataA\[22\] net859 vssd1
+ vssd1 vccd1 vccd1 _00043_ sky130_fd_sc_hd__mux2_1
X_12582_ cell3.SB0.route_sel\[47\] cell3.SB0.route_sel\[46\] net915 vssd1 vssd1 vccd1
+ vccd1 _01011_ sky130_fd_sc_hd__mux2_1
XTAP_TAPCELL_ROW_137_2362 vssd1 vccd1 sky130_fd_sc_hd__tapvpwrvgnd_1
XPHY_EDGE_ROW_122_Left_265 vssd1 vssd1 vccd1 vccd1 sky130_fd_sc_hd__decap_3
XANTENNA__10263__C1 _05263_ vssd1 vssd1 vccd1 vccd1 sky130_fd_sc_hd__diode_2
X_11533_ cell2.SB0.route_sel\[120\] cell2.SB0.route_sel\[121\] _01653_ cell2.SB0.route_sel\[124\]
+ _06355_ vssd1 vssd1 vccd1 vccd1 _06356_ sky130_fd_sc_hd__o221a_1
X_14321_ clknet_leaf_21_clk _01293_ net612 vssd1 vssd1 vccd1 vccd1 cell2.SB0.route_sel\[106\]
+ sky130_fd_sc_hd__dfstp_1
X_14252_ clknet_leaf_19_clk _01224_ net610 vssd1 vssd1 vccd1 vccd1 cell2.SB0.route_sel\[37\]
+ sky130_fd_sc_hd__dfstp_1
XFILLER_7_446 vssd1 vssd1 vccd1 vccd1 sky130_fd_sc_hd__fill_2
X_11464_ cell1.SB0.route_sel\[66\] _01526_ cell1.SB0.route_sel\[70\] cell1.SB0.route_sel\[71\]
+ _06309_ vssd1 vssd1 vccd1 vccd1 _06310_ sky130_fd_sc_hd__o221a_1
X_10415_ cell2.LE_0B.config_data\[5\] cell2.LE_0B.config_data\[4\] _05344_ vssd1 vssd1
+ vccd1 vccd1 _05414_ sky130_fd_sc_hd__mux2_1
X_13203_ clknet_leaf_23_clk _00175_ net603 vssd1 vssd1 vccd1 vccd1 cell0.LE_0A.config_data\[10\]
+ sky130_fd_sc_hd__dfrtp_1
X_14183_ clknet_leaf_58_clk _01155_ net721 vssd1 vssd1 vccd1 vccd1 cell3.CB_0.config_dataB\[18\]
+ sky130_fd_sc_hd__dfstp_1
X_11395_ cell0.SB0.route_sel\[69\] _01467_ _01468_ cell0.SB0.route_sel\[66\] _06263_
+ vssd1 vssd1 vccd1 vccd1 _06264_ sky130_fd_sc_hd__a221o_1
X_10346_ cell2.LE_0B.config_data\[1\] cell2.LE_0B.config_data\[0\] _05344_ vssd1 vssd1
+ vccd1 vccd1 _05345_ sky130_fd_sc_hd__mux2_1
XFILLER_98_729 vssd1 vssd1 vccd1 vccd1 sky130_fd_sc_hd__fill_1
XANTENNA__10590__Y _05548_ vssd1 vssd1 vccd1 vccd1 sky130_fd_sc_hd__diode_2
X_13134_ clknet_leaf_127_clk _00106_ net581 vssd1 vssd1 vccd1 vccd1 cell0.CB_1.config_dataB\[11\]
+ sky130_fd_sc_hd__dfstp_1
XFILLER_3_641 vccd1 vssd1 vccd1 vssd1 sky130_ef_sc_hd__decap_40_12
XANTENNA__06785__A2 net360 vssd1 vssd1 vccd1 vccd1 sky130_fd_sc_hd__diode_2
XFILLER_140_837 vssd1 vssd1 vccd1 vccd1 sky130_fd_sc_hd__fill_8
X_10277_ _01775_ cell2.LE_0A.dff_out vssd1 vssd1 vccd1 vccd1 _05277_ sky130_fd_sc_hd__or2_1
XFILLER_3_685 vccd1 vssd1 vccd1 vssd1 sky130_ef_sc_hd__decap_40_12
X_13065_ clknet_leaf_125_clk _00037_ net583 vssd1 vssd1 vccd1 vccd1 cell0.CB_1.config_dataA\[17\]
+ sky130_fd_sc_hd__dfstp_1
XANTENNA__10869__A1 net279 vssd1 vssd1 vccd1 vccd1 sky130_fd_sc_hd__diode_2
X_12016_ cell0.SB0.route_sel\[122\] cell0.SB0.route_sel\[121\] net775 vssd1 vssd1
+ vccd1 vccd1 _00453_ sky130_fd_sc_hd__mux2_1
XFILLER_2_195 vssd1 vssd1 vccd1 vccd1 sky130_fd_sc_hd__fill_1
XPHY_EDGE_ROW_131_Left_274 vssd1 vssd1 vccd1 vccd1 sky130_fd_sc_hd__decap_3
X_13967_ clknet_leaf_39_clk _00939_ net645 vssd1 vssd1 vccd1 vccd1 cell2.LEI0.config_data\[24\]
+ sky130_fd_sc_hd__dfrtp_1
XTAP_TAPCELL_ROW_66_1302 vssd1 vccd1 sky130_fd_sc_hd__tapvpwrvgnd_1
XFILLER_65_169 vssd1 vssd1 vccd1 vccd1 sky130_fd_sc_hd__fill_1
X_12918_ net1467 net1416 net954 vssd1 vssd1 vccd1 vccd1 _01347_ sky130_fd_sc_hd__mux2_1
XFILLER_0_76 vssd1 vssd1 vccd1 vccd1 sky130_fd_sc_hd__fill_8
XFILLER_19_586 vssd1 vssd1 vccd1 vccd1 sky130_fd_sc_hd__fill_1
X_13898_ clknet_1_0__leaf_cell2.LE_1A.sel_clk _00870_ net752 vssd1 vssd1 vccd1 vccd1
+ cell2.LE_1A.dff0_out sky130_fd_sc_hd__dfrtp_1
XANTENNA__11046__A1 _05856_ vssd1 vssd1 vccd1 vccd1 sky130_fd_sc_hd__diode_2
X_12849_ cell2.SB0.route_sel\[91\] cell2.SB0.route_sel\[90\] net831 vssd1 vssd1 vccd1
+ vccd1 _01278_ sky130_fd_sc_hd__mux2_1
XFILLER_34_589 vssd1 vssd1 vccd1 vccd1 sky130_fd_sc_hd__fill_1
XPHY_EDGE_ROW_140_Left_283 vssd1 vssd1 vccd1 vccd1 sky130_fd_sc_hd__decap_3
XANTENNA__11046__B2 _05861_ vssd1 vssd1 vccd1 vccd1 sky130_fd_sc_hd__diode_2
X_08040_ bus2_0\[0\] bus2_0\[1\] bus2_0\[2\] bus2_0\[3\] net534 net532 vssd1 vssd1
+ vccd1 vccd1 _03082_ sky130_fd_sc_hd__mux4_1
XTAP_TAPCELL_ROW_12_481 vssd1 vccd1 sky130_fd_sc_hd__tapvpwrvgnd_1
XANTENNA__11102__B _05874_ vssd1 vssd1 vccd1 vccd1 sky130_fd_sc_hd__diode_2
XTAP_TAPCELL_ROW_12_492 vssd1 vccd1 sky130_fd_sc_hd__tapvpwrvgnd_1
XTAP_TAPCELL_ROW_77_1464 vssd1 vccd1 sky130_fd_sc_hd__tapvpwrvgnd_1
XFILLER_142_141 vssd1 vssd1 vccd1 vccd1 sky130_fd_sc_hd__fill_1
X_09991_ net404 _04696_ _04994_ net402 vssd1 vssd1 vccd1 vccd1 _04995_ sky130_fd_sc_hd__o211a_1
X_08942_ bus3_1\[5\] _03972_ _03973_ bus3_1\[4\] cell1.CB_0.config_dataA\[18\] vssd1
+ vssd1 vccd1 vccd1 _03974_ sky130_fd_sc_hd__a221o_1
XTAP_TAPCELL_ROW_90_1664 vssd1 vccd1 sky130_fd_sc_hd__tapvpwrvgnd_1
XTAP_TAPCELL_ROW_90_1653 vssd1 vccd1 sky130_fd_sc_hd__tapvpwrvgnd_1
X_08873_ net472 net473 vssd1 vssd1 vccd1 vccd1 _03905_ sky130_fd_sc_hd__and2b_1
X_07824_ _02866_ _02868_ vssd1 vssd1 vccd1 vccd1 bus1_0\[5\] sky130_fd_sc_hd__nor2_4
XFILLER_29_339 vssd1 vssd1 vccd1 vccd1 sky130_fd_sc_hd__fill_1
X_07755_ net345 net359 _02031_ _02026_ _01863_ vssd1 vssd1 vccd1 vccd1 _02801_ sky130_fd_sc_hd__o32ai_2
XFILLER_44_309 vssd1 vssd1 vccd1 vccd1 sky130_fd_sc_hd__fill_1
XANTENNA__10088__A2 _05088_ vssd1 vssd1 vccd1 vccd1 sky130_fd_sc_hd__diode_2
X_06706_ cell3.LEI0.config_data\[11\] vssd1 vssd1 vccd1 vccd1 _01776_ sky130_fd_sc_hd__inv_2
XFILLER_71_117 vssd1 vssd1 vccd1 vccd1 sky130_fd_sc_hd__fill_1
X_07686_ _01888_ _02650_ bus3_1\[2\] vssd1 vssd1 vccd1 vccd1 _02734_ sky130_fd_sc_hd__o21ai_1
XTAP_TAPCELL_ROW_121_2130 vssd1 vccd1 sky130_fd_sc_hd__tapvpwrvgnd_1
X_06637_ cell3.SB0.route_sel\[46\] vssd1 vssd1 vccd1 vccd1 _01707_ sky130_fd_sc_hd__inv_2
X_09425_ net318 _04425_ _04447_ cell3.SB0.route_sel\[45\] cell3.SB0.route_sel\[44\]
+ vssd1 vssd1 vccd1 vccd1 _04448_ sky130_fd_sc_hd__o2111a_1
XANTENNA_fanout626_A net632 vssd1 vssd1 vccd1 vccd1 sky130_fd_sc_hd__diode_2
X_06568_ cell2.SB0.route_sel\[102\] vssd1 vssd1 vccd1 vccd1 _01638_ sky130_fd_sc_hd__inv_2
XFILLER_100_33 vssd1 vssd1 vccd1 vccd1 sky130_fd_sc_hd__fill_2
X_09356_ net303 _04379_ _04378_ vssd1 vssd1 vccd1 vccd1 _04380_ sky130_fd_sc_hd__a21oi_1
XFILLER_52_397 vssd1 vssd1 vccd1 vccd1 sky130_fd_sc_hd__fill_1
XANTENNA__08426__X cell0.CB_1.le_outB vssd1 vssd1 vccd1 vccd1 sky130_fd_sc_hd__diode_2
X_09287_ cell3.CB_0.config_dataB\[24\] cell3.CB_0.config_dataB\[20\] cell3.CB_0.config_dataB\[21\]
+ vssd1 vssd1 vccd1 vccd1 _04313_ sky130_fd_sc_hd__or3b_2
X_06499_ cell0.CB_0.config_dataA\[2\] vssd1 vssd1 vccd1 vccd1 _01569_ sky130_fd_sc_hd__inv_2
X_08307_ cell0.LEI0.config_data\[22\] _03342_ _03344_ cell0.LEI0.config_data\[23\]
+ vssd1 vssd1 vccd1 vccd1 _03345_ sky130_fd_sc_hd__a211oi_1
X_08238_ cell0.CB_1.config_dataA\[17\] _03276_ _03277_ vssd1 vssd1 vccd1 vccd1 _03278_
+ sky130_fd_sc_hd__or3_1
XTAP_TAPCELL_ROW_119_2092 vssd1 vccd1 sky130_fd_sc_hd__tapvpwrvgnd_1
X_10200_ net415 net414 vssd1 vssd1 vccd1 vccd1 _05201_ sky130_fd_sc_hd__nor2_1
XANTENNA__10548__B1 _04370_ vssd1 vssd1 vccd1 vccd1 sky130_fd_sc_hd__diode_2
X_08169_ bus1_0\[4\] _03201_ _03203_ bus1_0\[5\] cell0.CB_1.config_dataA\[8\] vssd1
+ vssd1 vccd1 vccd1 _03209_ sky130_fd_sc_hd__a221o_1
XTAP_TAPCELL_ROW_132_2292 vssd1 vccd1 sky130_fd_sc_hd__tapvpwrvgnd_1
XTAP_TAPCELL_ROW_132_2281 vssd1 vccd1 sky130_fd_sc_hd__tapvpwrvgnd_1
X_11180_ _05912_ _05916_ net385 vssd1 vssd1 vccd1 vccd1 _06132_ sky130_fd_sc_hd__mux2_1
XANTENNA__10012__A2 bus3_2\[1\] vssd1 vssd1 vccd1 vccd1 sky130_fd_sc_hd__diode_2
X_10131_ net418 _05131_ net417 vssd1 vssd1 vccd1 vccd1 _05132_ sky130_fd_sc_hd__o21ai_1
X_10062_ _05063_ _05065_ vssd1 vssd1 vccd1 vccd1 _05066_ sky130_fd_sc_hd__nor2_1
XFILLER_0_655 vssd1 vssd1 vccd1 vccd1 sky130_fd_sc_hd__fill_1
XANTENNA__08508__A3 net323 vssd1 vssd1 vccd1 vccd1 sky130_fd_sc_hd__diode_2
XFILLER_102_561 vssd1 vssd1 vccd1 vccd1 sky130_fd_sc_hd__fill_8
XFILLER_94_209 vssd1 vssd1 vccd1 vccd1 sky130_fd_sc_hd__fill_4
XFILLER_85_23 vccd1 vssd1 vccd1 vssd1 sky130_ef_sc_hd__decap_40_12
XTAP_TAPCELL_ROW_106_1903 vssd1 vccd1 sky130_fd_sc_hd__tapvpwrvgnd_1
XFILLER_75_489 vssd1 vssd1 vccd1 vccd1 sky130_fd_sc_hd__fill_1
X_13821_ clknet_leaf_104_clk _00793_ net678 vssd1 vssd1 vccd1 vccd1 cell1.SB0.route_sel\[98\]
+ sky130_fd_sc_hd__dfstp_1
XFILLER_141_51 vssd1 vssd1 vccd1 vccd1 sky130_fd_sc_hd__fill_4
XTAP_TAPCELL_ROW_48_1021 vssd1 vccd1 sky130_fd_sc_hd__tapvpwrvgnd_1
XANTENNA_input114_X net114 vssd1 vssd1 vccd1 vccd1 sky130_fd_sc_hd__diode_2
XTAP_TAPCELL_ROW_39_890 vssd1 vccd1 sky130_fd_sc_hd__tapvpwrvgnd_1
X_13752_ clknet_leaf_108_clk _00724_ net652 vssd1 vssd1 vccd1 vccd1 cell1.SB0.route_sel\[29\]
+ sky130_fd_sc_hd__dfstp_1
XFILLER_141_95 vssd1 vssd1 vccd1 vccd1 sky130_fd_sc_hd__fill_2
X_10964_ cell3.CB_0.config_dataA\[0\] _05912_ _05917_ net378 vssd1 vssd1 vccd1 vccd1
+ _05918_ sky130_fd_sc_hd__o211a_1
X_12703_ cell3.CB_1.config_dataA\[20\] cell3.CB_1.config_dataA\[19\] net938 vssd1
+ vssd1 vccd1 vccd1 _01132_ sky130_fd_sc_hd__mux2_1
XTAP_TAPCELL_ROW_48_1032 vssd1 vccd1 sky130_fd_sc_hd__tapvpwrvgnd_1
X_13683_ clknet_leaf_30_clk _00655_ net620 vssd1 vssd1 vccd1 vccd1 cell2.CB_0.config_dataB\[10\]
+ sky130_fd_sc_hd__dfstp_1
X_10895_ cell3.SB0.route_sel\[123\] cell3.SB0.route_sel\[122\] cell3.SB0.route_sel\[125\]
+ _01749_ _05848_ vssd1 vssd1 vccd1 vccd1 _05849_ sky130_fd_sc_hd__o221a_1
XANTENNA__11028__A1 net48 vssd1 vssd1 vccd1 vccd1 sky130_fd_sc_hd__diode_2
X_12634_ cell3.SB0.route_sel\[99\] cell3.SB0.route_sel\[98\] net937 vssd1 vssd1 vccd1
+ vccd1 _01063_ sky130_fd_sc_hd__mux2_1
XFILLER_70_194 vssd1 vssd1 vccd1 vccd1 sky130_fd_sc_hd__fill_2
XFILLER_70_183 vssd1 vssd1 vccd1 vccd1 sky130_fd_sc_hd__fill_1
XTAP_TAPCELL_ROW_61_1221 vssd1 vccd1 sky130_fd_sc_hd__tapvpwrvgnd_1
XFILLER_31_537 vssd1 vssd1 vccd1 vccd1 sky130_fd_sc_hd__fill_1
XFILLER_31_559 vssd1 vssd1 vccd1 vccd1 sky130_fd_sc_hd__fill_1
XANTENNA__10787__A0 net15 vssd1 vssd1 vccd1 vccd1 sky130_fd_sc_hd__diode_2
XFILLER_86_9 vccd1 vssd1 vccd1 vssd1 sky130_ef_sc_hd__decap_40_12
X_12565_ cell3.SB0.route_sel\[30\] cell3.SB0.route_sel\[29\] net910 vssd1 vssd1 vccd1
+ vccd1 _00994_ sky130_fd_sc_hd__mux2_1
XANTENNA__10251__A2 _05113_ vssd1 vssd1 vccd1 vccd1 sky130_fd_sc_hd__diode_2
X_14304_ clknet_leaf_17_clk _01276_ net627 vssd1 vssd1 vccd1 vccd1 cell2.SB0.route_sel\[89\]
+ sky130_fd_sc_hd__dfstp_1
X_11516_ _06344_ net264 vssd1 vssd1 vccd1 vccd1 net247 sky130_fd_sc_hd__and2b_2
X_12496_ net1321 net1214 net846 vssd1 vssd1 vccd1 vccd1 _00925_ sky130_fd_sc_hd__mux2_1
XFILLER_8_777 vssd1 vssd1 vccd1 vccd1 sky130_fd_sc_hd__fill_1
XANTENNA__10539__A0 net8 vssd1 vssd1 vccd1 vccd1 sky130_fd_sc_hd__diode_2
X_14235_ clknet_leaf_20_clk _01207_ net611 vssd1 vssd1 vccd1 vccd1 cell2.SB0.route_sel\[20\]
+ sky130_fd_sc_hd__dfstp_1
XFILLER_7_287 vssd1 vssd1 vccd1 vccd1 sky130_fd_sc_hd__fill_1
X_11447_ _02738_ _06298_ vssd1 vssd1 vccd1 vccd1 net207 sky130_fd_sc_hd__nor2_1
X_14166_ clknet_leaf_54_clk _01138_ net716 vssd1 vssd1 vccd1 vccd1 cell3.CB_0.config_dataB\[1\]
+ sky130_fd_sc_hd__dfstp_1
X_11378_ _02842_ _06252_ vssd1 vssd1 vccd1 vccd1 net257 sky130_fd_sc_hd__and2b_1
XANTENNA__08747__A3 _03498_ vssd1 vssd1 vccd1 vccd1 sky130_fd_sc_hd__diode_2
X_10329_ net436 _05103_ _05327_ vssd1 vssd1 vccd1 vccd1 _05328_ sky130_fd_sc_hd__a21o_1
XFILLER_112_303 vssd1 vssd1 vccd1 vccd1 sky130_fd_sc_hd__fill_1
XANTENNA__10106__X _05107_ vssd1 vssd1 vccd1 vccd1 sky130_fd_sc_hd__diode_2
XTAP_TAPCELL_ROW_59_1194 vssd1 vccd1 sky130_fd_sc_hd__tapvpwrvgnd_1
X_13117_ clknet_leaf_3_clk _00089_ net565 vssd1 vssd1 vccd1 vccd1 cell0.CB_0.config_dataA\[19\]
+ sky130_fd_sc_hd__dfstp_1
X_14097_ clknet_leaf_51_clk _01069_ net711 vssd1 vssd1 vccd1 vccd1 cell3.SB0.route_sel\[105\]
+ sky130_fd_sc_hd__dfstp_1
XANTENNA__09157__B1 net104 vssd1 vssd1 vccd1 vccd1 sky130_fd_sc_hd__diode_2
XTAP_TAPCELL_ROW_72_1394 vssd1 vccd1 sky130_fd_sc_hd__tapvpwrvgnd_1
XTAP_TAPCELL_ROW_72_1383 vssd1 vccd1 sky130_fd_sc_hd__tapvpwrvgnd_1
X_13048_ clknet_leaf_128_clk _00020_ net576 vssd1 vssd1 vccd1 vccd1 cell0.CB_1.config_dataA\[0\]
+ sky130_fd_sc_hd__dfstp_1
XFILLER_15_3 vccd1 vssd1 vccd1 vssd1 sky130_ef_sc_hd__decap_40_12
XFILLER_81_404 vssd1 vssd1 vccd1 vccd1 sky130_fd_sc_hd__fill_1
XFILLER_26_309 vssd1 vssd1 vccd1 vccd1 sky130_fd_sc_hd__fill_1
XANTENNA__11084__S _05930_ vssd1 vssd1 vccd1 vccd1 sky130_fd_sc_hd__diode_2
X_07540_ _01992_ _02379_ vssd1 vssd1 vccd1 vccd1 _02591_ sky130_fd_sc_hd__nand2_1
XANTENNA_clkbuf_leaf_80_clk_A clknet_4_12_0_clk vssd1 vssd1 vccd1 vccd1 sky130_fd_sc_hd__diode_2
XANTENNA__08132__A1 bus1_0\[13\] vssd1 vssd1 vccd1 vccd1 sky130_fd_sc_hd__diode_2
XANTENNA__10001__B _04608_ vssd1 vssd1 vccd1 vccd1 sky130_fd_sc_hd__diode_2
XANTENNA__09880__A1 _04671_ vssd1 vssd1 vccd1 vccd1 sky130_fd_sc_hd__diode_2
XANTENNA__12908__S net936 vssd1 vssd1 vccd1 vccd1 sky130_fd_sc_hd__diode_2
XANTENNA__11812__S net902 vssd1 vssd1 vccd1 vccd1 sky130_fd_sc_hd__diode_2
XTAP_TAPCELL_ROW_17_562 vssd1 vccd1 sky130_fd_sc_hd__tapvpwrvgnd_1
XFILLER_22_526 vssd1 vssd1 vccd1 vccd1 sky130_fd_sc_hd__fill_4
X_07471_ cell0.SB0.route_sel\[115\] cell0.SB0.route_sel\[114\] vssd1 vssd1 vccd1 vccd1
+ _02524_ sky130_fd_sc_hd__nor2_1
X_09210_ _02693_ _03870_ net271 vssd1 vssd1 vccd1 vccd1 _04237_ sky130_fd_sc_hd__or3b_1
X_06422_ cell0.CB_0.config_data_inA vssd1 vssd1 vccd1 vccd1 _01492_ sky130_fd_sc_hd__inv_2
XANTENNA__10778__A0 _05540_ vssd1 vssd1 vccd1 vccd1 sky130_fd_sc_hd__diode_2
X_09141_ _04127_ _04163_ _04170_ _04162_ vssd1 vssd1 vccd1 vccd1 _04171_ sky130_fd_sc_hd__a22o_1
XANTENNA_clkbuf_leaf_95_clk_A clknet_4_11_0_clk vssd1 vssd1 vccd1 vccd1 sky130_fd_sc_hd__diode_2
X_09072_ net479 _03862_ vssd1 vssd1 vccd1 vccd1 _04102_ sky130_fd_sc_hd__nand2_1
X_08023_ _02388_ _03060_ _03061_ _02456_ _01556_ vssd1 vssd1 vccd1 vccd1 _03065_ sky130_fd_sc_hd__a221o_1
XFILLER_30_29 vccd1 vssd1 vccd1 vssd1 sky130_ef_sc_hd__decap_40_12
XFILLER_116_620 vssd1 vssd1 vccd1 vccd1 sky130_fd_sc_hd__fill_1
XFILLER_89_515 vssd1 vssd1 vccd1 vccd1 sky130_fd_sc_hd__fill_1
XANTENNA_clkbuf_leaf_33_clk_A clknet_4_7_0_clk vssd1 vssd1 vccd1 vccd1 sky130_fd_sc_hd__diode_2
X_09974_ bus3_2\[8\] bus3_2\[9\] bus3_2\[10\] bus3_2\[11\] net406 net405 vssd1 vssd1
+ vccd1 vccd1 _04978_ sky130_fd_sc_hd__mux4_1
XFILLER_89_559 vssd1 vssd1 vccd1 vccd1 sky130_fd_sc_hd__fill_1
XFILLER_39_27 vccd1 vssd1 vccd1 vssd1 sky130_ef_sc_hd__decap_40_12
XFILLER_97_570 vssd1 vssd1 vccd1 vccd1 sky130_fd_sc_hd__fill_4
X_08925_ _03955_ _03956_ vssd1 vssd1 vccd1 vccd1 _03957_ sky130_fd_sc_hd__nor2_1
XFILLER_111_391 vssd1 vssd1 vccd1 vccd1 sky130_fd_sc_hd__fill_1
X_08856_ cell1.SB0.route_sel\[42\] cell1.SB0.route_sel\[43\] vssd1 vssd1 vccd1 vccd1
+ _03888_ sky130_fd_sc_hd__or2_1
X_07807_ net78 _02848_ _02851_ vssd1 vssd1 vccd1 vccd1 _02852_ sky130_fd_sc_hd__a21oi_1
XANTENNA__10399__A _05136_ vssd1 vssd1 vccd1 vccd1 sky130_fd_sc_hd__diode_2
XANTENNA_clkbuf_leaf_48_clk_A clknet_4_12_0_clk vssd1 vssd1 vccd1 vccd1 sky130_fd_sc_hd__diode_2
X_08787_ _01551_ _01552_ cell1.SB0.config_data_out _01554_ _03818_ vssd1 vssd1 vccd1
+ vccd1 _03819_ sky130_fd_sc_hd__a221o_1
XFILLER_25_331 vssd1 vssd1 vccd1 vccd1 sky130_fd_sc_hd__fill_1
X_07738_ net27 _02783_ vssd1 vssd1 vccd1 vccd1 _02784_ sky130_fd_sc_hd__or2_1
XANTENNA__08674__A2 _03489_ vssd1 vssd1 vccd1 vccd1 sky130_fd_sc_hd__diode_2
XFILLER_13_526 vssd1 vssd1 vccd1 vccd1 sky130_fd_sc_hd__fill_4
X_07669_ cell0.SB0.route_sel\[20\] cell0.SB0.route_sel\[21\] vssd1 vssd1 vccd1 vccd1
+ _02717_ sky130_fd_sc_hd__nor2_1
X_10680_ _05630_ _05635_ _05636_ vssd1 vssd1 vccd1 vccd1 _05638_ sky130_fd_sc_hd__nand3_1
XTAP_TAPCELL_ROW_101_1822 vssd1 vccd1 sky130_fd_sc_hd__tapvpwrvgnd_1
X_09408_ cell2.SB0.route_sel\[43\] cell2.SB0.route_sel\[42\] _04430_ vssd1 vssd1 vccd1
+ vccd1 _04431_ sky130_fd_sc_hd__a21oi_1
XFILLER_80_481 vssd1 vssd1 vccd1 vccd1 sky130_fd_sc_hd__fill_2
XFILLER_13_559 vssd1 vssd1 vccd1 vccd1 sky130_fd_sc_hd__fill_1
XFILLER_25_386 vssd1 vssd1 vccd1 vccd1 sky130_fd_sc_hd__fill_1
X_09339_ _04216_ _04363_ vssd1 vssd1 vccd1 vccd1 _04364_ sky130_fd_sc_hd__nand2_1
XANTENNA__07501__A cell0.CB_0.le_outB vssd1 vssd1 vccd1 vccd1 sky130_fd_sc_hd__diode_2
XANTENNA__11023__A _05898_ vssd1 vssd1 vccd1 vccd1 sky130_fd_sc_hd__diode_2
XPHY_EDGE_ROW_109_Right_109 vssd1 vssd1 vccd1 vccd1 sky130_fd_sc_hd__decap_3
XANTENNA_clkbuf_leaf_106_clk_A clknet_4_8_0_clk vssd1 vssd1 vccd1 vccd1 sky130_fd_sc_hd__diode_2
XTAP_TAPCELL_ROW_134_2321 vssd1 vccd1 sky130_fd_sc_hd__tapvpwrvgnd_1
X_12350_ cell1.SB0.route_sel\[88\] cell1.SB0.route_sel\[87\] net871 vssd1 vssd1 vccd1
+ vccd1 _00783_ sky130_fd_sc_hd__mux2_1
X_11301_ _05489_ net287 _04405_ vssd1 vssd1 vccd1 vccd1 _06215_ sky130_fd_sc_hd__mux2_1
XFILLER_5_725 vssd1 vssd1 vccd1 vccd1 sky130_fd_sc_hd__fill_2
X_12281_ cell1.SB0.route_sel\[19\] cell1.SB0.route_sel\[18\] net865 vssd1 vssd1 vccd1
+ vccd1 _00714_ sky130_fd_sc_hd__mux2_1
X_11232_ cell3.LE_0B.config_data\[2\] cell3.LE_0B.config_data\[3\] _06076_ vssd1 vssd1
+ vccd1 vccd1 _06184_ sky130_fd_sc_hd__mux2_1
XFILLER_106_141 vssd1 vssd1 vccd1 vccd1 sky130_fd_sc_hd__fill_1
XANTENNA__09428__A net14 vssd1 vssd1 vccd1 vccd1 sky130_fd_sc_hd__diode_2
X_14020_ clknet_leaf_80_clk _00992_ net702 vssd1 vssd1 vccd1 vccd1 cell3.SB0.route_sel\[28\]
+ sky130_fd_sc_hd__dfstp_1
XANTENNA__10073__S _05030_ vssd1 vssd1 vccd1 vccd1 sky130_fd_sc_hd__diode_2
X_11163_ _05856_ _06108_ _06110_ _05861_ _01800_ vssd1 vssd1 vccd1 vccd1 _06115_ sky130_fd_sc_hd__a221o_1
XFILLER_122_623 vssd1 vssd1 vccd1 vccd1 sky130_fd_sc_hd__fill_1
XFILLER_122_601 vssd1 vssd1 vccd1 vccd1 sky130_fd_sc_hd__fill_1
XFILLER_20_73 vssd1 vssd1 vccd1 vccd1 sky130_fd_sc_hd__fill_8
X_10114_ _05099_ _05114_ cell2.CB_0.config_dataA\[7\] vssd1 vssd1 vccd1 vccd1 _05115_
+ sky130_fd_sc_hd__o21ai_1
X_11094_ net389 net388 vssd1 vssd1 vccd1 vccd1 _06046_ sky130_fd_sc_hd__nor2_1
XTAP_TAPCELL_ROW_112_1995 vssd1 vccd1 sky130_fd_sc_hd__tapvpwrvgnd_1
XTAP_TAPCELL_ROW_112_1984 vssd1 vccd1 sky130_fd_sc_hd__tapvpwrvgnd_1
XFILLER_0_463 vssd1 vssd1 vccd1 vccd1 sky130_fd_sc_hd__fill_1
X_10045_ bus3_2\[4\] _05033_ _05035_ bus3_2\[5\] cell2.CB_1.config_dataB\[18\] vssd1
+ vssd1 vccd1 vccd1 _05049_ sky130_fd_sc_hd__a221o_1
XFILLER_75_220 vssd1 vssd1 vccd1 vccd1 sky130_fd_sc_hd__fill_4
XANTENNA_clkbuf_4_10_0_clk_A clknet_0_clk vssd1 vssd1 vccd1 vccd1 sky130_fd_sc_hd__diode_2
Xhold82 cell2.LE_1A.config_data\[5\] vssd1 vssd1 vccd1 vccd1 net1041 sky130_fd_sc_hd__dlygate4sd3_1
Xhold71 _00908_ vssd1 vssd1 vccd1 vccd1 net1030 sky130_fd_sc_hd__dlygate4sd3_1
Xhold60 _00178_ vssd1 vssd1 vccd1 vccd1 net1019 sky130_fd_sc_hd__dlygate4sd3_1
Xhold93 _00496_ vssd1 vssd1 vccd1 vccd1 net1052 sky130_fd_sc_hd__dlygate4sd3_1
X_13804_ clknet_leaf_112_clk _00776_ net656 vssd1 vssd1 vccd1 vccd1 cell1.SB0.route_sel\[81\]
+ sky130_fd_sc_hd__dfstp_1
X_11996_ cell0.SB0.route_sel\[102\] cell0.SB0.route_sel\[101\] net767 vssd1 vssd1
+ vccd1 vccd1 _00433_ sky130_fd_sc_hd__mux2_1
X_10947_ _04419_ _05900_ vssd1 vssd1 vccd1 vccd1 _05901_ sky130_fd_sc_hd__and2_2
X_13735_ clknet_leaf_106_clk _00707_ net660 vssd1 vssd1 vccd1 vccd1 cell1.SB0.route_sel\[12\]
+ sky130_fd_sc_hd__dfstp_1
XANTENNA__08665__A2 _01821_ vssd1 vssd1 vccd1 vccd1 sky130_fd_sc_hd__diode_2
XTAP_TAPCELL_ROW_34_819 vssd1 vccd1 sky130_fd_sc_hd__tapvpwrvgnd_1
X_13666_ clknet_leaf_45_clk _00638_ net630 vssd1 vssd1 vccd1 vccd1 cell2.CB_1.config_dataA\[18\]
+ sky130_fd_sc_hd__dfstp_1
XTAP_TAPCELL_ROW_14_521 vssd1 vccd1 sky130_fd_sc_hd__tapvpwrvgnd_1
X_10878_ _05832_ _05833_ _05758_ vssd1 vssd1 vccd1 vccd1 _05834_ sky130_fd_sc_hd__mux2_1
X_12617_ cell3.SB0.route_sel\[82\] cell3.SB0.route_sel\[81\] net878 vssd1 vssd1 vccd1
+ vccd1 _01046_ sky130_fd_sc_hd__mux2_1
Xclkbuf_4_14_0_clk clknet_0_clk vssd1 vssd1 vccd1 vccd1 clknet_4_14_0_clk sky130_fd_sc_hd__clkbuf_8
X_13597_ clknet_leaf_89_clk _00569_ net689 vssd1 vssd1 vccd1 vccd1 cell1.LEI0.config_data\[18\]
+ sky130_fd_sc_hd__dfrtp_1
XANTENNA__10224__A2 net55 vssd1 vssd1 vccd1 vccd1 sky130_fd_sc_hd__diode_2
X_12548_ cell3.SB0.route_sel\[13\] cell3.SB0.route_sel\[12\] net936 vssd1 vssd1 vccd1
+ vccd1 _00977_ sky130_fd_sc_hd__mux2_1
XANTENNA__07625__B1 _02673_ vssd1 vssd1 vccd1 vccd1 sky130_fd_sc_hd__diode_2
XANTENNA_2 CBnorth_in[11] vssd1 vssd1 vccd1 vccd1 sky130_fd_sc_hd__diode_2
XANTENNA__10775__A3 net25 vssd1 vssd1 vccd1 vccd1 sky130_fd_sc_hd__diode_2
X_12479_ cell2.LE_0A.config_data\[16\] net1029 net822 vssd1 vssd1 vccd1 vccd1 _00909_
+ sky130_fd_sc_hd__mux2_1
XFILLER_99_802 vssd1 vssd1 vccd1 vccd1 sky130_fd_sc_hd__fill_1
XTAP_TAPCELL_ROW_74_1412 vssd1 vccd1 sky130_fd_sc_hd__tapvpwrvgnd_1
X_14218_ clknet_leaf_12_clk _01190_ net588 vssd1 vssd1 vccd1 vccd1 cell2.SB0.route_sel\[3\]
+ sky130_fd_sc_hd__dfstp_1
XFILLER_6_53 vccd1 vssd1 vccd1 vssd1 sky130_ef_sc_hd__decap_40_12
XFILLER_98_323 vssd1 vssd1 vccd1 vccd1 sky130_fd_sc_hd__fill_1
XFILLER_98_301 vssd1 vssd1 vccd1 vccd1 sky130_fd_sc_hd__fill_1
XTAP_TAPCELL_ROW_74_1423 vssd1 vccd1 sky130_fd_sc_hd__tapvpwrvgnd_1
XANTENNA__07928__A1 bus2_0\[9\] vssd1 vssd1 vccd1 vccd1 sky130_fd_sc_hd__diode_2
XANTENNA__11724__A2 net548 vssd1 vssd1 vccd1 vccd1 sky130_fd_sc_hd__diode_2
XFILLER_6_97 vccd1 vssd1 vccd1 vssd1 sky130_ef_sc_hd__decap_40_12
XANTENNA__10491__B _03540_ vssd1 vssd1 vccd1 vccd1 sky130_fd_sc_hd__diode_2
X_14149_ clknet_leaf_68_clk _01121_ net736 vssd1 vssd1 vccd1 vccd1 cell3.CB_1.config_dataA\[9\]
+ sky130_fd_sc_hd__dfstp_2
Xfanout509 cell0.CB_1.config_dataB\[0\] vssd1 vssd1 vccd1 vccd1 net509 sky130_fd_sc_hd__buf_2
XFILLER_140_475 vssd1 vssd1 vccd1 vccd1 sky130_fd_sc_hd__fill_1
XFILLER_113_689 vssd1 vssd1 vccd1 vccd1 sky130_fd_sc_hd__fill_1
X_06971_ cell0.SB0.route_sel\[64\] cell0.SB0.route_sel\[65\] _02025_ _02036_ net764
+ vssd1 vssd1 vccd1 vccd1 _02037_ sky130_fd_sc_hd__a311o_4
X_09690_ cell3.SB0.route_sel\[115\] cell3.SB0.route_sel\[114\] net296 _04702_ vssd1
+ vssd1 vccd1 vccd1 _04704_ sky130_fd_sc_hd__a22o_1
XANTENNA__08896__B _03881_ vssd1 vssd1 vccd1 vccd1 sky130_fd_sc_hd__diode_2
X_08710_ cell1.CB_1.config_dataB\[11\] _03742_ _03743_ vssd1 vssd1 vccd1 vccd1 _03744_
+ sky130_fd_sc_hd__a21o_1
X_08641_ cell1.CB_1.config_dataB\[8\] cell1.CB_1.config_dataB\[7\] vssd1 vssd1 vccd1
+ vccd1 _03675_ sky130_fd_sc_hd__nor2_1
XFILLER_27_629 vssd1 vssd1 vccd1 vccd1 sky130_fd_sc_hd__fill_1
XFILLER_82_757 vssd1 vssd1 vccd1 vccd1 sky130_fd_sc_hd__fill_1
X_08572_ net491 _03468_ vssd1 vssd1 vccd1 vccd1 _03608_ sky130_fd_sc_hd__nand2_1
XTAP_TAPCELL_ROW_85_1585 vssd1 vccd1 sky130_fd_sc_hd__tapvpwrvgnd_1
XANTENNA__09360__X _04384_ vssd1 vssd1 vccd1 vccd1 sky130_fd_sc_hd__diode_2
X_07523_ bus3_1\[15\] _02574_ vssd1 vssd1 vccd1 vccd1 _02575_ sky130_fd_sc_hd__and2_1
X_07454_ _01884_ _02365_ vssd1 vssd1 vccd1 vccd1 _02508_ sky130_fd_sc_hd__or2_1
XANTENNA__07321__A _02377_ vssd1 vssd1 vccd1 vccd1 sky130_fd_sc_hd__diode_2
X_06405_ cell0.SB0.route_sel\[90\] vssd1 vssd1 vccd1 vccd1 _01475_ sky130_fd_sc_hd__inv_2
XANTENNA_fanout324_A cell1.CB_1.le_outB vssd1 vssd1 vccd1 vccd1 sky130_fd_sc_hd__diode_2
X_07385_ bus3_1\[13\] _02439_ _02440_ vssd1 vssd1 vccd1 vccd1 _02441_ sky130_fd_sc_hd__a21bo_1
XFILLER_41_39 vccd1 vssd1 vccd1 vssd1 sky130_ef_sc_hd__decap_40_12
XANTENNA__10215__A2 _05128_ vssd1 vssd1 vccd1 vccd1 sky130_fd_sc_hd__diode_2
X_09124_ net477 _03841_ _04153_ cell1.CB_0.config_dataB\[16\] vssd1 vssd1 vccd1 vccd1
+ _04154_ sky130_fd_sc_hd__o211a_1
XTAP_TAPCELL_ROW_116_2051 vssd1 vccd1 sky130_fd_sc_hd__tapvpwrvgnd_1
X_09055_ cell1.CB_0.config_dataB\[4\] _04054_ _04058_ vssd1 vssd1 vccd1 vccd1 _04085_
+ sky130_fd_sc_hd__nand3_1
X_08006_ bus2_0\[6\] bus2_0\[7\] net531 vssd1 vssd1 vccd1 vccd1 _03048_ sky130_fd_sc_hd__mux2_1
Xhold530 cell0.LE_0A.reset_val vssd1 vssd1 vccd1 vccd1 net1489 sky130_fd_sc_hd__dlygate4sd3_1
Xhold552 cell3.LE_1B.reset_val vssd1 vssd1 vccd1 vccd1 net1511 sky130_fd_sc_hd__dlygate4sd3_1
Xhold563 cell2.LEI0.config_data\[22\] vssd1 vssd1 vccd1 vccd1 net1522 sky130_fd_sc_hd__dlygate4sd3_1
Xhold541 _01410_ vssd1 vssd1 vccd1 vccd1 net1500 sky130_fd_sc_hd__dlygate4sd3_1
XANTENNA__07919__A1 bus2_0\[1\] vssd1 vssd1 vccd1 vccd1 sky130_fd_sc_hd__diode_2
XFILLER_1_205 vccd1 vssd1 vccd1 vssd1 sky130_ef_sc_hd__decap_40_12
Xmax_cap271 _02698_ vssd1 vssd1 vccd1 vccd1 net271 sky130_fd_sc_hd__clkbuf_2
Xhold585 cell2.LEI0.config_data\[15\] vssd1 vssd1 vccd1 vccd1 net1544 sky130_fd_sc_hd__dlygate4sd3_1
Xhold574 cell3.LEI0.config_data\[46\] vssd1 vssd1 vccd1 vccd1 net1533 sky130_fd_sc_hd__dlygate4sd3_1
XFILLER_1_249 vccd1 vssd1 vccd1 vssd1 sky130_ef_sc_hd__decap_40_12
XFILLER_106_21 vssd1 vssd1 vccd1 vccd1 sky130_fd_sc_hd__fill_4
X_09957_ net406 _04298_ _04960_ net405 vssd1 vssd1 vccd1 vccd1 _04961_ sky130_fd_sc_hd__o211a_1
XANTENNA_fanout958_A net959 vssd1 vssd1 vccd1 vccd1 sky130_fd_sc_hd__diode_2
XANTENNA__14390__RESET_B net753 vssd1 vssd1 vccd1 vccd1 sky130_fd_sc_hd__diode_2
X_08908_ net466 net467 vssd1 vssd1 vccd1 vccd1 _03940_ sky130_fd_sc_hd__and2b_1
X_09888_ bus3_2\[6\] bus3_2\[7\] net439 vssd1 vssd1 vccd1 vccd1 _04894_ sky130_fd_sc_hd__mux2_1
XANTENNA__07552__C1 net551 vssd1 vssd1 vccd1 vccd1 sky130_fd_sc_hd__diode_2
X_08839_ _03870_ net271 vssd1 vssd1 vccd1 vccd1 _03871_ sky130_fd_sc_hd__nand2b_4
XFILLER_122_53 vssd1 vssd1 vccd1 vccd1 sky130_fd_sc_hd__fill_8
X_11850_ net481 net483 net897 vssd1 vssd1 vccd1 vccd1 _00287_ sky130_fd_sc_hd__mux2_1
X_10801_ cell3.LEI0.config_data\[22\] _05756_ _05754_ cell3.LEI0.config_data\[23\]
+ vssd1 vssd1 vccd1 vccd1 _05757_ sky130_fd_sc_hd__a211o_1
XANTENNA__09844__A1 _04260_ vssd1 vssd1 vccd1 vccd1 sky130_fd_sc_hd__diode_2
XANTENNA__12548__S net936 vssd1 vssd1 vccd1 vccd1 sky130_fd_sc_hd__diode_2
X_11781_ net1361 net1399 net800 vssd1 vssd1 vccd1 vccd1 _00218_ sky130_fd_sc_hd__mux2_1
X_10732_ cell3.LE_1A.config_data\[16\] _05687_ _05688_ net352 vssd1 vssd1 vccd1 vccd1
+ cell3.CB_1.le_outA sky130_fd_sc_hd__o211a_1
XANTENNA__09844__B2 _04197_ vssd1 vssd1 vccd1 vccd1 sky130_fd_sc_hd__diode_2
XFILLER_41_610 vssd1 vssd1 vccd1 vccd1 sky130_fd_sc_hd__fill_1
X_13520_ clknet_leaf_100_clk _00492_ net680 vssd1 vssd1 vccd1 vccd1 cell1.LE_1A.config_data\[7\]
+ sky130_fd_sc_hd__dfrtp_1
XTAP_TAPCELL_ROW_0_293 vssd1 vccd1 sky130_fd_sc_hd__tapvpwrvgnd_1
XANTENNA__07231__A net327 vssd1 vssd1 vccd1 vccd1 sky130_fd_sc_hd__diode_2
XFILLER_15_51 vssd1 vssd1 vccd1 vccd1 sky130_fd_sc_hd__fill_4
X_10663_ net14 _05602_ _05603_ net13 cell3.CB_1.config_dataA\[13\] vssd1 vssd1 vccd1
+ vccd1 _05621_ sky130_fd_sc_hd__a221o_1
X_13451_ clknet_leaf_123_clk _00423_ net587 vssd1 vssd1 vccd1 vccd1 cell0.SB0.route_sel\[92\]
+ sky130_fd_sc_hd__dfstp_1
X_12402_ cell2.CB_1.config_dataB\[12\] net402 net833 vssd1 vssd1 vccd1 vccd1 _00835_
+ sky130_fd_sc_hd__mux2_1
X_10594_ _01726_ cell3.SB0.route_sel\[79\] _05551_ vssd1 vssd1 vccd1 vccd1 _05552_
+ sky130_fd_sc_hd__o21ai_1
XANTENNA_input87_A SBsouth_in[2] vssd1 vssd1 vccd1 vccd1 sky130_fd_sc_hd__diode_2
X_13382_ clknet_leaf_131_clk _00354_ net559 vssd1 vssd1 vccd1 vccd1 cell0.SB0.route_sel\[23\]
+ sky130_fd_sc_hd__dfstp_1
X_12333_ cell1.SB0.route_sel\[71\] cell1.SB0.route_sel\[70\] net868 vssd1 vssd1 vccd1
+ vccd1 _00766_ sky130_fd_sc_hd__mux2_1
XFILLER_142_729 vssd1 vssd1 vccd1 vccd1 sky130_fd_sc_hd__fill_1
X_14003_ clknet_leaf_76_clk _00975_ net725 vssd1 vssd1 vccd1 vccd1 cell3.SB0.route_sel\[11\]
+ sky130_fd_sc_hd__dfstp_1
XFILLER_5_599 vccd1 vssd1 vccd1 vssd1 sky130_ef_sc_hd__decap_40_12
XFILLER_5_577 vssd1 vssd1 vccd1 vccd1 sky130_fd_sc_hd__fill_1
X_12264_ cell1.SB0.route_sel\[2\] cell1.SB0.route_sel\[1\] net885 vssd1 vssd1 vccd1
+ vccd1 _00697_ sky130_fd_sc_hd__mux2_1
X_11215_ _05871_ _05874_ _01802_ vssd1 vssd1 vccd1 vccd1 _06167_ sky130_fd_sc_hd__mux2_1
X_12195_ cell2.CB_1.config_dataA\[8\] cell2.CB_1.config_dataA\[7\] net924 vssd1 vssd1
+ vccd1 vccd1 _00628_ sky130_fd_sc_hd__mux2_1
XTAP_TAPCELL_ROW_56_1153 vssd1 vccd1 sky130_fd_sc_hd__tapvpwrvgnd_1
XTAP_TAPCELL_ROW_56_1142 vssd1 vccd1 sky130_fd_sc_hd__tapvpwrvgnd_1
XANTENNA_input42_X net42 vssd1 vssd1 vccd1 vccd1 sky130_fd_sc_hd__diode_2
X_11146_ net40 net41 net42 net43 cell3.CB_0.config_dataB\[5\] net386 vssd1 vssd1 vccd1
+ vccd1 _06098_ sky130_fd_sc_hd__mux4_1
XANTENNA_output243_A net243 vssd1 vssd1 vccd1 vccd1 sky130_fd_sc_hd__diode_2
X_11077_ cell3.LE_0A.config_data\[8\] cell3.LE_0A.config_data\[9\] _05930_ vssd1 vssd1
+ vccd1 vccd1 _06031_ sky130_fd_sc_hd__mux2_1
XFILLER_1_783 vssd1 vssd1 vccd1 vccd1 sky130_fd_sc_hd__fill_1
X_10028_ _04993_ _05031_ _04992_ vssd1 vssd1 vccd1 vccd1 _05032_ sky130_fd_sc_hd__mux2_1
XFILLER_76_573 vssd1 vssd1 vccd1 vccd1 sky130_fd_sc_hd__fill_4
XFILLER_17_673 vssd1 vssd1 vccd1 vccd1 sky130_fd_sc_hd__fill_1
X_13718_ clknet_leaf_29_clk _00690_ net618 vssd1 vssd1 vccd1 vccd1 cell2.CB_0.config_dataA\[20\]
+ sky130_fd_sc_hd__dfstp_1
XANTENNA__09835__A1 bus3_2\[14\] vssd1 vssd1 vccd1 vccd1 sky130_fd_sc_hd__diode_2
X_11979_ cell0.SB0.route_sel\[85\] cell0.SB0.route_sel\[84\] net784 vssd1 vssd1 vccd1
+ vccd1 _00416_ sky130_fd_sc_hd__mux2_1
XANTENNA__07141__A net344 vssd1 vssd1 vccd1 vccd1 sky130_fd_sc_hd__diode_2
XFILLER_16_194 vssd1 vssd1 vccd1 vccd1 sky130_fd_sc_hd__fill_2
XFILLER_32_643 vssd1 vssd1 vccd1 vccd1 sky130_fd_sc_hd__fill_1
X_13649_ clknet_leaf_41_clk _00621_ net641 vssd1 vssd1 vccd1 vccd1 cell2.CB_1.config_dataA\[1\]
+ sky130_fd_sc_hd__dfstp_1
XANTENNA__09063__A2 bus3_1\[14\] vssd1 vssd1 vccd1 vccd1 sky130_fd_sc_hd__diode_2
X_07170_ cell1.SB0.route_sel\[80\] cell1.SB0.route_sel\[81\] _01533_ cell1.SB0.route_sel\[83\]
+ _02231_ vssd1 vssd1 vccd1 vccd1 _02232_ sky130_fd_sc_hd__o221a_1
Xclkbuf_leaf_120_clk clknet_4_3_0_clk vssd1 vssd1 vccd1 vccd1 clknet_leaf_120_clk
+ sky130_fd_sc_hd__clkbuf_8
XFILLER_141_751 vccd1 vssd1 vccd1 vssd1 sky130_ef_sc_hd__decap_40_12
Xfanout317 net318 vssd1 vssd1 vccd1 vccd1 net317 sky130_fd_sc_hd__clkbuf_4
Xfanout306 net308 vssd1 vssd1 vccd1 vccd1 net306 sky130_fd_sc_hd__clkbuf_2
X_09811_ net446 _04815_ _04816_ vssd1 vssd1 vccd1 vccd1 _04817_ sky130_fd_sc_hd__a21o_1
XANTENNA__09771__A0 bus3_2\[0\] vssd1 vssd1 vccd1 vccd1 sky130_fd_sc_hd__diode_2
XFILLER_87_827 vssd1 vssd1 vccd1 vccd1 sky130_fd_sc_hd__fill_1
Xfanout328 net329 vssd1 vssd1 vccd1 vccd1 net328 sky130_fd_sc_hd__clkbuf_4
Xfanout339 net340 vssd1 vssd1 vccd1 vccd1 net339 sky130_fd_sc_hd__buf_2
XANTENNA__08574__A1 _03477_ vssd1 vssd1 vccd1 vccd1 sky130_fd_sc_hd__diode_2
XANTENNA__08574__B2 _03473_ vssd1 vssd1 vccd1 vccd1 sky130_fd_sc_hd__diode_2
XANTENNA_clkload11_A clknet_4_12_0_clk vssd1 vssd1 vccd1 vccd1 sky130_fd_sc_hd__diode_2
XFILLER_86_337 vssd1 vssd1 vccd1 vccd1 sky130_fd_sc_hd__fill_1
X_09742_ _04750_ _04345_ vssd1 vssd1 vccd1 vccd1 bus2_0\[3\] sky130_fd_sc_hd__and2b_2
X_06954_ _02017_ _02019_ _02018_ vssd1 vssd1 vccd1 vccd1 _02020_ sky130_fd_sc_hd__a21o_1
X_09673_ _04676_ _04682_ _04687_ vssd1 vssd1 vccd1 vccd1 _04688_ sky130_fd_sc_hd__a21oi_2
XTAP_TAPCELL_ROW_87_1614 vssd1 vccd1 sky130_fd_sc_hd__tapvpwrvgnd_1
XANTENNA__08877__A2 bus3_1\[10\] vssd1 vssd1 vccd1 vccd1 sky130_fd_sc_hd__diode_2
XFILLER_39_275 vssd1 vssd1 vccd1 vccd1 sky130_fd_sc_hd__fill_1
X_06885_ cell0.SB0.route_sel\[56\] cell0.SB0.route_sel\[57\] _01942_ _01952_ net762
+ vssd1 vssd1 vccd1 vccd1 _01953_ sky130_fd_sc_hd__a311oi_4
X_08624_ _03658_ _03659_ _03583_ vssd1 vssd1 vccd1 vccd1 _03660_ sky130_fd_sc_hd__mux2_1
XANTENNA__09090__X _04120_ vssd1 vssd1 vccd1 vccd1 sky130_fd_sc_hd__diode_2
X_08555_ net29 net30 net491 vssd1 vssd1 vccd1 vccd1 _03591_ sky130_fd_sc_hd__mux2_1
X_07506_ cell0.SB0.config_data_out cell0.SB0.route_sel\[126\] vssd1 vssd1 vccd1 vccd1
+ _02558_ sky130_fd_sc_hd__nand2b_1
X_08486_ _01664_ _03521_ vssd1 vssd1 vccd1 vccd1 _03522_ sky130_fd_sc_hd__nand2_1
XANTENNA_fanout706_A net724 vssd1 vssd1 vccd1 vccd1 sky130_fd_sc_hd__diode_2
XANTENNA_fanout327_X net327 vssd1 vssd1 vccd1 vccd1 sky130_fd_sc_hd__diode_2
XFILLER_10_304 vssd1 vssd1 vccd1 vccd1 sky130_fd_sc_hd__fill_1
X_07437_ cell0.SB0.route_sel\[112\] cell0.SB0.route_sel\[113\] _02483_ _02490_ net766
+ vssd1 vssd1 vccd1 vccd1 _02491_ sky130_fd_sc_hd__a311oi_4
XFILLER_22_186 vssd1 vssd1 vccd1 vccd1 sky130_fd_sc_hd__fill_1
X_07368_ cell0.SB0.route_sel\[104\] _01479_ cell0.SB0.route_sel\[109\] cell0.SB0.route_sel\[108\]
+ _02423_ vssd1 vssd1 vccd1 vccd1 _02424_ sky130_fd_sc_hd__o221a_4
XANTENNA__10739__A3 net20 vssd1 vssd1 vccd1 vccd1 sky130_fd_sc_hd__diode_2
X_09107_ bus3_1\[4\] _04128_ _04129_ bus3_1\[5\] cell1.CB_0.config_dataB\[18\] vssd1
+ vssd1 vccd1 vccd1 _04137_ sky130_fd_sc_hd__a221o_1
XTAP_TAPCELL_ROW_98_1776 vssd1 vccd1 sky130_fd_sc_hd__tapvpwrvgnd_1
XANTENNA__08801__A2 bus3_1\[14\] vssd1 vssd1 vccd1 vccd1 sky130_fd_sc_hd__diode_2
XANTENNA__06812__A1 net79 vssd1 vssd1 vccd1 vccd1 sky130_fd_sc_hd__diode_2
X_07299_ _02046_ _02356_ vssd1 vssd1 vccd1 vccd1 _02357_ sky130_fd_sc_hd__nor2_1
Xclkbuf_leaf_111_clk clknet_4_8_0_clk vssd1 vssd1 vccd1 vccd1 clknet_leaf_111_clk
+ sky130_fd_sc_hd__clkbuf_8
XANTENNA__11149__A0 _05912_ vssd1 vssd1 vccd1 vccd1 sky130_fd_sc_hd__diode_2
X_09038_ net485 _03817_ _04067_ net484 vssd1 vssd1 vccd1 vccd1 _04068_ sky130_fd_sc_hd__o211a_1
Xhold371 cell3.LE_0B.config_data\[1\] vssd1 vssd1 vccd1 vccd1 net1330 sky130_fd_sc_hd__dlygate4sd3_1
XFILLER_104_431 vssd1 vssd1 vccd1 vccd1 sky130_fd_sc_hd__fill_1
Xhold360 _00015_ vssd1 vssd1 vccd1 vccd1 net1319 sky130_fd_sc_hd__dlygate4sd3_1
XFILLER_2_525 vssd1 vssd1 vccd1 vccd1 sky130_fd_sc_hd__fill_4
Xhold393 _01106_ vssd1 vssd1 vccd1 vccd1 net1352 sky130_fd_sc_hd__dlygate4sd3_1
Xhold382 cell2.LEI0.config_data\[23\] vssd1 vssd1 vccd1 vccd1 net1341 sky130_fd_sc_hd__dlygate4sd3_1
X_11000_ _01809_ _05949_ _05950_ _05953_ vssd1 vssd1 vccd1 vccd1 _05954_ sky130_fd_sc_hd__o2bb2a_1
XFILLER_2_569 vccd1 vssd1 vccd1 vssd1 sky130_ef_sc_hd__decap_40_12
Xfanout851 net854 vssd1 vssd1 vccd1 vccd1 net851 sky130_fd_sc_hd__clkbuf_2
XTAP_TAPCELL_ROW_129_2242 vssd1 vccd1 sky130_fd_sc_hd__tapvpwrvgnd_1
Xfanout840 net845 vssd1 vssd1 vccd1 vccd1 net840 sky130_fd_sc_hd__clkbuf_4
XFILLER_104_475 vssd1 vssd1 vccd1 vccd1 sky130_fd_sc_hd__fill_1
XANTENNA_fanout863_X net863 vssd1 vssd1 vccd1 vccd1 sky130_fd_sc_hd__diode_2
Xfanout884 net959 vssd1 vssd1 vccd1 vccd1 net884 sky130_fd_sc_hd__buf_2
Xfanout873 net875 vssd1 vssd1 vccd1 vccd1 net873 sky130_fd_sc_hd__clkbuf_2
Xfanout862 net863 vssd1 vssd1 vccd1 vccd1 net862 sky130_fd_sc_hd__clkbuf_2
X_12951_ cell3.LE_0B.config_data\[16\] net1333 net950 vssd1 vssd1 vccd1 vccd1 _01379_
+ sky130_fd_sc_hd__mux2_1
Xfanout895 net898 vssd1 vssd1 vccd1 vccd1 net895 sky130_fd_sc_hd__clkbuf_4
XANTENNA__08868__A2 net336 vssd1 vssd1 vccd1 vccd1 sky130_fd_sc_hd__diode_2
XTAP_TAPCELL_ROW_51_1072 vssd1 vccd1 sky130_fd_sc_hd__tapvpwrvgnd_1
XTAP_TAPCELL_ROW_5_385 vssd1 vccd1 sky130_fd_sc_hd__tapvpwrvgnd_1
XTAP_TAPCELL_ROW_142_2453 vssd1 vccd1 sky130_fd_sc_hd__tapvpwrvgnd_1
XTAP_TAPCELL_ROW_142_2442 vssd1 vccd1 sky130_fd_sc_hd__tapvpwrvgnd_1
XTAP_TAPCELL_ROW_142_2431 vssd1 vccd1 sky130_fd_sc_hd__tapvpwrvgnd_1
X_12882_ cell2.SB0.route_sel\[124\] cell2.SB0.route_sel\[123\] net832 vssd1 vssd1
+ vccd1 vccd1 _01311_ sky130_fd_sc_hd__mux2_1
XFILLER_45_245 vssd1 vssd1 vccd1 vccd1 sky130_fd_sc_hd__fill_1
XFILLER_45_223 vssd1 vssd1 vccd1 vccd1 sky130_fd_sc_hd__fill_1
X_11902_ cell0.SB0.route_sel\[8\] cell0.SB0.route_sel\[7\] net781 vssd1 vssd1 vccd1
+ vccd1 _00339_ sky130_fd_sc_hd__mux2_1
XFILLER_61_727 vssd1 vssd1 vccd1 vccd1 sky130_fd_sc_hd__fill_1
X_11833_ cell1.CB_1.config_dataA\[14\] cell1.CB_1.config_dataA\[13\] net886 vssd1
+ vssd1 vccd1 vccd1 _00270_ sky130_fd_sc_hd__mux2_1
XFILLER_14_632 vssd1 vssd1 vccd1 vccd1 sky130_fd_sc_hd__fill_1
XANTENNA__08096__A3 bus2_0\[15\] vssd1 vssd1 vccd1 vccd1 sky130_fd_sc_hd__diode_2
X_11764_ cell0.LEI0.config_data\[14\] net1435 net774 vssd1 vssd1 vccd1 vccd1 _00201_
+ sky130_fd_sc_hd__mux2_1
XTAP_TAPCELL_ROW_44_969 vssd1 vccd1 sky130_fd_sc_hd__tapvpwrvgnd_1
X_14483_ clknet_1_1__leaf_cell3.LE_0A.sel_clk _01455_ net752 vssd1 vssd1 vccd1 vccd1
+ cell3.LE_0A.dff1_out sky130_fd_sc_hd__dfstp_1
X_10715_ _05669_ _05670_ _05672_ vssd1 vssd1 vccd1 vccd1 _05673_ sky130_fd_sc_hd__and3_1
X_11695_ net1072 cell0.LE_1A.config_data\[13\] net873 vssd1 vssd1 vccd1 vccd1 _00135_
+ sky130_fd_sc_hd__mux2_1
XFILLER_9_113 vccd1 vssd1 vccd1 vssd1 sky130_ef_sc_hd__decap_40_12
XTAP_TAPCELL_ROW_24_671 vssd1 vccd1 sky130_fd_sc_hd__tapvpwrvgnd_1
X_13503_ clknet_leaf_104_clk _00475_ net678 vssd1 vssd1 vccd1 vccd1 cell1.CB_1.config_dataB\[16\]
+ sky130_fd_sc_hd__dfstp_1
X_10646_ net21 net22 net24 net25 net393 net392 vssd1 vssd1 vccd1 vccd1 _05604_ sky130_fd_sc_hd__mux4_1
XANTENNA__13992__SET_B net727 vssd1 vssd1 vccd1 vccd1 sky130_fd_sc_hd__diode_2
X_13434_ clknet_leaf_130_clk _00406_ net562 vssd1 vssd1 vccd1 vccd1 cell0.SB0.route_sel\[75\]
+ sky130_fd_sc_hd__dfstp_1
XANTENNA_output193_A net193 vssd1 vssd1 vccd1 vccd1 sky130_fd_sc_hd__diode_2
X_10577_ net21 net22 net24 net25 net395 cell3.CB_1.config_dataA\[6\] vssd1 vssd1 vccd1
+ vccd1 _05535_ sky130_fd_sc_hd__mux4_1
X_13365_ clknet_leaf_127_clk _00337_ net576 vssd1 vssd1 vccd1 vccd1 cell0.SB0.route_sel\[6\]
+ sky130_fd_sc_hd__dfstp_1
Xclkbuf_leaf_102_clk clknet_4_10_0_clk vssd1 vssd1 vccd1 vccd1 clknet_leaf_102_clk
+ sky130_fd_sc_hd__clkbuf_8
XFILLER_115_718 vssd1 vssd1 vccd1 vccd1 sky130_fd_sc_hd__fill_1
X_12316_ cell1.SB0.route_sel\[54\] cell1.SB0.route_sel\[53\] net858 vssd1 vssd1 vccd1
+ vccd1 _00749_ sky130_fd_sc_hd__mux2_1
X_13296_ clknet_leaf_103_clk _00268_ net678 vssd1 vssd1 vccd1 vccd1 cell1.CB_1.config_dataA\[12\]
+ sky130_fd_sc_hd__dfstp_2
X_12247_ cell2.CB_0.config_dataA\[10\] cell2.CB_0.config_dataA\[9\] net822 vssd1 vssd1
+ vccd1 vccd1 _00680_ sky130_fd_sc_hd__mux2_1
XANTENNA__08556__B2 net28 vssd1 vssd1 vccd1 vccd1 sky130_fd_sc_hd__diode_2
XANTENNA__08556__A1 net27 vssd1 vssd1 vccd1 vccd1 sky130_fd_sc_hd__diode_2
X_12178_ net1168 net1171 net852 vssd1 vssd1 vccd1 vccd1 _00611_ sky130_fd_sc_hd__mux2_1
X_11129_ _05856_ _06078_ _06080_ _05861_ _01799_ vssd1 vssd1 vccd1 vccd1 _06081_ sky130_fd_sc_hd__a221o_1
XFILLER_95_167 vssd1 vssd1 vccd1 vccd1 sky130_fd_sc_hd__fill_1
XANTENNA__11312__A0 _05553_ vssd1 vssd1 vccd1 vccd1 sky130_fd_sc_hd__diode_2
X_06670_ cell3.SB0.route_sel\[100\] vssd1 vssd1 vccd1 vccd1 _01740_ sky130_fd_sc_hd__inv_2
XTAP_TAPCELL_ROW_69_1344 vssd1 vccd1 sky130_fd_sc_hd__tapvpwrvgnd_1
XFILLER_37_746 vssd1 vssd1 vccd1 vccd1 sky130_fd_sc_hd__fill_1
XTAP_TAPCELL_ROW_82_1533 vssd1 vccd1 sky130_fd_sc_hd__tapvpwrvgnd_1
XTAP_TAPCELL_ROW_82_1544 vssd1 vccd1 sky130_fd_sc_hd__tapvpwrvgnd_1
X_08340_ _01827_ net346 net349 net339 cell0.LEI0.config_data\[9\] cell0.LEI0.config_data\[10\]
+ vssd1 vssd1 vccd1 vccd1 _03378_ sky130_fd_sc_hd__mux4_2
X_08271_ _03303_ _03310_ _03299_ vssd1 vssd1 vccd1 vccd1 _03311_ sky130_fd_sc_hd__mux2_1
XPHY_EDGE_ROW_17_Left_160 vssd1 vssd1 vccd1 vccd1 sky130_fd_sc_hd__decap_3
X_07222_ net84 _02279_ vssd1 vssd1 vccd1 vccd1 _02282_ sky130_fd_sc_hd__nand2_1
X_07153_ _02192_ _02212_ _02214_ vssd1 vssd1 vccd1 vccd1 _02215_ sky130_fd_sc_hd__a21o_1
XTAP_TAPCELL_ROW_113_2010 vssd1 vccd1 sky130_fd_sc_hd__tapvpwrvgnd_1
X_07084_ net321 _02047_ _02143_ _02146_ _02051_ vssd1 vssd1 vccd1 vccd1 _02148_ sky130_fd_sc_hd__o32a_1
XANTENNA__11146__A3 net43 vssd1 vssd1 vccd1 vccd1 sky130_fd_sc_hd__diode_2
XFILLER_87_613 vssd1 vssd1 vccd1 vccd1 sky130_fd_sc_hd__fill_2
XFILLER_101_423 vssd1 vssd1 vccd1 vccd1 sky130_fd_sc_hd__fill_2
XFILLER_87_679 vssd1 vssd1 vccd1 vccd1 sky130_fd_sc_hd__fill_1
X_07986_ net530 _02526_ _03027_ net529 vssd1 vssd1 vccd1 vccd1 _03028_ sky130_fd_sc_hd__o211a_1
X_06937_ _01923_ _02003_ vssd1 vssd1 vccd1 vccd1 _02004_ sky130_fd_sc_hd__nor2_1
X_09725_ cell3.SB0.route_sel\[120\] cell3.SB0.route_sel\[121\] _04737_ vssd1 vssd1
+ vccd1 vccd1 _04738_ sky130_fd_sc_hd__a21o_1
X_09656_ _02469_ _04670_ vssd1 vssd1 vccd1 vccd1 _04671_ sky130_fd_sc_hd__or2_4
XFILLER_83_841 vssd1 vssd1 vccd1 vccd1 sky130_fd_sc_hd__fill_1
XTAP_TAPCELL_ROW_2_344 vssd1 vccd1 sky130_fd_sc_hd__tapvpwrvgnd_1
XTAP_TAPCELL_ROW_2_333 vssd1 vccd1 sky130_fd_sc_hd__tapvpwrvgnd_1
XFILLER_28_768 vssd1 vssd1 vccd1 vccd1 sky130_fd_sc_hd__fill_1
XTAP_TAPCELL_ROW_124_2172 vssd1 vccd1 sky130_fd_sc_hd__tapvpwrvgnd_1
XTAP_TAPCELL_ROW_124_2161 vssd1 vccd1 sky130_fd_sc_hd__tapvpwrvgnd_1
XFILLER_103_55 vssd1 vssd1 vccd1 vccd1 sky130_fd_sc_hd__fill_1
XFILLER_82_351 vssd1 vssd1 vccd1 vccd1 sky130_fd_sc_hd__fill_1
X_06868_ net360 _01933_ bus1_0\[7\] vssd1 vssd1 vccd1 vccd1 _01936_ sky130_fd_sc_hd__o21a_1
X_08607_ _01667_ net487 _03494_ _03642_ vssd1 vssd1 vccd1 vccd1 _03643_ sky130_fd_sc_hd__o31a_1
XANTENNA__08429__X _03465_ vssd1 vssd1 vccd1 vccd1 sky130_fd_sc_hd__diode_2
XANTENNA_fanout823_A net824 vssd1 vssd1 vccd1 vccd1 sky130_fd_sc_hd__diode_2
X_09587_ _04604_ _04602_ vssd1 vssd1 vccd1 vccd1 bus3_1\[10\] sky130_fd_sc_hd__and2b_2
X_06799_ _01867_ net359 vssd1 vssd1 vccd1 vccd1 _01869_ sky130_fd_sc_hd__or2_1
XANTENNA__10409__A2 net55 vssd1 vssd1 vccd1 vccd1 sky130_fd_sc_hd__diode_2
XANTENNA__09275__A2 _04299_ vssd1 vssd1 vccd1 vccd1 sky130_fd_sc_hd__diode_2
X_08538_ _03572_ _03573_ vssd1 vssd1 vccd1 vccd1 _03574_ sky130_fd_sc_hd__nor2_1
XTAP_TAPCELL_ROW_41_928 vssd1 vccd1 sky130_fd_sc_hd__tapvpwrvgnd_1
XTAP_TAPCELL_ROW_41_917 vssd1 vccd1 sky130_fd_sc_hd__tapvpwrvgnd_1
XFILLER_11_613 vssd1 vssd1 vccd1 vccd1 sky130_fd_sc_hd__fill_2
X_08469_ _03504_ vssd1 vssd1 vccd1 vccd1 _03505_ sky130_fd_sc_hd__inv_2
XANTENNA__08483__B1 _03517_ vssd1 vssd1 vccd1 vccd1 sky130_fd_sc_hd__diode_2
XANTENNA__10290__A0 net61 vssd1 vssd1 vccd1 vccd1 sky130_fd_sc_hd__diode_2
XTAP_TAPCELL_ROW_21_630 vssd1 vccd1 sky130_fd_sc_hd__tapvpwrvgnd_1
X_10500_ net333 _02052_ _02053_ _05465_ vssd1 vssd1 vccd1 vccd1 net164 sky130_fd_sc_hd__a22o_1
XFILLER_137_821 vssd1 vssd1 vccd1 vccd1 sky130_fd_sc_hd__fill_8
XANTENNA__09027__A2 bus3_1\[2\] vssd1 vssd1 vccd1 vccd1 sky130_fd_sc_hd__diode_2
XFILLER_7_617 vccd1 vssd1 vccd1 vssd1 sky130_ef_sc_hd__decap_40_12
X_11480_ _02444_ _06320_ vssd1 vssd1 vccd1 vccd1 net219 sky130_fd_sc_hd__nor2_1
XFILLER_137_843 vssd1 vssd1 vccd1 vccd1 sky130_fd_sc_hd__fill_1
X_10431_ _01686_ cell3.SB0.route_sel\[10\] _01689_ cell3.SB0.route_sel\[13\] _05427_
+ vssd1 vssd1 vccd1 vccd1 _05428_ sky130_fd_sc_hd__a221o_1
XFILLER_12_41 vccd1 vssd1 vccd1 vssd1 sky130_ef_sc_hd__decap_40_12
X_10362_ _05360_ vssd1 vssd1 vccd1 vccd1 _05361_ sky130_fd_sc_hd__inv_2
XFILLER_128_41 vccd1 vssd1 vccd1 vssd1 sky130_ef_sc_hd__decap_40_12
X_13150_ clknet_leaf_119_clk net1300 net595 vssd1 vssd1 vccd1 vccd1 cell0.LE_1A.config_data\[1\]
+ sky130_fd_sc_hd__dfrtp_1
XFILLER_12_85 vssd1 vssd1 vccd1 vccd1 sky130_fd_sc_hd__fill_4
X_10293_ cell2.CB_0.config_dataB\[8\] cell2.CB_0.config_dataB\[7\] _05290_ _05291_
+ vssd1 vssd1 vccd1 vccd1 _05292_ sky130_fd_sc_hd__o22a_1
X_13081_ clknet_leaf_22_clk _00053_ net604 vssd1 vssd1 vccd1 vccd1 cell0.CB_0.config_dataB\[8\]
+ sky130_fd_sc_hd__dfstp_1
X_12101_ net1355 cell1.LE_0A.config_data\[5\] net877 vssd1 vssd1 vccd1 vccd1 _00535_
+ sky130_fd_sc_hd__mux2_1
XFILLER_3_834 vssd1 vssd1 vccd1 vccd1 sky130_fd_sc_hd__fill_1
XFILLER_3_823 vssd1 vssd1 vccd1 vccd1 sky130_fd_sc_hd__fill_1
XTAP_TAPCELL_ROW_53_1101 vssd1 vccd1 sky130_fd_sc_hd__tapvpwrvgnd_1
XFILLER_2_333 vccd1 vssd1 vccd1 vssd1 sky130_ef_sc_hd__decap_40_12
X_12032_ cell1.CB_1.config_dataB\[10\] cell1.CB_1.config_dataB\[9\] net901 vssd1 vssd1
+ vccd1 vccd1 _00469_ sky130_fd_sc_hd__mux2_1
Xhold190 cell1.LE_0A.config_data\[0\] vssd1 vssd1 vccd1 vccd1 net1149 sky130_fd_sc_hd__dlygate4sd3_1
XFILLER_2_377 vccd1 vssd1 vccd1 vssd1 sky130_ef_sc_hd__decap_40_12
X_13983_ clknet_leaf_34_clk _00955_ net635 vssd1 vssd1 vccd1 vccd1 cell2.LEI0.config_data\[40\]
+ sky130_fd_sc_hd__dfrtp_1
XFILLER_77_167 vssd1 vssd1 vccd1 vccd1 sky130_fd_sc_hd__fill_1
Xfanout670 net671 vssd1 vssd1 vccd1 vccd1 net670 sky130_fd_sc_hd__clkbuf_4
Xfanout692 net695 vssd1 vssd1 vccd1 vccd1 net692 sky130_fd_sc_hd__clkbuf_4
Xfanout681 net682 vssd1 vssd1 vccd1 vccd1 net681 sky130_fd_sc_hd__clkbuf_2
XTAP_TAPCELL_ROW_109_1945 vssd1 vccd1 sky130_fd_sc_hd__tapvpwrvgnd_1
X_12934_ net968 net550 _06385_ vssd1 vssd1 vccd1 vccd1 _01362_ sky130_fd_sc_hd__a21bo_1
XFILLER_74_841 vssd1 vssd1 vccd1 vccd1 sky130_fd_sc_hd__fill_1
XPHY_EDGE_ROW_16_Right_16 vssd1 vssd1 vccd1 vccd1 sky130_fd_sc_hd__decap_3
XFILLER_18_267 vssd1 vssd1 vccd1 vccd1 sky130_fd_sc_hd__fill_1
XTAP_TAPCELL_ROW_29_741 vssd1 vccd1 sky130_fd_sc_hd__tapvpwrvgnd_1
X_12865_ cell2.SB0.route_sel\[107\] cell2.SB0.route_sel\[106\] net817 vssd1 vssd1
+ vccd1 vccd1 _01294_ sky130_fd_sc_hd__mux2_1
XANTENNA_output206_A net206 vssd1 vssd1 vccd1 vccd1 sky130_fd_sc_hd__diode_2
X_12796_ cell2.SB0.route_sel\[38\] cell2.SB0.route_sel\[37\] net818 vssd1 vssd1 vccd1
+ vccd1 _01225_ sky130_fd_sc_hd__mux2_1
XANTENNA__10110__A _02469_ vssd1 vssd1 vccd1 vccd1 sky130_fd_sc_hd__diode_2
X_11816_ cell1.LE_1B.edge_mode cell1.LE_1B.config_data\[16\] net905 vssd1 vssd1 vccd1
+ vccd1 _00253_ sky130_fd_sc_hd__mux2_1
XTAP_TAPCELL_ROW_64_1274 vssd1 vccd1 sky130_fd_sc_hd__tapvpwrvgnd_1
XTAP_TAPCELL_ROW_64_1263 vssd1 vccd1 sky130_fd_sc_hd__tapvpwrvgnd_1
X_11747_ net1528 net548 _06375_ vssd1 vssd1 vccd1 vccd1 _00185_ sky130_fd_sc_hd__a21bo_1
XFILLER_14_484 vssd1 vssd1 vccd1 vccd1 sky130_fd_sc_hd__fill_1
X_14466_ clknet_leaf_63_clk _01438_ net747 vssd1 vssd1 vccd1 vccd1 cell3.LEI0.config_data\[31\]
+ sky130_fd_sc_hd__dfrtp_1
XANTENNA__09018__A2 net337 vssd1 vssd1 vccd1 vccd1 sky130_fd_sc_hd__diode_2
X_11678_ cell0.CB_1.config_dataB\[24\] cell0.CB_1.config_dataB\[23\] net784 vssd1
+ vssd1 vccd1 vccd1 _00119_ sky130_fd_sc_hd__mux2_1
X_14397_ clknet_leaf_57_clk _01369_ net722 vssd1 vssd1 vccd1 vccd1 cell3.LE_0B.config_data\[6\]
+ sky130_fd_sc_hd__dfrtp_1
X_10629_ net13 _05565_ _05568_ net14 cell3.CB_1.config_dataA\[3\] vssd1 vssd1 vccd1
+ vccd1 _05587_ sky130_fd_sc_hd__a221o_1
X_13417_ clknet_leaf_133_clk _00389_ net557 vssd1 vssd1 vccd1 vccd1 cell0.SB0.route_sel\[58\]
+ sky130_fd_sc_hd__dfstp_1
XPHY_EDGE_ROW_25_Right_25 vssd1 vssd1 vccd1 vccd1 sky130_fd_sc_hd__decap_3
XANTENNA__09974__A0 bus3_2\[8\] vssd1 vssd1 vccd1 vccd1 sky130_fd_sc_hd__diode_2
X_13348_ clknet_leaf_85_clk _00320_ net685 vssd1 vssd1 vccd1 vccd1 cell1.CB_0.config_dataA\[14\]
+ sky130_fd_sc_hd__dfstp_1
X_13279_ clknet_leaf_91_clk net1515 net698 vssd1 vssd1 vccd1 vccd1 cell1.LE_1B.config_data\[15\]
+ sky130_fd_sc_hd__dfrtp_1
X_07840_ cell0.SB0.route_sel\[35\] cell0.SB0.route_sel\[34\] vssd1 vssd1 vccd1 vccd1
+ _02884_ sky130_fd_sc_hd__or2_1
XANTENNA__07201__A1 _01933_ vssd1 vssd1 vccd1 vccd1 sky130_fd_sc_hd__diode_2
X_07771_ net325 _01890_ _02062_ _02814_ vssd1 vssd1 vccd1 vccd1 _02817_ sky130_fd_sc_hd__o31a_1
X_06722_ cell3.CB_1.config_dataA\[17\] vssd1 vssd1 vccd1 vccd1 _01792_ sky130_fd_sc_hd__inv_2
X_09510_ _02089_ _04528_ _04529_ vssd1 vssd1 vccd1 vccd1 _04530_ sky130_fd_sc_hd__a21o_1
XANTENNA__11815__S net905 vssd1 vssd1 vccd1 vccd1 sky130_fd_sc_hd__diode_2
XPHY_EDGE_ROW_34_Right_34 vssd1 vssd1 vccd1 vccd1 sky130_fd_sc_hd__decap_3
XANTENNA__10639__A2 net298 vssd1 vssd1 vccd1 vccd1 sky130_fd_sc_hd__diode_2
XANTENNA__08701__A1 cell1.LEI0.config_data\[11\] vssd1 vssd1 vccd1 vccd1 sky130_fd_sc_hd__diode_2
X_09441_ cell3.SB0.route_sel\[46\] cell3.SB0.route_sel\[47\] vssd1 vssd1 vccd1 vccd1
+ _04464_ sky130_fd_sc_hd__nor2_1
X_06653_ cell3.SB0.route_sel\[73\] vssd1 vssd1 vccd1 vccd1 _01723_ sky130_fd_sc_hd__inv_2
X_09372_ _04385_ _04389_ _04395_ net820 vssd1 vssd1 vccd1 vccd1 _04396_ sky130_fd_sc_hd__a211oi_2
X_06584_ cell1.CB_1.config_dataB\[2\] vssd1 vssd1 vccd1 vccd1 _01654_ sky130_fd_sc_hd__inv_2
X_08323_ net509 _01877_ _03360_ net508 vssd1 vssd1 vccd1 vccd1 _03361_ sky130_fd_sc_hd__o211a_1
XFILLER_33_771 vssd1 vssd1 vccd1 vccd1 sky130_fd_sc_hd__fill_1
XFILLER_137_117 vssd1 vssd1 vccd1 vccd1 sky130_fd_sc_hd__fill_1
XANTENNA__09009__A2 bus3_1\[10\] vssd1 vssd1 vccd1 vccd1 sky130_fd_sc_hd__diode_2
XPHY_EDGE_ROW_43_Right_43 vssd1 vssd1 vccd1 vccd1 sky130_fd_sc_hd__decap_3
X_08254_ _02678_ _03266_ _03267_ _02633_ cell0.CB_1.config_dataA\[17\] vssd1 vssd1
+ vccd1 vccd1 _03294_ sky130_fd_sc_hd__a221o_1
X_08185_ _02040_ _03202_ _03203_ _02136_ vssd1 vssd1 vccd1 vccd1 _03225_ sky130_fd_sc_hd__a2bb2o_1
X_07205_ cell0.SB0.route_sel\[93\] cell0.SB0.route_sel\[92\] net67 vssd1 vssd1 vccd1
+ vccd1 _02265_ sky130_fd_sc_hd__a21boi_1
XFILLER_134_813 vssd1 vssd1 vccd1 vccd1 sky130_fd_sc_hd__fill_4
XFILLER_116_9 vccd1 vssd1 vccd1 vssd1 sky130_ef_sc_hd__decap_40_12
XTAP_TAPCELL_ROW_95_1735 vssd1 vccd1 sky130_fd_sc_hd__tapvpwrvgnd_1
XANTENNA__08768__A1 cell1.LE_1B.config_data\[0\] vssd1 vssd1 vccd1 vccd1 sky130_fd_sc_hd__diode_2
X_07136_ cell0.SB0.route_sel\[85\] cell0.SB0.route_sel\[84\] net66 vssd1 vssd1 vccd1
+ vccd1 _02198_ sky130_fd_sc_hd__a21boi_1
X_07067_ cell0.SB0.route_sel\[72\] cell0.SB0.route_sel\[73\] _02130_ vssd1 vssd1 vccd1
+ vccd1 _02131_ sky130_fd_sc_hd__a21oi_1
Xoutput251 net251 vssd1 vssd1 vccd1 vccd1 SBwest_out[29] sky130_fd_sc_hd__buf_2
Xoutput240 net240 vssd1 vssd1 vccd1 vccd1 SBwest_out[19] sky130_fd_sc_hd__buf_2
XANTENNA__09717__A0 net25 vssd1 vssd1 vccd1 vccd1 sky130_fd_sc_hd__diode_2
XTAP_TAPCELL_ROW_7_414 vssd1 vccd1 sky130_fd_sc_hd__tapvpwrvgnd_1
Xoutput262 net262 vssd1 vssd1 vccd1 vccd1 config_data_out sky130_fd_sc_hd__buf_2
XFILLER_99_281 vssd1 vssd1 vccd1 vccd1 sky130_fd_sc_hd__fill_1
XANTENNA_fanout773_A net780 vssd1 vssd1 vccd1 vccd1 sky130_fd_sc_hd__diode_2
XANTENNA__07991__A2 _02235_ vssd1 vssd1 vccd1 vccd1 sky130_fd_sc_hd__diode_2
XANTENNA__09193__A1 net40 vssd1 vssd1 vccd1 vccd1 sky130_fd_sc_hd__diode_2
XTAP_TAPCELL_ROW_126_2201 vssd1 vccd1 sky130_fd_sc_hd__tapvpwrvgnd_1
XFILLER_114_21 vssd1 vssd1 vccd1 vccd1 sky130_fd_sc_hd__fill_4
XFILLER_101_275 vssd1 vssd1 vccd1 vccd1 sky130_fd_sc_hd__fill_1
XFILLER_59_167 vssd1 vssd1 vccd1 vccd1 sky130_fd_sc_hd__fill_1
XPHY_EDGE_ROW_52_Right_52 vssd1 vssd1 vccd1 vccd1 sky130_fd_sc_hd__decap_3
XANTENNA__07743__A2 net360 vssd1 vssd1 vccd1 vccd1 sky130_fd_sc_hd__diode_2
X_09708_ cell2.SB0.route_sel\[120\] cell2.SB0.route_sel\[121\] vssd1 vssd1 vccd1 vccd1
+ _04721_ sky130_fd_sc_hd__nand2b_1
XANTENNA_fanout940_A net944 vssd1 vssd1 vccd1 vccd1 sky130_fd_sc_hd__diode_2
X_07969_ cell0.LE_0A.config_data\[3\] cell0.LE_0A.config_data\[2\] _02947_ vssd1 vssd1
+ vccd1 vccd1 _03013_ sky130_fd_sc_hd__mux2_1
XFILLER_28_521 vssd1 vssd1 vccd1 vccd1 sky130_fd_sc_hd__fill_1
X_10980_ cell3.CB_0.config_dataA\[5\] net376 vssd1 vssd1 vccd1 vccd1 _05934_ sky130_fd_sc_hd__or2_1
X_09639_ _04215_ _04654_ vssd1 vssd1 vccd1 vccd1 _04655_ sky130_fd_sc_hd__nor2_1
XFILLER_83_682 vccd1 vssd1 vccd1 vssd1 sky130_ef_sc_hd__decap_40_12
XFILLER_83_671 vssd1 vssd1 vccd1 vccd1 sky130_fd_sc_hd__fill_1
XFILLER_82_170 vssd1 vssd1 vccd1 vccd1 sky130_fd_sc_hd__fill_2
XFILLER_15_204 vssd1 vssd1 vccd1 vccd1 sky130_fd_sc_hd__fill_1
XTAP_TAPCELL_ROW_26_700 vssd1 vccd1 sky130_fd_sc_hd__tapvpwrvgnd_1
XFILLER_130_53 vccd1 vssd1 vccd1 vssd1 sky130_ef_sc_hd__decap_40_12
X_12650_ cell3.SB0.route_sel\[115\] cell3.SB0.route_sel\[114\] net937 vssd1 vssd1
+ vccd1 vccd1 _01079_ sky130_fd_sc_hd__mux2_1
XANTENNA_input104_A SBwest_in[16] vssd1 vssd1 vccd1 vccd1 sky130_fd_sc_hd__diode_2
XTAP_TAPCELL_ROW_104_1875 vssd1 vccd1 sky130_fd_sc_hd__tapvpwrvgnd_1
XTAP_TAPCELL_ROW_104_1864 vssd1 vccd1 sky130_fd_sc_hd__tapvpwrvgnd_1
XFILLER_70_365 vssd1 vssd1 vccd1 vccd1 sky130_fd_sc_hd__fill_1
X_11601_ cell0.CB_1.config_dataA\[22\] cell0.CB_1.config_dataA\[21\] net859 vssd1
+ vssd1 vccd1 vccd1 _00042_ sky130_fd_sc_hd__mux2_1
X_12581_ cell3.SB0.route_sel\[46\] cell3.SB0.route_sel\[45\] net915 vssd1 vssd1 vccd1
+ vccd1 _01010_ sky130_fd_sc_hd__mux2_1
XANTENNA__10865__A _05513_ vssd1 vssd1 vccd1 vccd1 sky130_fd_sc_hd__diode_2
X_14320_ clknet_leaf_19_clk _01292_ net610 vssd1 vssd1 vccd1 vccd1 cell2.SB0.route_sel\[105\]
+ sky130_fd_sc_hd__dfstp_1
XPHY_EDGE_ROW_61_Right_61 vssd1 vssd1 vccd1 vccd1 sky130_fd_sc_hd__decap_3
X_11532_ _01650_ cell2.SB0.route_sel\[122\] vssd1 vssd1 vccd1 vccd1 _06355_ sky130_fd_sc_hd__nand2_1
XFILLER_23_51 vssd1 vssd1 vccd1 vccd1 sky130_fd_sc_hd__fill_4
XFILLER_139_51 vssd1 vssd1 vccd1 vccd1 sky130_fd_sc_hd__fill_4
XTAP_TAPCELL_ROW_137_2363 vssd1 vccd1 sky130_fd_sc_hd__tapvpwrvgnd_1
X_14251_ clknet_leaf_19_clk _01223_ net614 vssd1 vssd1 vccd1 vccd1 cell2.SB0.route_sel\[36\]
+ sky130_fd_sc_hd__dfstp_1
X_11463_ cell1.SB0.route_sel\[65\] cell1.SB0.route_sel\[64\] vssd1 vssd1 vccd1 vccd1
+ _06309_ sky130_fd_sc_hd__nand2b_1
X_14182_ clknet_leaf_58_clk _01154_ net721 vssd1 vssd1 vccd1 vccd1 cell3.CB_0.config_dataB\[17\]
+ sky130_fd_sc_hd__dfstp_1
X_10414_ _01759_ _05412_ _05411_ _05410_ vssd1 vssd1 vccd1 vccd1 _05413_ sky130_fd_sc_hd__a211o_1
XFILLER_109_375 vssd1 vssd1 vccd1 vccd1 sky130_fd_sc_hd__fill_1
XANTENNA__09718__X _04731_ vssd1 vssd1 vccd1 vccd1 sky130_fd_sc_hd__diode_2
X_13202_ clknet_leaf_23_clk net989 net603 vssd1 vssd1 vccd1 vccd1 cell0.LE_0A.config_data\[9\]
+ sky130_fd_sc_hd__dfrtp_1
X_13133_ clknet_leaf_127_clk _00105_ net577 vssd1 vssd1 vccd1 vccd1 cell0.CB_1.config_dataB\[10\]
+ sky130_fd_sc_hd__dfstp_1
X_11394_ cell0.SB0.route_sel\[64\] cell0.SB0.route_sel\[65\] vssd1 vssd1 vccd1 vccd1
+ _06263_ sky130_fd_sc_hd__nor2_1
XFILLER_140_805 vssd1 vssd1 vccd1 vccd1 sky130_fd_sc_hd__fill_4
X_10345_ _05343_ _05341_ vssd1 vssd1 vccd1 vccd1 _05344_ sky130_fd_sc_hd__and2b_2
XANTENNA__06923__B1_N _01989_ vssd1 vssd1 vccd1 vccd1 sky130_fd_sc_hd__diode_2
XFILLER_3_653 vccd1 vssd1 vccd1 vssd1 sky130_ef_sc_hd__decap_40_12
X_10276_ cell2.LE_0A.dff0_out cell2.LE_0A.dff1_out cell2.LE_0A.reset_val vssd1 vssd1
+ vccd1 vccd1 cell2.LE_0A.dff_out sky130_fd_sc_hd__mux2_1
XPHY_EDGE_ROW_70_Right_70 vssd1 vssd1 vccd1 vccd1 sky130_fd_sc_hd__decap_3
XFILLER_3_697 vccd1 vssd1 vccd1 vssd1 sky130_ef_sc_hd__decap_40_12
XFILLER_2_141 vccd1 vssd1 vccd1 vssd1 sky130_ef_sc_hd__decap_40_12
XANTENNA__07238__X bus1_0\[11\] vssd1 vssd1 vccd1 vccd1 sky130_fd_sc_hd__diode_2
X_13064_ clknet_leaf_125_clk _00036_ net583 vssd1 vssd1 vccd1 vccd1 cell0.CB_1.config_dataA\[16\]
+ sky130_fd_sc_hd__dfstp_1
XANTENNA__09184__A1 net8 vssd1 vssd1 vccd1 vccd1 sky130_fd_sc_hd__diode_2
X_12015_ cell0.SB0.route_sel\[121\] cell0.SB0.route_sel\[120\] net775 vssd1 vssd1
+ vccd1 vccd1 _00452_ sky130_fd_sc_hd__mux2_1
XANTENNA__08931__B2 _03853_ vssd1 vssd1 vccd1 vccd1 sky130_fd_sc_hd__diode_2
XANTENNA__08931__A1 _03849_ vssd1 vssd1 vccd1 vccd1 sky130_fd_sc_hd__diode_2
XFILLER_24_8 vccd1 vssd1 vccd1 vssd1 sky130_ef_sc_hd__decap_40_12
XFILLER_120_595 vssd1 vssd1 vccd1 vccd1 sky130_fd_sc_hd__fill_1
X_13966_ clknet_leaf_39_clk net1342 net642 vssd1 vssd1 vccd1 vccd1 cell2.LEI0.config_data\[23\]
+ sky130_fd_sc_hd__dfrtp_1
XANTENNA__11818__A1 cell1.LE_1B.reset_val vssd1 vssd1 vccd1 vccd1 sky130_fd_sc_hd__diode_2
XTAP_TAPCELL_ROW_66_1303 vssd1 vccd1 sky130_fd_sc_hd__tapvpwrvgnd_1
X_13897_ clknet_1_1__leaf_cell2.LE_1B.sel_clk _00869_ net752 vssd1 vssd1 vccd1 vccd1
+ cell2.LE_1B.dff1_out sky130_fd_sc_hd__dfstp_1
X_12917_ net1416 net1377 net954 vssd1 vssd1 vccd1 vccd1 _01346_ sky130_fd_sc_hd__mux2_1
XFILLER_80_107 vssd1 vssd1 vccd1 vccd1 sky130_fd_sc_hd__fill_8
XFILLER_74_693 vssd1 vssd1 vccd1 vccd1 sky130_fd_sc_hd__fill_1
XFILLER_0_55 vssd1 vssd1 vccd1 vccd1 sky130_fd_sc_hd__fill_1
X_12848_ cell2.SB0.route_sel\[90\] cell2.SB0.route_sel\[89\] net832 vssd1 vssd1 vccd1
+ vccd1 _01277_ sky130_fd_sc_hd__mux2_1
XFILLER_61_387 vssd1 vssd1 vccd1 vccd1 sky130_fd_sc_hd__fill_4
XFILLER_61_376 vssd1 vssd1 vccd1 vccd1 sky130_fd_sc_hd__fill_2
X_12779_ cell2.SB0.route_sel\[21\] cell2.SB0.route_sel\[20\] net816 vssd1 vssd1 vccd1
+ vccd1 _01208_ sky130_fd_sc_hd__mux2_1
XANTENNA__08998__A1 bus3_1\[4\] vssd1 vssd1 vccd1 vccd1 sky130_fd_sc_hd__diode_2
XANTENNA__08998__B2 bus3_1\[5\] vssd1 vssd1 vccd1 vccd1 sky130_fd_sc_hd__diode_2
X_14449_ clknet_leaf_59_clk _01421_ net735 vssd1 vssd1 vccd1 vccd1 cell3.LEI0.config_data\[14\]
+ sky130_fd_sc_hd__dfrtp_1
XFILLER_116_802 vssd1 vssd1 vccd1 vccd1 sky130_fd_sc_hd__fill_1
XTAP_TAPCELL_ROW_12_482 vssd1 vccd1 sky130_fd_sc_hd__tapvpwrvgnd_1
XTAP_TAPCELL_ROW_12_493 vssd1 vccd1 sky130_fd_sc_hd__tapvpwrvgnd_1
XTAP_TAPCELL_ROW_77_1465 vssd1 vccd1 sky130_fd_sc_hd__tapvpwrvgnd_1
X_09990_ net403 _04724_ vssd1 vssd1 vccd1 vccd1 _04994_ sky130_fd_sc_hd__nand2_1
XANTENNA__07422__A1 net340 vssd1 vssd1 vccd1 vccd1 sky130_fd_sc_hd__diode_2
X_08941_ net463 net464 vssd1 vssd1 vccd1 vccd1 _03973_ sky130_fd_sc_hd__nor2_1
XFILLER_142_197 vssd1 vssd1 vccd1 vccd1 sky130_fd_sc_hd__fill_1
XTAP_TAPCELL_ROW_90_1665 vssd1 vccd1 sky130_fd_sc_hd__tapvpwrvgnd_1
XTAP_TAPCELL_ROW_90_1654 vssd1 vccd1 sky130_fd_sc_hd__tapvpwrvgnd_1
XANTENNA__09175__B2 _04202_ vssd1 vssd1 vccd1 vccd1 sky130_fd_sc_hd__diode_2
X_08872_ net473 _03844_ vssd1 vssd1 vccd1 vccd1 _03904_ sky130_fd_sc_hd__nand2_1
XANTENNA__09363__X _04387_ vssd1 vssd1 vccd1 vccd1 sky130_fd_sc_hd__diode_2
XANTENNA__13556__RESET_B net753 vssd1 vssd1 vccd1 vccd1 sky130_fd_sc_hd__diode_2
X_07823_ cell1.SB0.route_sel\[40\] cell1.SB0.route_sel\[41\] _01515_ cell1.SB0.route_sel\[43\]
+ _02867_ vssd1 vssd1 vccd1 vccd1 _02868_ sky130_fd_sc_hd__o221a_1
XFILLER_28_29 vccd1 vssd1 vccd1 vssd1 sky130_ef_sc_hd__decap_40_12
X_07754_ net359 _02031_ bus2_0\[4\] vssd1 vssd1 vccd1 vccd1 _02800_ sky130_fd_sc_hd__o21a_1
XTAP_TAPCELL_ROW_121_2120 vssd1 vccd1 sky130_fd_sc_hd__tapvpwrvgnd_1
X_06705_ cell2.LE_0A.config_data\[16\] vssd1 vssd1 vccd1 vccd1 _01775_ sky130_fd_sc_hd__inv_2
XANTENNA__07324__A net301 vssd1 vssd1 vccd1 vccd1 sky130_fd_sc_hd__diode_2
X_07685_ _02732_ vssd1 vssd1 vccd1 vccd1 _02733_ sky130_fd_sc_hd__inv_2
XANTENNA__07489__A1 cell0.CB_1.le_outB vssd1 vssd1 vccd1 vccd1 sky130_fd_sc_hd__diode_2
XANTENNA__07489__B2 _01931_ vssd1 vssd1 vccd1 vccd1 sky130_fd_sc_hd__diode_2
X_06636_ cell3.SB0.route_sel\[42\] vssd1 vssd1 vccd1 vccd1 _01706_ sky130_fd_sc_hd__inv_2
X_09424_ cell3.SB0.route_sel\[46\] cell3.SB0.route_sel\[47\] vssd1 vssd1 vccd1 vccd1
+ _04447_ sky130_fd_sc_hd__nand2_1
Xclkbuf_leaf_91_clk clknet_4_11_0_clk vssd1 vssd1 vccd1 vccd1 clknet_leaf_91_clk sky130_fd_sc_hd__clkbuf_8
XFILLER_40_505 vssd1 vssd1 vccd1 vccd1 sky130_fd_sc_hd__fill_1
XANTENNA_fanout619_A net622 vssd1 vssd1 vccd1 vccd1 sky130_fd_sc_hd__diode_2
X_06567_ cell2.SB0.route_sel\[99\] vssd1 vssd1 vccd1 vccd1 _01637_ sky130_fd_sc_hd__inv_2
X_09355_ _01906_ _02082_ vssd1 vssd1 vccd1 vccd1 _04379_ sky130_fd_sc_hd__nor2_1
XFILLER_100_56 vssd1 vssd1 vccd1 vccd1 sky130_fd_sc_hd__fill_4
X_09286_ _04310_ _04311_ cell3.SB0.route_sel\[16\] cell3.SB0.route_sel\[17\] vssd1
+ vssd1 vccd1 vccd1 _04312_ sky130_fd_sc_hd__o211a_1
X_06498_ cell0.CB_0.config_dataA\[3\] vssd1 vssd1 vccd1 vccd1 _01568_ sky130_fd_sc_hd__inv_2
X_08306_ cell0.LEI0.config_data\[22\] _03343_ vssd1 vssd1 vccd1 vccd1 _03344_ sky130_fd_sc_hd__nor2_1
XANTENNA_clkbuf_leaf_7_clk_A clknet_4_1_0_clk vssd1 vssd1 vccd1 vccd1 sky130_fd_sc_hd__diode_2
XANTENNA__07661__A1 _02704_ vssd1 vssd1 vccd1 vccd1 sky130_fd_sc_hd__diode_2
X_08237_ _02040_ _03268_ _02136_ _03266_ vssd1 vssd1 vccd1 vccd1 _03277_ sky130_fd_sc_hd__a2bb2o_1
XTAP_TAPCELL_ROW_31_780 vssd1 vccd1 sky130_fd_sc_hd__tapvpwrvgnd_1
XTAP_TAPCELL_ROW_119_2093 vssd1 vccd1 sky130_fd_sc_hd__tapvpwrvgnd_1
XANTENNA__10548__A1 _04354_ vssd1 vssd1 vccd1 vccd1 sky130_fd_sc_hd__diode_2
X_08168_ bus1_0\[6\] bus1_0\[7\] net543 vssd1 vssd1 vccd1 vccd1 _03208_ sky130_fd_sc_hd__mux2_1
XFILLER_134_643 vssd1 vssd1 vccd1 vccd1 sky130_fd_sc_hd__fill_1
XTAP_TAPCELL_ROW_132_2282 vssd1 vccd1 sky130_fd_sc_hd__tapvpwrvgnd_1
X_07119_ net305 _02179_ _02181_ vssd1 vssd1 vccd1 vccd1 _02182_ sky130_fd_sc_hd__a21oi_1
XANTENNA__10012__A3 bus3_2\[3\] vssd1 vssd1 vccd1 vccd1 sky130_fd_sc_hd__diode_2
X_08099_ _02388_ _03125_ _03126_ _02456_ _01561_ vssd1 vssd1 vccd1 vccd1 _03141_ sky130_fd_sc_hd__a221o_1
XANTENNA__08602__B _03468_ vssd1 vssd1 vccd1 vccd1 sky130_fd_sc_hd__diode_2
XTAP_TAPCELL_ROW_132_2293 vssd1 vccd1 sky130_fd_sc_hd__tapvpwrvgnd_1
X_10130_ _05129_ _05130_ _01928_ vssd1 vssd1 vccd1 vccd1 _05131_ sky130_fd_sc_hd__a21boi_4
XFILLER_79_229 vssd1 vssd1 vccd1 vccd1 sky130_fd_sc_hd__fill_2
XFILLER_69_69 vssd1 vssd1 vccd1 vccd1 sky130_fd_sc_hd__fill_1
X_10061_ cell2.CB_0.config_data_inA _05064_ _05062_ vssd1 vssd1 vccd1 vccd1 _05065_
+ sky130_fd_sc_hd__o21ai_1
XFILLER_0_645 vssd1 vssd1 vccd1 vccd1 sky130_fd_sc_hd__fill_1
XFILLER_85_35 vccd1 vssd1 vccd1 vssd1 sky130_ef_sc_hd__decap_40_12
XANTENNA__09273__X _04299_ vssd1 vssd1 vccd1 vccd1 sky130_fd_sc_hd__diode_2
XANTENNA_hold566_A cell1.LE_1B.config_data\[13\] vssd1 vssd1 vccd1 vccd1 sky130_fd_sc_hd__diode_2
XFILLER_0_678 vssd1 vssd1 vccd1 vccd1 sky130_fd_sc_hd__fill_2
XFILLER_85_57 vssd1 vssd1 vccd1 vccd1 sky130_fd_sc_hd__fill_4
XTAP_TAPCELL_ROW_106_1904 vssd1 vccd1 sky130_fd_sc_hd__tapvpwrvgnd_1
XFILLER_75_479 vssd1 vssd1 vccd1 vccd1 sky130_fd_sc_hd__fill_2
X_13820_ clknet_leaf_113_clk _00792_ net678 vssd1 vssd1 vccd1 vccd1 cell1.SB0.route_sel\[97\]
+ sky130_fd_sc_hd__dfstp_2
X_10963_ _04354_ _04362_ _04370_ _05915_ _01806_ vssd1 vssd1 vccd1 vccd1 _05917_ sky130_fd_sc_hd__a2111o_1
XFILLER_62_118 vssd1 vssd1 vccd1 vccd1 sky130_fd_sc_hd__fill_1
XTAP_TAPCELL_ROW_48_1022 vssd1 vccd1 sky130_fd_sc_hd__tapvpwrvgnd_1
X_13751_ clknet_leaf_108_clk _00723_ net652 vssd1 vssd1 vccd1 vccd1 cell1.SB0.route_sel\[28\]
+ sky130_fd_sc_hd__dfstp_1
X_12702_ cell3.CB_1.config_dataA\[19\] cell3.CB_1.config_dataA\[18\] net939 vssd1
+ vssd1 vccd1 vccd1 _01131_ sky130_fd_sc_hd__mux2_1
Xclkbuf_leaf_82_clk clknet_4_9_0_clk vssd1 vssd1 vccd1 vccd1 clknet_leaf_82_clk sky130_fd_sc_hd__clkbuf_8
XTAP_TAPCELL_ROW_48_1033 vssd1 vccd1 sky130_fd_sc_hd__tapvpwrvgnd_1
XTAP_TAPCELL_ROW_39_891 vssd1 vccd1 sky130_fd_sc_hd__tapvpwrvgnd_1
X_13682_ clknet_leaf_30_clk _00654_ net620 vssd1 vssd1 vccd1 vccd1 cell2.CB_0.config_dataB\[9\]
+ sky130_fd_sc_hd__dfstp_1
X_10894_ cell3.SB0.route_sel\[126\] net262 vssd1 vssd1 vccd1 vccd1 _05848_ sky130_fd_sc_hd__nand2b_1
XANTENNA_input107_X net107 vssd1 vssd1 vccd1 vccd1 sky130_fd_sc_hd__diode_2
XFILLER_31_505 vssd1 vssd1 vccd1 vccd1 sky130_fd_sc_hd__fill_1
X_12633_ cell3.SB0.route_sel\[98\] cell3.SB0.route_sel\[97\] net922 vssd1 vssd1 vccd1
+ vccd1 _01062_ sky130_fd_sc_hd__mux2_1
XTAP_TAPCELL_ROW_61_1222 vssd1 vccd1 sky130_fd_sc_hd__tapvpwrvgnd_1
X_12564_ cell3.SB0.route_sel\[29\] cell3.SB0.route_sel\[28\] net878 vssd1 vssd1 vccd1
+ vccd1 _00993_ sky130_fd_sc_hd__mux2_1
XFILLER_8_701 vccd1 vssd1 vccd1 vssd1 sky130_ef_sc_hd__decap_40_12
XFILLER_34_83 vssd1 vssd1 vccd1 vccd1 sky130_fd_sc_hd__fill_1
XANTENNA__10787__A1 net16 vssd1 vssd1 vccd1 vccd1 sky130_fd_sc_hd__diode_2
X_14303_ clknet_leaf_15_clk _01275_ net625 vssd1 vssd1 vccd1 vccd1 cell2.SB0.route_sel\[88\]
+ sky130_fd_sc_hd__dfstp_1
X_11515_ cell2.SB0.route_sel\[72\] cell2.SB0.route_sel\[73\] _01628_ cell2.SB0.route_sel\[76\]
+ _06343_ vssd1 vssd1 vccd1 vccd1 _06344_ sky130_fd_sc_hd__o221a_1
X_12495_ net1214 net1145 net838 vssd1 vssd1 vccd1 vccd1 _00924_ sky130_fd_sc_hd__mux2_1
X_14234_ clknet_leaf_16_clk _01206_ net624 vssd1 vssd1 vccd1 vccd1 cell2.SB0.route_sel\[19\]
+ sky130_fd_sc_hd__dfstp_1
XANTENNA__10539__A1 net9 vssd1 vssd1 vccd1 vccd1 sky130_fd_sc_hd__diode_2
XFILLER_7_277 vssd1 vssd1 vccd1 vccd1 sky130_fd_sc_hd__fill_2
X_11446_ cell1.SB0.route_sel\[18\] _01506_ cell1.SB0.route_sel\[22\] cell1.SB0.route_sel\[23\]
+ _06297_ vssd1 vssd1 vccd1 vccd1 _06298_ sky130_fd_sc_hd__o221a_1
XANTENNA__12933__C1 net550 vssd1 vssd1 vccd1 vccd1 sky130_fd_sc_hd__diode_2
X_14165_ clknet_leaf_52_clk _01137_ net720 vssd1 vssd1 vccd1 vccd1 cell3.CB_0.config_dataB\[0\]
+ sky130_fd_sc_hd__dfstp_1
XANTENNA__08601__A0 net31 vssd1 vssd1 vccd1 vccd1 sky130_fd_sc_hd__diode_2
X_11377_ _01609_ cell0.SB0.route_sel\[42\] _01610_ cell0.SB0.route_sel\[45\] _06251_
+ vssd1 vssd1 vccd1 vccd1 _06252_ sky130_fd_sc_hd__a221o_1
X_10328_ net435 _05107_ net433 vssd1 vssd1 vccd1 vccd1 _05327_ sky130_fd_sc_hd__o21ai_1
X_14096_ clknet_leaf_77_clk _01068_ net713 vssd1 vssd1 vccd1 vccd1 cell3.SB0.route_sel\[104\]
+ sky130_fd_sc_hd__dfstp_1
XTAP_TAPCELL_ROW_59_1195 vssd1 vccd1 sky130_fd_sc_hd__tapvpwrvgnd_1
X_13116_ clknet_leaf_3_clk _00088_ net565 vssd1 vssd1 vccd1 vccd1 cell0.CB_0.config_dataA\[18\]
+ sky130_fd_sc_hd__dfstp_1
XFILLER_3_461 vccd1 vssd1 vccd1 vssd1 sky130_ef_sc_hd__decap_40_12
XFILLER_124_197 vssd1 vssd1 vccd1 vccd1 sky130_fd_sc_hd__fill_1
X_13047_ clknet_leaf_119_clk _00019_ net597 vssd1 vssd1 vccd1 vccd1 cell0.LE_1B.reset_mode
+ sky130_fd_sc_hd__dfrtp_1
X_10259_ _05258_ _05259_ cell2.CB_0.config_dataA\[17\] vssd1 vssd1 vccd1 vccd1 _05260_
+ sky130_fd_sc_hd__mux2_1
XTAP_TAPCELL_ROW_72_1395 vssd1 vccd1 sky130_fd_sc_hd__tapvpwrvgnd_1
XTAP_TAPCELL_ROW_72_1384 vssd1 vccd1 sky130_fd_sc_hd__tapvpwrvgnd_1
XFILLER_66_446 vssd1 vssd1 vccd1 vccd1 sky130_fd_sc_hd__fill_2
XANTENNA__06967__B _02032_ vssd1 vssd1 vccd1 vccd1 sky130_fd_sc_hd__diode_2
XANTENNA__08380__A2 _02494_ vssd1 vssd1 vccd1 vccd1 sky130_fd_sc_hd__diode_2
XANTENNA__12464__A1 cell2.LE_0A.config_data\[0\] vssd1 vssd1 vccd1 vccd1 sky130_fd_sc_hd__diode_2
XFILLER_19_373 vssd1 vssd1 vccd1 vccd1 sky130_fd_sc_hd__fill_1
X_13949_ clknet_leaf_34_clk _00921_ net638 vssd1 vssd1 vccd1 vccd1 cell2.LEI0.config_data\[6\]
+ sky130_fd_sc_hd__dfrtp_1
Xclkbuf_leaf_73_clk clknet_4_14_0_clk vssd1 vssd1 vccd1 vccd1 clknet_leaf_73_clk sky130_fd_sc_hd__clkbuf_8
XANTENNA__08132__A2 bus1_0\[14\] vssd1 vssd1 vccd1 vccd1 sky130_fd_sc_hd__diode_2
X_07470_ cell2.SB0.route_sel\[115\] cell2.SB0.route_sel\[114\] _02522_ vssd1 vssd1
+ vccd1 vccd1 _02523_ sky130_fd_sc_hd__a21oi_1
XTAP_TAPCELL_ROW_17_563 vssd1 vccd1 sky130_fd_sc_hd__tapvpwrvgnd_1
XANTENNA__06983__A net31 vssd1 vssd1 vccd1 vccd1 sky130_fd_sc_hd__diode_2
XFILLER_50_847 vssd1 vssd1 vccd1 vccd1 sky130_fd_sc_hd__fill_1
XANTENNA__07891__A1 _02456_ vssd1 vssd1 vccd1 vccd1 sky130_fd_sc_hd__diode_2
XANTENNA__07891__B2 _02388_ vssd1 vssd1 vccd1 vccd1 sky130_fd_sc_hd__diode_2
X_06421_ cell0.CB_1.config_dataB\[7\] vssd1 vssd1 vccd1 vccd1 _01491_ sky130_fd_sc_hd__inv_2
X_09140_ _04166_ _04169_ _04120_ vssd1 vssd1 vccd1 vccd1 _04170_ sky130_fd_sc_hd__mux2_1
X_09071_ _04098_ _04099_ _04100_ vssd1 vssd1 vccd1 vccd1 _04101_ sky130_fd_sc_hd__o21a_1
X_08022_ net533 _02526_ _03063_ net532 vssd1 vssd1 vccd1 vccd1 _03064_ sky130_fd_sc_hd__o211a_1
XANTENNA__08840__B1 _03871_ vssd1 vssd1 vccd1 vccd1 sky130_fd_sc_hd__diode_2
Xclkbuf_1_1__f_cell2.LE_0A.sel_clk clknet_0_cell2.LE_0A.sel_clk vssd1 vssd1 vccd1
+ vccd1 clknet_1_1__leaf_cell2.LE_0A.sel_clk sky130_fd_sc_hd__clkbuf_16
XANTENNA__08199__A2 _02211_ vssd1 vssd1 vccd1 vccd1 sky130_fd_sc_hd__diode_2
XFILLER_131_613 vssd1 vssd1 vccd1 vccd1 sky130_fd_sc_hd__fill_1
X_09973_ bus3_2\[12\] bus3_2\[14\] bus3_2\[13\] bus3_2\[15\] net405 net406 vssd1 vssd1
+ vccd1 vccd1 _04977_ sky130_fd_sc_hd__mux4_1
XANTENNA__07946__A2 _02894_ vssd1 vssd1 vccd1 vccd1 sky130_fd_sc_hd__diode_2
Xclkbuf_1_0__f_cell0.LE_0B.sel_clk clknet_0_cell0.LE_0B.sel_clk vssd1 vssd1 vccd1
+ vccd1 clknet_1_0__leaf_cell0.LE_0B.sel_clk sky130_fd_sc_hd__clkbuf_16
X_08924_ _03826_ _03940_ _03941_ _03830_ _01681_ vssd1 vssd1 vccd1 vccd1 _03956_ sky130_fd_sc_hd__a221o_1
XFILLER_39_39 vccd1 vssd1 vccd1 vssd1 sky130_ef_sc_hd__decap_40_12
XFILLER_130_156 vssd1 vssd1 vccd1 vccd1 sky130_fd_sc_hd__fill_1
XANTENNA__10702__A1 net13 vssd1 vssd1 vccd1 vccd1 sky130_fd_sc_hd__diode_2
X_08855_ _01517_ cell1.SB0.route_sel\[47\] vssd1 vssd1 vccd1 vccd1 _03887_ sky130_fd_sc_hd__nand2_1
XANTENNA__10702__B2 net14 vssd1 vssd1 vccd1 vccd1 sky130_fd_sc_hd__diode_2
XFILLER_45_619 vssd1 vssd1 vccd1 vccd1 sky130_fd_sc_hd__fill_1
X_08786_ cell1.SB0.route_sel\[125\] cell1.SB0.route_sel\[124\] vssd1 vssd1 vccd1 vccd1
+ _03818_ sky130_fd_sc_hd__and2b_1
XPHY_EDGE_ROW_2_Right_2 vssd1 vssd1 vccd1 vccd1 sky130_fd_sc_hd__decap_3
X_07806_ cell1.SB0.route_sel\[42\] cell1.SB0.route_sel\[43\] vssd1 vssd1 vccd1 vccd1
+ _02851_ sky130_fd_sc_hd__nand2_1
X_07737_ _01838_ _02046_ vssd1 vssd1 vccd1 vccd1 _02783_ sky130_fd_sc_hd__nor2_1
Xclkbuf_leaf_64_clk clknet_4_15_0_clk vssd1 vssd1 vccd1 vccd1 clknet_leaf_64_clk sky130_fd_sc_hd__clkbuf_8
XANTENNA_fanout736_A net742 vssd1 vssd1 vccd1 vccd1 sky130_fd_sc_hd__diode_2
XANTENNA_fanout357_X net357 vssd1 vssd1 vccd1 vccd1 sky130_fd_sc_hd__diode_2
XFILLER_111_55 vssd1 vssd1 vccd1 vccd1 sky130_fd_sc_hd__fill_1
XPHY_EDGE_ROW_9_Left_152 vssd1 vssd1 vccd1 vccd1 sky130_fd_sc_hd__decap_3
XANTENNA__08584__S _03546_ vssd1 vssd1 vccd1 vccd1 sky130_fd_sc_hd__diode_2
XANTENNA__06893__A net80 vssd1 vssd1 vccd1 vccd1 sky130_fd_sc_hd__diode_2
X_07668_ cell0.SB0.route_sel\[17\] cell0.SB0.route_sel\[16\] _02709_ _02715_ net782
+ vssd1 vssd1 vccd1 vccd1 _02716_ sky130_fd_sc_hd__a311oi_4
XTAP_TAPCELL_ROW_36_850 vssd1 vccd1 sky130_fd_sc_hd__tapvpwrvgnd_1
XTAP_TAPCELL_ROW_101_1823 vssd1 vccd1 sky130_fd_sc_hd__tapvpwrvgnd_1
X_09407_ net317 _04425_ _04427_ _04429_ vssd1 vssd1 vccd1 vccd1 _04430_ sky130_fd_sc_hd__o22a_1
X_06619_ cell3.SB0.route_sel\[12\] vssd1 vssd1 vccd1 vccd1 _01689_ sky130_fd_sc_hd__inv_2
XANTENNA_fanout903_A net907 vssd1 vssd1 vccd1 vccd1 sky130_fd_sc_hd__diode_2
X_07599_ cell1.CB_0.config_dataB\[23\] cell1.CB_0.config_dataB\[22\] vssd1 vssd1 vccd1
+ vccd1 _02649_ sky130_fd_sc_hd__nor2_1
X_09338_ cell3.CB_0.config_dataB\[24\] cell3.CB_0.config_dataB\[21\] cell3.CB_0.config_dataB\[20\]
+ vssd1 vssd1 vccd1 vccd1 _04363_ sky130_fd_sc_hd__and3b_1
XTAP_TAPCELL_ROW_134_2322 vssd1 vccd1 sky130_fd_sc_hd__tapvpwrvgnd_1
XTAP_TAPCELL_ROW_134_2311 vssd1 vccd1 sky130_fd_sc_hd__tapvpwrvgnd_1
X_11300_ net293 _06214_ _04357_ vssd1 vssd1 vccd1 vccd1 net144 sky130_fd_sc_hd__mux2_1
X_09269_ cell2.SB0.route_sel\[16\] cell2.SB0.route_sel\[17\] _04289_ _04294_ net816
+ vssd1 vssd1 vccd1 vccd1 _04295_ sky130_fd_sc_hd__a311oi_2
XFILLER_4_214 vssd1 vssd1 vccd1 vccd1 sky130_fd_sc_hd__fill_1
X_12280_ cell1.SB0.route_sel\[18\] cell1.SB0.route_sel\[17\] net865 vssd1 vssd1 vccd1
+ vccd1 _00713_ sky130_fd_sc_hd__mux2_1
X_11231_ cell3.LE_0B.config_data\[0\] cell3.LE_0B.config_data\[1\] _06076_ vssd1 vssd1
+ vccd1 vccd1 _06183_ sky130_fd_sc_hd__mux2_1
XFILLER_4_236 vccd1 vssd1 vccd1 vssd1 sky130_ef_sc_hd__decap_40_12
XFILLER_20_41 vccd1 vssd1 vccd1 vssd1 sky130_ef_sc_hd__decap_40_12
XFILLER_136_41 vccd1 vssd1 vccd1 vssd1 sky130_ef_sc_hd__decap_40_12
X_11162_ _05847_ _05851_ net385 vssd1 vssd1 vccd1 vccd1 _06114_ sky130_fd_sc_hd__mux2_1
XFILLER_20_63 vssd1 vssd1 vccd1 vccd1 sky130_fd_sc_hd__fill_1
XFILLER_136_85 vssd1 vssd1 vccd1 vccd1 sky130_fd_sc_hd__fill_8
X_10113_ net319 _05113_ vssd1 vssd1 vccd1 vccd1 _05114_ sky130_fd_sc_hd__nand2_1
XFILLER_136_96 vssd1 vssd1 vccd1 vccd1 sky130_fd_sc_hd__fill_1
X_11093_ net389 _05847_ _06044_ cell3.CB_0.config_dataB\[1\] vssd1 vssd1 vccd1 vccd1
+ _06045_ sky130_fd_sc_hd__o211a_1
XTAP_TAPCELL_ROW_112_1985 vssd1 vccd1 sky130_fd_sc_hd__tapvpwrvgnd_1
XFILLER_95_519 vssd1 vssd1 vccd1 vccd1 sky130_fd_sc_hd__fill_1
XANTENNA_input32_A CBeast_in[9] vssd1 vssd1 vccd1 vccd1 sky130_fd_sc_hd__diode_2
X_10044_ bus3_2\[6\] bus3_2\[7\] net401 vssd1 vssd1 vccd1 vccd1 _05048_ sky130_fd_sc_hd__mux2_1
Xhold50 _00494_ vssd1 vssd1 vccd1 vccd1 net1009 sky130_fd_sc_hd__dlygate4sd3_1
XANTENNA__11038__X _05992_ vssd1 vssd1 vccd1 vccd1 sky130_fd_sc_hd__diode_2
Xhold83 _00854_ vssd1 vssd1 vccd1 vccd1 net1042 sky130_fd_sc_hd__dlygate4sd3_1
Xhold61 cell1.LE_0B.config_data\[9\] vssd1 vssd1 vccd1 vccd1 net1020 sky130_fd_sc_hd__dlygate4sd3_1
XFILLER_76_755 vssd1 vssd1 vccd1 vccd1 sky130_fd_sc_hd__fill_1
Xhold72 cell1.LE_1A.config_data\[6\] vssd1 vssd1 vccd1 vccd1 net1031 sky130_fd_sc_hd__dlygate4sd3_1
Xhold94 cell2.LE_0B.config_data\[6\] vssd1 vssd1 vccd1 vccd1 net1053 sky130_fd_sc_hd__dlygate4sd3_1
X_13803_ clknet_leaf_112_clk _00775_ net656 vssd1 vssd1 vccd1 vccd1 cell1.SB0.route_sel\[80\]
+ sky130_fd_sc_hd__dfstp_1
XFILLER_29_671 vssd1 vssd1 vccd1 vccd1 sky130_fd_sc_hd__fill_1
Xclkbuf_leaf_55_clk clknet_4_13_0_clk vssd1 vssd1 vccd1 vccd1 clknet_leaf_55_clk sky130_fd_sc_hd__clkbuf_8
XFILLER_90_235 vssd1 vssd1 vccd1 vccd1 sky130_fd_sc_hd__fill_2
XFILLER_63_449 vssd1 vssd1 vccd1 vccd1 sky130_fd_sc_hd__fill_2
XFILLER_16_332 vssd1 vssd1 vccd1 vccd1 sky130_fd_sc_hd__fill_2
XFILLER_29_693 vssd1 vssd1 vccd1 vccd1 sky130_fd_sc_hd__fill_1
X_11995_ cell0.SB0.route_sel\[101\] cell0.SB0.route_sel\[100\] net767 vssd1 vssd1
+ vccd1 vccd1 _00432_ sky130_fd_sc_hd__mux2_1
X_10946_ _01699_ _01700_ _01701_ cell3.SB0.route_sel\[39\] _05899_ vssd1 vssd1 vccd1
+ vccd1 _05900_ sky130_fd_sc_hd__a221o_1
X_13734_ clknet_leaf_106_clk _00706_ net660 vssd1 vssd1 vccd1 vccd1 cell1.SB0.route_sel\[11\]
+ sky130_fd_sc_hd__dfstp_1
XFILLER_16_365 vssd1 vssd1 vccd1 vccd1 sky130_fd_sc_hd__fill_1
X_10877_ cell3.LE_1B.config_data\[0\] cell3.LE_1B.config_data\[1\] net292 vssd1 vssd1
+ vccd1 vccd1 _05833_ sky130_fd_sc_hd__mux2_1
X_13665_ clknet_leaf_46_clk _00637_ net630 vssd1 vssd1 vccd1 vccd1 cell2.CB_1.config_dataA\[17\]
+ sky130_fd_sc_hd__dfstp_2
XANTENNA__07873__A1 cell0.LEI0.config_data\[14\] vssd1 vssd1 vccd1 vccd1 sky130_fd_sc_hd__diode_2
XTAP_TAPCELL_ROW_14_511 vssd1 vccd1 sky130_fd_sc_hd__tapvpwrvgnd_1
XTAP_TAPCELL_ROW_14_522 vssd1 vccd1 sky130_fd_sc_hd__tapvpwrvgnd_1
XFILLER_31_335 vssd1 vssd1 vccd1 vccd1 sky130_fd_sc_hd__fill_1
X_12616_ cell3.SB0.route_sel\[81\] cell3.SB0.route_sel\[80\] net878 vssd1 vssd1 vccd1
+ vccd1 _01045_ sky130_fd_sc_hd__mux2_1
XANTENNA__09075__A0 bus3_1\[0\] vssd1 vssd1 vccd1 vccd1 sky130_fd_sc_hd__diode_2
X_13596_ clknet_leaf_88_clk _00568_ net688 vssd1 vssd1 vccd1 vccd1 cell1.LEI0.config_data\[17\]
+ sky130_fd_sc_hd__dfrtp_1
XFILLER_12_582 vssd1 vssd1 vccd1 vccd1 sky130_fd_sc_hd__fill_4
XANTENNA__10224__A3 net58 vssd1 vssd1 vccd1 vccd1 sky130_fd_sc_hd__diode_2
XANTENNA__11501__X net242 vssd1 vssd1 vccd1 vccd1 sky130_fd_sc_hd__diode_2
X_12547_ cell3.SB0.route_sel\[12\] cell3.SB0.route_sel\[11\] net936 vssd1 vssd1 vccd1
+ vccd1 _00976_ sky130_fd_sc_hd__mux2_1
XANTENNA__08822__B1 _03853_ vssd1 vssd1 vccd1 vccd1 sky130_fd_sc_hd__diode_2
X_12478_ net1029 cell2.LE_0A.config_data\[14\] net822 vssd1 vssd1 vccd1 vccd1 _00908_
+ sky130_fd_sc_hd__mux2_1
XANTENNA_3 _00250_ vssd1 vssd1 vccd1 vccd1 sky130_fd_sc_hd__diode_2
X_14217_ clknet_leaf_15_clk _01189_ net625 vssd1 vssd1 vccd1 vccd1 cell2.SB0.route_sel\[2\]
+ sky130_fd_sc_hd__dfstp_1
XTAP_TAPCELL_ROW_74_1413 vssd1 vccd1 sky130_fd_sc_hd__tapvpwrvgnd_1
X_11429_ _06286_ net266 vssd1 vssd1 vccd1 vccd1 net203 sky130_fd_sc_hd__and2b_1
XFILLER_6_65 vccd1 vssd1 vccd1 vssd1 sky130_ef_sc_hd__decap_40_12
X_14148_ clknet_leaf_68_clk _01120_ net736 vssd1 vssd1 vccd1 vccd1 cell3.CB_1.config_dataA\[8\]
+ sky130_fd_sc_hd__dfstp_1
XFILLER_98_313 vssd1 vssd1 vccd1 vccd1 sky130_fd_sc_hd__fill_1
XTAP_TAPCELL_ROW_74_1424 vssd1 vccd1 sky130_fd_sc_hd__tapvpwrvgnd_1
XANTENNA__07928__A2 bus2_0\[10\] vssd1 vssd1 vccd1 vccd1 sky130_fd_sc_hd__diode_2
XANTENNA__13148__RESET_B net751 vssd1 vssd1 vccd1 vccd1 sky130_fd_sc_hd__diode_2
XFILLER_4_781 vssd1 vssd1 vccd1 vccd1 sky130_fd_sc_hd__fill_2
XFILLER_100_307 vssd1 vssd1 vccd1 vccd1 sky130_fd_sc_hd__fill_1
X_14079_ clknet_leaf_82_clk _01051_ net701 vssd1 vssd1 vccd1 vccd1 cell3.SB0.route_sel\[87\]
+ sky130_fd_sc_hd__dfstp_1
X_06970_ cell0.SB0.route_sel\[64\] cell0.SB0.route_sel\[65\] _02029_ _02035_ vssd1
+ vssd1 vccd1 vccd1 _02036_ sky130_fd_sc_hd__o2bb2a_1
XFILLER_94_530 vssd1 vssd1 vccd1 vccd1 sky130_fd_sc_hd__fill_2
X_08640_ _03673_ vssd1 vssd1 vccd1 vccd1 _03674_ sky130_fd_sc_hd__inv_2
XFILLER_94_574 vssd1 vssd1 vccd1 vccd1 sky130_fd_sc_hd__fill_1
XFILLER_82_725 vssd1 vssd1 vccd1 vccd1 sky130_fd_sc_hd__fill_1
XFILLER_54_427 vssd1 vssd1 vccd1 vccd1 sky130_fd_sc_hd__fill_1
XFILLER_39_479 vssd1 vssd1 vccd1 vccd1 sky130_fd_sc_hd__fill_1
Xclkbuf_leaf_46_clk clknet_4_12_0_clk vssd1 vssd1 vccd1 vccd1 clknet_leaf_46_clk sky130_fd_sc_hd__clkbuf_8
XFILLER_26_129 vssd1 vssd1 vccd1 vccd1 sky130_fd_sc_hd__fill_2
X_08571_ _03605_ _03606_ _01665_ vssd1 vssd1 vccd1 vccd1 _03607_ sky130_fd_sc_hd__mux2_1
XFILLER_81_279 vssd1 vssd1 vccd1 vccd1 sky130_fd_sc_hd__fill_1
XFILLER_50_600 vssd1 vssd1 vccd1 vccd1 sky130_fd_sc_hd__fill_1
X_07522_ _01973_ _02367_ vssd1 vssd1 vccd1 vccd1 _02574_ sky130_fd_sc_hd__or2_1
XTAP_TAPCELL_ROW_85_1586 vssd1 vccd1 sky130_fd_sc_hd__tapvpwrvgnd_1
X_07453_ _02499_ _02500_ _02506_ vssd1 vssd1 vccd1 vccd1 _02507_ sky130_fd_sc_hd__o21ai_1
X_06404_ cell0.SB0.route_sel\[89\] vssd1 vssd1 vccd1 vccd1 _01474_ sky130_fd_sc_hd__inv_2
X_09123_ net477 _03844_ vssd1 vssd1 vccd1 vccd1 _04153_ sky130_fd_sc_hd__nand2_1
X_07384_ net325 _02439_ vssd1 vssd1 vccd1 vccd1 _02440_ sky130_fd_sc_hd__or2_1
XANTENNA_fanout317_A net318 vssd1 vssd1 vccd1 vccd1 sky130_fd_sc_hd__diode_2
XTAP_TAPCELL_ROW_116_2052 vssd1 vccd1 sky130_fd_sc_hd__tapvpwrvgnd_1
XTAP_TAPCELL_ROW_116_2041 vssd1 vccd1 sky130_fd_sc_hd__tapvpwrvgnd_1
X_09054_ cell1.LEI0.config_data\[5\] _04081_ _04083_ vssd1 vssd1 vccd1 vccd1 _04084_
+ sky130_fd_sc_hd__or3_1
XANTENNA__11411__X net200 vssd1 vssd1 vccd1 vccd1 sky130_fd_sc_hd__diode_2
Xhold520 cell3.LEI0.config_data\[36\] vssd1 vssd1 vccd1 vccd1 net1479 sky130_fd_sc_hd__dlygate4sd3_1
XANTENNA__09369__A1 net305 vssd1 vssd1 vccd1 vccd1 sky130_fd_sc_hd__diode_2
X_08005_ cell0.CB_0.config_dataB\[8\] cell0.CB_0.config_dataB\[7\] vssd1 vssd1 vccd1
+ vccd1 _03047_ sky130_fd_sc_hd__or2_1
XANTENNA__07919__A2 bus2_0\[2\] vssd1 vssd1 vccd1 vccd1 sky130_fd_sc_hd__diode_2
Xhold531 cell0.LEI0.config_data\[3\] vssd1 vssd1 vccd1 vccd1 net1490 sky130_fd_sc_hd__dlygate4sd3_1
Xhold553 cell0.LE_1B.reset_val vssd1 vssd1 vccd1 vccd1 net1512 sky130_fd_sc_hd__dlygate4sd3_1
Xhold542 cell1.LEI0.config_data\[9\] vssd1 vssd1 vccd1 vccd1 net1501 sky130_fd_sc_hd__dlygate4sd3_1
Xhold575 cell3.LE_0B.config_data\[0\] vssd1 vssd1 vccd1 vccd1 net1534 sky130_fd_sc_hd__dlygate4sd3_1
XFILLER_131_432 vssd1 vssd1 vccd1 vccd1 sky130_fd_sc_hd__fill_2
Xhold564 cell1.LEI0.config_data\[19\] vssd1 vssd1 vccd1 vccd1 net1523 sky130_fd_sc_hd__dlygate4sd3_1
Xhold586 cell0.LEI0.config_data\[12\] vssd1 vssd1 vccd1 vccd1 net1545 sky130_fd_sc_hd__dlygate4sd3_1
XFILLER_1_217 vssd1 vssd1 vccd1 vccd1 sky130_fd_sc_hd__fill_4
X_09956_ net406 _04348_ vssd1 vssd1 vccd1 vccd1 _04960_ sky130_fd_sc_hd__nand2_1
X_09887_ cell2.CB_1.config_dataA\[18\] cell2.CB_1.config_dataA\[17\] vssd1 vssd1 vccd1
+ vccd1 _04893_ sky130_fd_sc_hd__nor2_1
X_08907_ net467 _03885_ vssd1 vssd1 vccd1 vccd1 _03939_ sky130_fd_sc_hd__or2_1
XANTENNA_fanout853_A net854 vssd1 vssd1 vccd1 vccd1 sky130_fd_sc_hd__diode_2
X_08838_ cell1.SB0.route_sel\[10\] cell1.SB0.route_sel\[11\] cell1.SB0.route_sel\[14\]
+ _01504_ _03869_ vssd1 vssd1 vccd1 vccd1 _03870_ sky130_fd_sc_hd__o221a_1
XANTENNA__08344__A2 _02494_ vssd1 vssd1 vccd1 vccd1 sky130_fd_sc_hd__diode_2
XPHY_EDGE_ROW_142_Right_142 vssd1 vssd1 vccd1 vccd1 sky130_fd_sc_hd__decap_3
XFILLER_122_21 vssd1 vssd1 vccd1 vccd1 sky130_fd_sc_hd__fill_4
XFILLER_85_585 vssd1 vssd1 vccd1 vccd1 sky130_fd_sc_hd__fill_1
XANTENNA__11402__A_N _02132_ vssd1 vssd1 vccd1 vccd1 sky130_fd_sc_hd__diode_2
Xclkbuf_leaf_37_clk clknet_4_7_0_clk vssd1 vssd1 vccd1 vccd1 clknet_leaf_37_clk sky130_fd_sc_hd__clkbuf_8
XFILLER_72_235 vssd1 vssd1 vccd1 vccd1 sky130_fd_sc_hd__fill_1
X_08769_ _03802_ _03801_ _03702_ vssd1 vssd1 vccd1 vccd1 _03803_ sky130_fd_sc_hd__mux2_1
X_10800_ _05755_ vssd1 vssd1 vccd1 vccd1 _05756_ sky130_fd_sc_hd__inv_2
XANTENNA__09946__A1_N _04527_ vssd1 vssd1 vccd1 vccd1 sky130_fd_sc_hd__diode_2
XFILLER_82_25 vssd1 vssd1 vccd1 vccd1 sky130_fd_sc_hd__fill_2
X_11780_ net1399 net1328 net793 vssd1 vssd1 vccd1 vccd1 _00217_ sky130_fd_sc_hd__mux2_1
X_10731_ _01793_ cell3.LE_1A.dff_out vssd1 vssd1 vccd1 vccd1 _05688_ sky130_fd_sc_hd__or2_1
XTAP_TAPCELL_ROW_0_294 vssd1 vccd1 sky130_fd_sc_hd__tapvpwrvgnd_1
X_13450_ clknet_leaf_123_clk _00422_ net585 vssd1 vssd1 vccd1 vccd1 cell0.SB0.route_sel\[91\]
+ sky130_fd_sc_hd__dfstp_1
X_12401_ net402 net403 net833 vssd1 vssd1 vccd1 vccd1 _00834_ sky130_fd_sc_hd__mux2_1
X_10662_ net15 net16 cell3.CB_1.config_dataA\[10\] vssd1 vssd1 vccd1 vccd1 _05620_
+ sky130_fd_sc_hd__mux2_1
X_10593_ cell3.SB0.route_sel\[72\] _01723_ cell3.SB0.route_sel\[77\] cell3.SB0.route_sel\[76\]
+ vssd1 vssd1 vccd1 vccd1 _05551_ sky130_fd_sc_hd__o22a_1
X_13381_ clknet_leaf_132_clk _00353_ net559 vssd1 vssd1 vccd1 vccd1 cell0.SB0.route_sel\[22\]
+ sky130_fd_sc_hd__dfstp_1
XANTENNA__08280__B2 _02040_ vssd1 vssd1 vccd1 vccd1 sky130_fd_sc_hd__diode_2
X_12332_ cell1.SB0.route_sel\[70\] cell1.SB0.route_sel\[69\] net869 vssd1 vssd1 vccd1
+ vccd1 _00765_ sky130_fd_sc_hd__mux2_1
XFILLER_31_51 vssd1 vssd1 vccd1 vccd1 sky130_fd_sc_hd__fill_4
X_12263_ cell1.SB0.route_sel\[1\] cell1.SB0.route_sel\[0\] net866 vssd1 vssd1 vccd1
+ vccd1 _00696_ sky130_fd_sc_hd__mux2_1
X_11214_ _06165_ vssd1 vssd1 vccd1 vccd1 _06166_ sky130_fd_sc_hd__inv_2
X_14002_ clknet_leaf_76_clk _00974_ net725 vssd1 vssd1 vccd1 vccd1 cell3.SB0.route_sel\[10\]
+ sky130_fd_sc_hd__dfstp_1
X_12194_ cell2.CB_1.config_dataA\[7\] cell2.CB_1.config_dataA\[6\] net924 vssd1 vssd1
+ vccd1 vccd1 _00627_ sky130_fd_sc_hd__mux2_1
XTAP_TAPCELL_ROW_56_1154 vssd1 vccd1 sky130_fd_sc_hd__tapvpwrvgnd_1
XTAP_TAPCELL_ROW_56_1143 vssd1 vccd1 sky130_fd_sc_hd__tapvpwrvgnd_1
XANTENNA__08630__X _03666_ vssd1 vssd1 vccd1 vccd1 sky130_fd_sc_hd__diode_2
X_11145_ net386 _06095_ _06096_ vssd1 vssd1 vccd1 vccd1 _06097_ sky130_fd_sc_hd__a21oi_1
XANTENNA__09780__A1 net308 vssd1 vssd1 vccd1 vccd1 sky130_fd_sc_hd__diode_2
XANTENNA__09445__Y _04467_ vssd1 vssd1 vccd1 vccd1 sky130_fd_sc_hd__diode_2
XANTENNA_input35_X net35 vssd1 vssd1 vccd1 vccd1 sky130_fd_sc_hd__diode_2
X_11076_ cell3.LE_0A.config_data\[10\] cell3.LE_0A.config_data\[11\] _05930_ vssd1
+ vssd1 vccd1 vccd1 _06030_ sky130_fd_sc_hd__mux2_1
XFILLER_0_250 vssd1 vssd1 vccd1 vccd1 sky130_fd_sc_hd__fill_2
XFILLER_0_272 vssd1 vssd1 vccd1 vccd1 sky130_fd_sc_hd__fill_2
XFILLER_0_261 vssd1 vssd1 vccd1 vccd1 sky130_fd_sc_hd__fill_1
XANTENNA_clkbuf_leaf_94_clk_A clknet_4_11_0_clk vssd1 vssd1 vccd1 vccd1 sky130_fd_sc_hd__diode_2
X_10027_ cell2.LE_1B.config_data\[4\] cell2.LE_1B.config_data\[5\] _04956_ vssd1 vssd1
+ vccd1 vccd1 _05031_ sky130_fd_sc_hd__mux2_1
XANTENNA_output236_A net236 vssd1 vssd1 vccd1 vccd1 sky130_fd_sc_hd__diode_2
XFILLER_76_530 vssd1 vssd1 vccd1 vccd1 sky130_fd_sc_hd__fill_2
XANTENNA__10113__A net319 vssd1 vssd1 vccd1 vccd1 sky130_fd_sc_hd__diode_2
XANTENNA__07543__B1 _02592_ vssd1 vssd1 vccd1 vccd1 sky130_fd_sc_hd__diode_2
XFILLER_64_703 vssd1 vssd1 vccd1 vccd1 sky130_fd_sc_hd__fill_1
Xclkbuf_leaf_28_clk clknet_4_5_0_clk vssd1 vssd1 vccd1 vccd1 clknet_leaf_28_clk sky130_fd_sc_hd__clkbuf_8
XFILLER_63_246 vssd1 vssd1 vccd1 vccd1 sky130_fd_sc_hd__fill_1
XFILLER_56_81 vssd1 vssd1 vccd1 vccd1 sky130_fd_sc_hd__fill_1
XANTENNA__08099__A1 _02388_ vssd1 vssd1 vccd1 vccd1 sky130_fd_sc_hd__diode_2
XANTENNA__08077__X _03119_ vssd1 vssd1 vccd1 vccd1 sky130_fd_sc_hd__diode_2
XANTENNA__08099__B2 _02456_ vssd1 vssd1 vccd1 vccd1 sky130_fd_sc_hd__diode_2
XFILLER_17_663 vssd1 vssd1 vccd1 vccd1 sky130_fd_sc_hd__fill_2
X_11978_ cell0.SB0.route_sel\[84\] cell0.SB0.route_sel\[83\] net784 vssd1 vssd1 vccd1
+ vccd1 _00415_ sky130_fd_sc_hd__mux2_1
X_13717_ clknet_leaf_29_clk _00689_ net618 vssd1 vssd1 vccd1 vccd1 cell2.CB_0.config_dataA\[19\]
+ sky130_fd_sc_hd__dfstp_1
XANTENNA__09835__A2 bus3_2\[13\] vssd1 vssd1 vccd1 vccd1 sky130_fd_sc_hd__diode_2
X_10929_ _04563_ _04569_ _04575_ _05882_ vssd1 vssd1 vccd1 vccd1 _05883_ sky130_fd_sc_hd__o211a_2
XANTENNA__10850__A0 net19 vssd1 vssd1 vccd1 vccd1 sky130_fd_sc_hd__diode_2
XANTENNA_clkbuf_leaf_32_clk_A clknet_4_5_0_clk vssd1 vssd1 vccd1 vccd1 sky130_fd_sc_hd__diode_2
X_13648_ clknet_leaf_43_clk _00620_ net635 vssd1 vssd1 vccd1 vccd1 cell2.CB_1.config_dataA\[0\]
+ sky130_fd_sc_hd__dfstp_1
XFILLER_75_3 vssd1 vssd1 vccd1 vccd1 sky130_fd_sc_hd__fill_1
X_13579_ clknet_leaf_89_clk _00551_ net697 vssd1 vssd1 vccd1 vccd1 cell1.LEI0.config_data\[0\]
+ sky130_fd_sc_hd__dfrtp_1
XANTENNA__09063__A3 bus3_1\[15\] vssd1 vssd1 vccd1 vccd1 sky130_fd_sc_hd__diode_2
XANTENNA_clkbuf_leaf_47_clk_A clknet_4_12_0_clk vssd1 vssd1 vccd1 vccd1 sky130_fd_sc_hd__diode_2
XPHY_EDGE_ROW_99_Right_99 vssd1 vssd1 vccd1 vccd1 sky130_fd_sc_hd__decap_3
XANTENNA__08023__A1 _02388_ vssd1 vssd1 vccd1 vccd1 sky130_fd_sc_hd__diode_2
XANTENNA__08023__B2 _02456_ vssd1 vssd1 vccd1 vccd1 sky130_fd_sc_hd__diode_2
XFILLER_141_763 vccd1 vssd1 vccd1 vssd1 sky130_ef_sc_hd__decap_40_12
Xfanout318 cell2.CB_1.le_outA vssd1 vssd1 vccd1 vccd1 net318 sky130_fd_sc_hd__buf_4
Xfanout307 net308 vssd1 vssd1 vccd1 vccd1 net307 sky130_fd_sc_hd__clkbuf_2
X_09810_ bus3_2\[5\] _04792_ _04793_ bus3_2\[4\] cell2.CB_1.config_dataA\[3\] vssd1
+ vssd1 vccd1 vccd1 _04816_ sky130_fd_sc_hd__a221o_1
XANTENNA__09771__A1 bus3_2\[2\] vssd1 vssd1 vccd1 vccd1 sky130_fd_sc_hd__diode_2
XANTENNA__11818__S net905 vssd1 vssd1 vccd1 vccd1 sky130_fd_sc_hd__diode_2
Xfanout329 cell1.CB_0.le_outA vssd1 vssd1 vccd1 vccd1 net329 sky130_fd_sc_hd__clkbuf_2
XFILLER_141_785 vccd1 vssd1 vccd1 vssd1 sky130_ef_sc_hd__decap_40_12
X_09741_ _01594_ cell2.SB0.route_sel\[26\] cell2.SB0.route_sel\[31\] cell2.SB0.route_sel\[30\]
+ _04749_ vssd1 vssd1 vccd1 vccd1 _04750_ sky130_fd_sc_hd__o221a_1
X_06953_ net358 net357 bus1_0\[8\] vssd1 vssd1 vccd1 vccd1 _02019_ sky130_fd_sc_hd__o21ai_1
XANTENNA_clkbuf_leaf_105_clk_A clknet_4_8_0_clk vssd1 vssd1 vccd1 vccd1 sky130_fd_sc_hd__diode_2
X_09672_ net552 _04686_ vssd1 vssd1 vccd1 vccd1 _04687_ sky130_fd_sc_hd__nand2_1
XTAP_TAPCELL_ROW_87_1615 vssd1 vccd1 sky130_fd_sc_hd__tapvpwrvgnd_1
XANTENNA__08877__A3 bus3_1\[11\] vssd1 vssd1 vccd1 vccd1 sky130_fd_sc_hd__diode_2
X_06884_ cell0.SB0.route_sel\[56\] cell0.SB0.route_sel\[57\] _01951_ vssd1 vssd1 vccd1
+ vccd1 _01952_ sky130_fd_sc_hd__a21oi_1
Xclkbuf_leaf_19_clk clknet_4_4_0_clk vssd1 vssd1 vccd1 vccd1 clknet_leaf_19_clk sky130_fd_sc_hd__clkbuf_8
X_08623_ cell1.LE_1A.config_data\[5\] cell1.LE_1A.config_data\[4\] _03546_ vssd1 vssd1
+ vccd1 vccd1 _03659_ sky130_fd_sc_hd__mux2_1
XFILLER_36_29 vccd1 vssd1 vccd1 vssd1 sky130_ef_sc_hd__decap_40_12
XANTENNA__07603__Y _02653_ vssd1 vssd1 vccd1 vccd1 sky130_fd_sc_hd__diode_2
X_08554_ cell1.CB_1.config_dataA\[13\] cell1.CB_1.config_dataA\[12\] vssd1 vssd1 vccd1
+ vccd1 _03590_ sky130_fd_sc_hd__nor2_1
X_07505_ cell0.SB0.route_sel\[120\] cell0.SB0.route_sel\[121\] _02549_ _02556_ net791
+ vssd1 vssd1 vccd1 vccd1 _02557_ sky130_fd_sc_hd__a311o_4
XFILLER_23_622 vssd1 vssd1 vccd1 vccd1 sky130_fd_sc_hd__fill_1
X_08485_ net1 net12 net23 net26 net498 net496 vssd1 vssd1 vccd1 vccd1 _03521_ sky130_fd_sc_hd__mux4_1
XFILLER_23_644 vssd1 vssd1 vccd1 vccd1 sky130_fd_sc_hd__fill_1
XPHY_EDGE_ROW_99_Left_242 vssd1 vssd1 vccd1 vccd1 sky130_fd_sc_hd__decap_3
X_07436_ cell0.SB0.route_sel\[112\] cell0.SB0.route_sel\[113\] _02489_ vssd1 vssd1
+ vccd1 vccd1 _02490_ sky130_fd_sc_hd__a21oi_1
XANTENNA_fanout601_A net602 vssd1 vssd1 vccd1 vccd1 sky130_fd_sc_hd__diode_2
X_07367_ cell0.SB0.route_sel\[111\] cell0.SB0.route_sel\[110\] vssd1 vssd1 vccd1 vccd1
+ _02423_ sky130_fd_sc_hd__nand2b_1
XFILLER_109_727 vssd1 vssd1 vccd1 vccd1 sky130_fd_sc_hd__fill_1
X_09106_ bus3_1\[6\] bus3_1\[7\] net477 vssd1 vssd1 vccd1 vccd1 _04136_ sky130_fd_sc_hd__mux2_1
XFILLER_108_259 vssd1 vssd1 vccd1 vccd1 sky130_fd_sc_hd__fill_1
XTAP_TAPCELL_ROW_98_1777 vssd1 vccd1 sky130_fd_sc_hd__tapvpwrvgnd_1
X_09037_ net485 _03820_ vssd1 vssd1 vccd1 vccd1 _04067_ sky130_fd_sc_hd__nand2_1
XANTENNA__08801__A3 bus3_1\[15\] vssd1 vssd1 vccd1 vccd1 sky130_fd_sc_hd__diode_2
X_07298_ net449 net450 vssd1 vssd1 vccd1 vccd1 _02356_ sky130_fd_sc_hd__nand2_1
XANTENNA__11149__A1 _05916_ vssd1 vssd1 vccd1 vccd1 sky130_fd_sc_hd__diode_2
Xhold361 cell3.LE_0A.config_data\[15\] vssd1 vssd1 vccd1 vccd1 net1320 sky130_fd_sc_hd__dlygate4sd3_1
Xhold350 cell2.LE_0B.config_data\[11\] vssd1 vssd1 vccd1 vccd1 net1309 sky130_fd_sc_hd__dlygate4sd3_1
XANTENNA__08450__X _03486_ vssd1 vssd1 vccd1 vccd1 sky130_fd_sc_hd__diode_2
Xhold372 _01364_ vssd1 vssd1 vccd1 vccd1 net1331 sky130_fd_sc_hd__dlygate4sd3_1
Xhold383 _00938_ vssd1 vssd1 vccd1 vccd1 net1342 sky130_fd_sc_hd__dlygate4sd3_1
Xhold394 cell2.LEI0.config_data\[25\] vssd1 vssd1 vccd1 vccd1 net1353 sky130_fd_sc_hd__dlygate4sd3_1
Xfanout841 net845 vssd1 vssd1 vccd1 vccd1 net841 sky130_fd_sc_hd__clkbuf_4
Xfanout852 net854 vssd1 vssd1 vccd1 vccd1 net852 sky130_fd_sc_hd__clkbuf_4
Xfanout830 net831 vssd1 vssd1 vccd1 vccd1 net830 sky130_fd_sc_hd__clkbuf_4
XANTENNA__07066__X _02130_ vssd1 vssd1 vccd1 vccd1 sky130_fd_sc_hd__diode_2
XANTENNA__07773__B1 _02815_ vssd1 vssd1 vccd1 vccd1 sky130_fd_sc_hd__diode_2
XTAP_TAPCELL_ROW_129_2243 vssd1 vccd1 sky130_fd_sc_hd__tapvpwrvgnd_1
Xclkbuf_4_13_0_clk clknet_0_clk vssd1 vssd1 vccd1 vccd1 clknet_4_13_0_clk sky130_fd_sc_hd__clkbuf_8
X_09939_ bus3_2\[8\] bus3_2\[9\] bus3_2\[10\] bus3_2\[11\] net410 cell2.CB_1.config_dataB\[1\]
+ vssd1 vssd1 vccd1 vccd1 _04943_ sky130_fd_sc_hd__mux4_1
Xfanout874 net875 vssd1 vssd1 vccd1 vccd1 net874 sky130_fd_sc_hd__clkbuf_4
Xfanout885 net886 vssd1 vssd1 vccd1 vccd1 net885 sky130_fd_sc_hd__clkbuf_4
Xfanout863 net884 vssd1 vssd1 vccd1 vccd1 net863 sky130_fd_sc_hd__clkbuf_2
X_12950_ net1333 net1132 net950 vssd1 vssd1 vccd1 vccd1 _01378_ sky130_fd_sc_hd__mux2_1
Xfanout896 net897 vssd1 vssd1 vccd1 vccd1 net896 sky130_fd_sc_hd__buf_2
XTAP_TAPCELL_ROW_51_1073 vssd1 vccd1 sky130_fd_sc_hd__tapvpwrvgnd_1
XTAP_TAPCELL_ROW_5_386 vssd1 vccd1 sky130_fd_sc_hd__tapvpwrvgnd_1
XTAP_TAPCELL_ROW_142_2454 vssd1 vccd1 sky130_fd_sc_hd__tapvpwrvgnd_1
XTAP_TAPCELL_ROW_142_2443 vssd1 vccd1 sky130_fd_sc_hd__tapvpwrvgnd_1
XTAP_TAPCELL_ROW_142_2432 vssd1 vccd1 sky130_fd_sc_hd__tapvpwrvgnd_1
X_12881_ cell2.SB0.route_sel\[123\] cell2.SB0.route_sel\[122\] net832 vssd1 vssd1
+ vccd1 vccd1 _01310_ sky130_fd_sc_hd__mux2_1
XFILLER_93_57 vccd1 vssd1 vccd1 vssd1 sky130_ef_sc_hd__decap_40_12
XFILLER_85_393 vssd1 vssd1 vccd1 vccd1 sky130_fd_sc_hd__fill_4
X_11901_ cell0.SB0.route_sel\[7\] cell0.SB0.route_sel\[6\] net781 vssd1 vssd1 vccd1
+ vccd1 _00338_ sky130_fd_sc_hd__mux2_1
XANTENNA__11316__X net152 vssd1 vssd1 vccd1 vccd1 sky130_fd_sc_hd__diode_2
X_11832_ cell1.CB_1.config_dataA\[13\] cell1.CB_1.config_dataA\[12\] net886 vssd1
+ vssd1 vccd1 vccd1 _00269_ sky130_fd_sc_hd__mux2_1
XANTENNA__10942__A_N cell3.SB0.route_sel\[45\] vssd1 vssd1 vccd1 vccd1 sky130_fd_sc_hd__diode_2
XFILLER_14_622 vssd1 vssd1 vccd1 vccd1 sky130_fd_sc_hd__fill_2
Xclkbuf_0_cell3.LE_0A.sel_clk cell3.LE_0A.sel_clk vssd1 vssd1 vccd1 vccd1 clknet_0_cell3.LE_0A.sel_clk
+ sky130_fd_sc_hd__clkbuf_16
X_11763_ net1435 cell0.LEI0.config_data\[12\] net775 vssd1 vssd1 vccd1 vccd1 _00200_
+ sky130_fd_sc_hd__mux2_1
XFILLER_14_655 vssd1 vssd1 vccd1 vccd1 sky130_fd_sc_hd__fill_4
X_10714_ cell3.LEI0.config_data\[44\] _05671_ vssd1 vssd1 vccd1 vccd1 _05672_ sky130_fd_sc_hd__nand2b_1
X_14482_ clknet_leaf_67_clk net1409 net737 vssd1 vssd1 vccd1 vccd1 cell3.CB_0.config_data_inA
+ sky130_fd_sc_hd__dfrtp_1
X_11694_ net1122 cell0.LE_1A.config_data\[12\] net873 vssd1 vssd1 vccd1 vccd1 _00134_
+ sky130_fd_sc_hd__mux2_1
XFILLER_14_699 vssd1 vssd1 vccd1 vccd1 sky130_fd_sc_hd__fill_1
XTAP_TAPCELL_ROW_24_661 vssd1 vccd1 sky130_fd_sc_hd__tapvpwrvgnd_1
XTAP_TAPCELL_ROW_24_672 vssd1 vccd1 sky130_fd_sc_hd__tapvpwrvgnd_1
X_13502_ clknet_leaf_97_clk _00474_ net684 vssd1 vssd1 vccd1 vccd1 cell1.CB_1.config_dataB\[15\]
+ sky130_fd_sc_hd__dfstp_1
X_10645_ cell3.CB_1.config_dataA\[10\] cell3.CB_1.config_dataA\[11\] vssd1 vssd1 vccd1
+ vccd1 _05603_ sky130_fd_sc_hd__nor2_1
X_13433_ clknet_leaf_131_clk _00405_ net562 vssd1 vssd1 vccd1 vccd1 cell0.SB0.route_sel\[74\]
+ sky130_fd_sc_hd__dfstp_1
XFILLER_42_83 vssd1 vssd1 vccd1 vccd1 sky130_fd_sc_hd__fill_1
X_13364_ clknet_leaf_127_clk _00336_ net576 vssd1 vssd1 vccd1 vccd1 cell0.SB0.route_sel\[5\]
+ sky130_fd_sc_hd__dfstp_1
XANTENNA_output186_A net186 vssd1 vssd1 vccd1 vccd1 sky130_fd_sc_hd__diode_2
XANTENNA__10060__A1 net305 vssd1 vssd1 vccd1 vccd1 sky130_fd_sc_hd__diode_2
X_10576_ net17 net18 net19 net20 cell3.CB_1.config_dataA\[5\] cell3.CB_1.config_dataA\[6\]
+ vssd1 vssd1 vccd1 vccd1 _05534_ sky130_fd_sc_hd__mux4_1
X_12315_ cell1.SB0.route_sel\[53\] cell1.SB0.route_sel\[52\] net858 vssd1 vssd1 vccd1
+ vccd1 _00748_ sky130_fd_sc_hd__mux2_1
XANTENNA__10890__X cell3.CB_1.le_outB vssd1 vssd1 vccd1 vccd1 sky130_fd_sc_hd__diode_2
X_13295_ clknet_leaf_101_clk _00267_ net677 vssd1 vssd1 vccd1 vccd1 cell1.CB_1.config_dataA\[11\]
+ sky130_fd_sc_hd__dfstp_1
X_12246_ cell2.CB_0.config_dataA\[9\] cell2.CB_0.config_dataA\[8\] net822 vssd1 vssd1
+ vccd1 vccd1 _00679_ sky130_fd_sc_hd__mux2_1
XFILLER_5_397 vssd1 vssd1 vccd1 vccd1 sky130_fd_sc_hd__fill_1
X_12177_ net1171 net1230 net852 vssd1 vssd1 vccd1 vccd1 _00610_ sky130_fd_sc_hd__mux2_1
X_11128_ net386 net387 vssd1 vssd1 vccd1 vccd1 _06080_ sky130_fd_sc_hd__and2b_1
XFILLER_122_262 vssd1 vssd1 vccd1 vccd1 sky130_fd_sc_hd__fill_1
XFILLER_95_113 vssd1 vssd1 vccd1 vccd1 sky130_fd_sc_hd__fill_4
XFILLER_69_839 vssd1 vssd1 vccd1 vccd1 sky130_fd_sc_hd__fill_1
XFILLER_3_55 vssd1 vssd1 vccd1 vccd1 sky130_fd_sc_hd__fill_1
X_11059_ net40 net41 net42 net43 cell3.CB_0.config_dataA\[15\] net372 vssd1 vssd1
+ vccd1 vccd1 _06013_ sky130_fd_sc_hd__mux4_1
XANTENNA__10115__A2 _05111_ vssd1 vssd1 vccd1 vccd1 sky130_fd_sc_hd__diode_2
XFILLER_64_500 vssd1 vssd1 vccd1 vccd1 sky130_fd_sc_hd__fill_1
XANTENNA__09632__A net21 vssd1 vssd1 vccd1 vccd1 sky130_fd_sc_hd__diode_2
XTAP_TAPCELL_ROW_69_1345 vssd1 vccd1 sky130_fd_sc_hd__tapvpwrvgnd_1
XFILLER_91_341 vssd1 vssd1 vccd1 vccd1 sky130_fd_sc_hd__fill_2
XANTENNA__06975__B _02037_ vssd1 vssd1 vccd1 vccd1 sky130_fd_sc_hd__diode_2
XFILLER_24_419 vssd1 vssd1 vccd1 vccd1 sky130_fd_sc_hd__fill_1
XFILLER_83_90 vssd1 vssd1 vccd1 vccd1 sky130_fd_sc_hd__fill_1
XTAP_TAPCELL_ROW_82_1545 vssd1 vccd1 sky130_fd_sc_hd__tapvpwrvgnd_1
XTAP_TAPCELL_ROW_82_1534 vssd1 vccd1 sky130_fd_sc_hd__tapvpwrvgnd_1
XFILLER_17_493 vssd1 vssd1 vccd1 vccd1 sky130_fd_sc_hd__fill_8
X_08270_ _03309_ _03306_ _03263_ vssd1 vssd1 vccd1 vccd1 _03310_ sky130_fd_sc_hd__mux2_1
X_07221_ _02257_ _02278_ _02280_ vssd1 vssd1 vccd1 vccd1 _02281_ sky130_fd_sc_hd__a21o_1
X_07152_ cell1.SB0.route_sel\[86\] cell1.SB0.route_sel\[87\] _02193_ _02213_ vssd1
+ vssd1 vccd1 vccd1 _02214_ sky130_fd_sc_hd__a211o_1
XTAP_TAPCELL_ROW_113_2000 vssd1 vccd1 sky130_fd_sc_hd__tapvpwrvgnd_1
XANTENNA__12932__S net756 vssd1 vssd1 vccd1 vccd1 sky130_fd_sc_hd__diode_2
Xclkbuf_leaf_8_clk clknet_4_1_0_clk vssd1 vssd1 vccd1 vccd1 clknet_leaf_8_clk sky130_fd_sc_hd__clkbuf_8
X_07083_ _02051_ _02146_ vssd1 vssd1 vccd1 vccd1 _02147_ sky130_fd_sc_hd__nor2_1
XANTENNA__10354__A2 _05148_ vssd1 vssd1 vccd1 vccd1 sky130_fd_sc_hd__diode_2
XTAP_TAPCELL_ROW_93_1696 vssd1 vccd1 sky130_fd_sc_hd__tapvpwrvgnd_1
XFILLER_87_669 vssd1 vssd1 vccd1 vccd1 sky130_fd_sc_hd__fill_2
X_07985_ net530 _02585_ vssd1 vssd1 vccd1 vccd1 _03027_ sky130_fd_sc_hd__nand2_1
X_06936_ cell2.CB_0.config_dataA\[24\] cell2.CB_0.config_dataA\[20\] cell2.CB_0.config_dataA\[21\]
+ vssd1 vssd1 vccd1 vccd1 _02003_ sky130_fd_sc_hd__nand3b_2
X_09724_ _04736_ net281 _04735_ vssd1 vssd1 vccd1 vccd1 _04737_ sky130_fd_sc_hd__mux2_1
XFILLER_74_319 vssd1 vssd1 vccd1 vccd1 sky130_fd_sc_hd__fill_4
XFILLER_103_23 vssd1 vssd1 vccd1 vccd1 sky130_fd_sc_hd__fill_2
X_09655_ cell2.SB0.route_sel\[104\] _01641_ cell2.SB0.route_sel\[109\] cell2.SB0.route_sel\[108\]
+ _04669_ vssd1 vssd1 vccd1 vccd1 _04670_ sky130_fd_sc_hd__o221a_1
XFILLER_67_393 vssd1 vssd1 vccd1 vccd1 sky130_fd_sc_hd__fill_4
XTAP_TAPCELL_ROW_2_345 vssd1 vccd1 sky130_fd_sc_hd__tapvpwrvgnd_1
XTAP_TAPCELL_ROW_2_334 vssd1 vccd1 sky130_fd_sc_hd__tapvpwrvgnd_1
X_06867_ net348 _01848_ _01931_ vssd1 vssd1 vccd1 vccd1 _01935_ sky130_fd_sc_hd__and3_1
XANTENNA_fanout649_A net650 vssd1 vssd1 vccd1 vccd1 sky130_fd_sc_hd__diode_2
XTAP_TAPCELL_ROW_124_2162 vssd1 vccd1 sky130_fd_sc_hd__tapvpwrvgnd_1
XANTENNA__07333__Y _02390_ vssd1 vssd1 vccd1 vccd1 sky130_fd_sc_hd__diode_2
XANTENNA_fanout551_A _01495_ vssd1 vssd1 vccd1 vccd1 sky130_fd_sc_hd__diode_2
XANTENNA__08180__A0 bus1_0\[8\] vssd1 vssd1 vccd1 vccd1 sky130_fd_sc_hd__diode_2
X_08606_ net489 net487 _03498_ _03641_ cell1.CB_1.config_dataA\[17\] vssd1 vssd1 vccd1
+ vccd1 _03642_ sky130_fd_sc_hd__o311a_1
XTAP_TAPCELL_ROW_124_2173 vssd1 vccd1 sky130_fd_sc_hd__tapvpwrvgnd_1
X_09586_ _01729_ cell3.SB0.route_sel\[82\] cell3.SB0.route_sel\[87\] cell3.SB0.route_sel\[86\]
+ _04603_ vssd1 vssd1 vccd1 vccd1 _04604_ sky130_fd_sc_hd__o221a_1
XFILLER_70_514 vssd1 vssd1 vccd1 vccd1 sky130_fd_sc_hd__fill_2
XANTENNA__07062__A _02032_ vssd1 vssd1 vccd1 vccd1 sky130_fd_sc_hd__diode_2
X_06798_ cell0.CB_0.config_dataB\[23\] cell0.CB_0.config_dataB\[22\] vssd1 vssd1 vccd1
+ vccd1 _01868_ sky130_fd_sc_hd__nand2b_1
XANTENNA__10409__A3 net58 vssd1 vssd1 vccd1 vccd1 sky130_fd_sc_hd__diode_2
X_08537_ _03477_ _03549_ _03550_ _03473_ cell1.CB_1.config_dataA\[7\] vssd1 vssd1
+ vccd1 vccd1 _03573_ sky130_fd_sc_hd__a221o_1
XANTENNA__10814__A0 net8 vssd1 vssd1 vccd1 vccd1 sky130_fd_sc_hd__diode_2
XFILLER_51_783 vssd1 vssd1 vccd1 vccd1 sky130_fd_sc_hd__fill_1
XTAP_TAPCELL_ROW_41_929 vssd1 vccd1 sky130_fd_sc_hd__tapvpwrvgnd_1
XTAP_TAPCELL_ROW_41_918 vssd1 vccd1 sky130_fd_sc_hd__tapvpwrvgnd_1
X_08468_ _02738_ _03503_ vssd1 vssd1 vccd1 vccd1 _03504_ sky130_fd_sc_hd__or2_4
XANTENNA__10290__A1 net62 vssd1 vssd1 vccd1 vccd1 sky130_fd_sc_hd__diode_2
XTAP_TAPCELL_ROW_21_620 vssd1 vccd1 sky130_fd_sc_hd__tapvpwrvgnd_1
X_07419_ _02472_ vssd1 vssd1 vccd1 vccd1 _02473_ sky130_fd_sc_hd__inv_2
X_10430_ cell3.SB0.route_sel\[8\] cell3.SB0.route_sel\[9\] vssd1 vssd1 vccd1 vccd1
+ _05427_ sky130_fd_sc_hd__nor2_1
XANTENNA__09027__A3 bus3_1\[3\] vssd1 vssd1 vccd1 vccd1 sky130_fd_sc_hd__diode_2
XFILLER_7_629 vccd1 vssd1 vccd1 vssd1 sky130_ef_sc_hd__decap_40_12
X_08399_ cell0.CB_1.config_dataB\[18\] cell0.CB_1.config_dataB\[17\] vssd1 vssd1 vccd1
+ vccd1 _03437_ sky130_fd_sc_hd__nor2_1
XFILLER_6_139 vssd1 vssd1 vccd1 vccd1 sky130_fd_sc_hd__fill_1
XFILLER_12_53 vccd1 vssd1 vccd1 vssd1 sky130_ef_sc_hd__decap_40_12
XFILLER_136_354 vssd1 vssd1 vccd1 vccd1 sky130_fd_sc_hd__fill_1
X_10361_ net33 net44 net55 net58 net428 net426 vssd1 vssd1 vccd1 vccd1 _05360_ sky130_fd_sc_hd__mux4_1
XFILLER_128_53 vccd1 vssd1 vccd1 vssd1 sky130_ef_sc_hd__decap_40_12
XANTENNA__09983__A1 cell2.CB_0.le_outB vssd1 vssd1 vccd1 vccd1 sky130_fd_sc_hd__diode_2
XANTENNA__07994__A0 bus2_0\[12\] vssd1 vssd1 vccd1 vccd1 sky130_fd_sc_hd__diode_2
X_10292_ net59 _05280_ _05282_ net60 cell2.CB_0.config_dataB\[8\] vssd1 vssd1 vccd1
+ vccd1 _05291_ sky130_fd_sc_hd__a221o_1
X_13080_ clknet_leaf_6_clk _00052_ net568 vssd1 vssd1 vccd1 vccd1 cell0.CB_0.config_dataB\[7\]
+ sky130_fd_sc_hd__dfstp_1
X_12100_ net1387 cell1.LE_0A.config_data\[4\] net877 vssd1 vssd1 vccd1 vccd1 _00534_
+ sky130_fd_sc_hd__mux2_1
XFILLER_2_301 vssd1 vssd1 vccd1 vccd1 sky130_fd_sc_hd__fill_4
Xhold180 _00886_ vssd1 vssd1 vccd1 vccd1 net1139 sky130_fd_sc_hd__dlygate4sd3_1
XTAP_TAPCELL_ROW_53_1102 vssd1 vccd1 sky130_fd_sc_hd__tapvpwrvgnd_1
XFILLER_5_3 vccd1 vssd1 vccd1 vssd1 sky130_ef_sc_hd__decap_40_12
XFILLER_2_345 vccd1 vssd1 vccd1 vssd1 sky130_ef_sc_hd__decap_40_12
XANTENNA__07508__Y _02560_ vssd1 vssd1 vccd1 vccd1 sky130_fd_sc_hd__diode_2
X_12031_ cell1.CB_1.config_dataB\[9\] cell1.CB_1.config_dataB\[8\] net901 vssd1 vssd1
+ vccd1 vccd1 _00468_ sky130_fd_sc_hd__mux2_1
Xhold191 cell3.LE_0A.config_data\[11\] vssd1 vssd1 vccd1 vccd1 net1150 sky130_fd_sc_hd__dlygate4sd3_1
XFILLER_2_389 vccd1 vssd1 vccd1 vssd1 sky130_ef_sc_hd__decap_40_12
XANTENNA__07746__B1 bus1_0\[4\] vssd1 vssd1 vccd1 vccd1 sky130_fd_sc_hd__diode_2
Xfanout660 net664 vssd1 vssd1 vccd1 vccd1 net660 sky130_fd_sc_hd__clkbuf_4
X_13982_ clknet_leaf_42_clk _00954_ net634 vssd1 vssd1 vccd1 vccd1 cell2.LEI0.config_data\[39\]
+ sky130_fd_sc_hd__dfrtp_1
Xfanout671 net672 vssd1 vssd1 vccd1 vccd1 net671 sky130_fd_sc_hd__clkbuf_4
Xfanout693 net695 vssd1 vssd1 vccd1 vccd1 net693 sky130_fd_sc_hd__clkbuf_4
Xfanout682 net683 vssd1 vssd1 vccd1 vccd1 net682 sky130_fd_sc_hd__clkbuf_2
XTAP_TAPCELL_ROW_109_1946 vssd1 vccd1 sky130_fd_sc_hd__tapvpwrvgnd_1
X_12933_ _05673_ _05678_ _05686_ net550 vssd1 vssd1 vccd1 vccd1 _06385_ sky130_fd_sc_hd__a211o_1
XFILLER_86_680 vssd1 vssd1 vccd1 vccd1 sky130_fd_sc_hd__fill_2
XTAP_TAPCELL_ROW_29_742 vssd1 vccd1 sky130_fd_sc_hd__tapvpwrvgnd_1
X_12864_ cell2.SB0.route_sel\[106\] cell2.SB0.route_sel\[105\] net817 vssd1 vssd1
+ vccd1 vccd1 _01293_ sky130_fd_sc_hd__mux2_1
X_12795_ cell2.SB0.route_sel\[37\] cell2.SB0.route_sel\[36\] net815 vssd1 vssd1 vccd1
+ vccd1 _01224_ sky130_fd_sc_hd__mux2_1
X_11815_ cell1.LE_1B.config_data\[16\] net1514 net905 vssd1 vssd1 vccd1 vccd1 _00252_
+ sky130_fd_sc_hd__mux2_1
XTAP_TAPCELL_ROW_64_1275 vssd1 vccd1 sky130_fd_sc_hd__tapvpwrvgnd_1
XTAP_TAPCELL_ROW_64_1264 vssd1 vccd1 sky130_fd_sc_hd__tapvpwrvgnd_1
X_11746_ cell0.LE_0A.reset_mode net1489 net796 vssd1 vssd1 vccd1 vccd1 _00184_ sky130_fd_sc_hd__mux2_1
X_14465_ clknet_leaf_62_clk _01437_ net740 vssd1 vssd1 vccd1 vccd1 cell3.LEI0.config_data\[30\]
+ sky130_fd_sc_hd__dfrtp_1
X_11677_ cell0.CB_1.config_dataB\[23\] cell0.CB_1.config_dataB\[22\] net786 vssd1
+ vssd1 vccd1 vccd1 _00118_ sky130_fd_sc_hd__mux2_1
X_14396_ clknet_leaf_57_clk _01368_ net723 vssd1 vssd1 vccd1 vccd1 cell3.LE_0B.config_data\[5\]
+ sky130_fd_sc_hd__dfrtp_1
X_10628_ net15 net16 cell3.CB_1.config_dataA\[0\] vssd1 vssd1 vccd1 vccd1 _05586_
+ sky130_fd_sc_hd__mux2_1
X_13416_ clknet_leaf_131_clk _00388_ net556 vssd1 vssd1 vccd1 vccd1 cell0.SB0.route_sel\[57\]
+ sky130_fd_sc_hd__dfstp_2
XANTENNA__12752__S net929 vssd1 vssd1 vccd1 vccd1 sky130_fd_sc_hd__diode_2
XANTENNA__09974__A1 bus3_2\[9\] vssd1 vssd1 vccd1 vccd1 sky130_fd_sc_hd__diode_2
X_10559_ cell3.SB0.route_sel\[118\] _01746_ vssd1 vssd1 vccd1 vccd1 _05517_ sky130_fd_sc_hd__nand2_1
X_13347_ clknet_leaf_85_clk _00319_ net685 vssd1 vssd1 vccd1 vccd1 cell1.CB_0.config_dataA\[13\]
+ sky130_fd_sc_hd__dfstp_1
X_13278_ clknet_leaf_91_clk net1526 net698 vssd1 vssd1 vccd1 vccd1 cell1.LE_1B.config_data\[14\]
+ sky130_fd_sc_hd__dfrtp_1
X_12229_ cell2.CB_0.config_dataB\[17\] net423 net827 vssd1 vssd1 vccd1 vccd1 _00662_
+ sky130_fd_sc_hd__mux2_1
XANTENNA__08529__A2 _03486_ vssd1 vssd1 vccd1 vccd1 sky130_fd_sc_hd__diode_2
XFILLER_68_135 vssd1 vssd1 vccd1 vccd1 sky130_fd_sc_hd__fill_1
XANTENNA__07201__A2 net357 vssd1 vssd1 vccd1 vccd1 sky130_fd_sc_hd__diode_2
X_07770_ _01890_ _02062_ vssd1 vssd1 vccd1 vccd1 _02816_ sky130_fd_sc_hd__nor2_1
X_06721_ net393 vssd1 vssd1 vccd1 vccd1 _01791_ sky130_fd_sc_hd__inv_2
XANTENNA__10639__A3 net291 vssd1 vssd1 vccd1 vccd1 sky130_fd_sc_hd__diode_2
X_09440_ cell3.SB0.route_sel\[40\] cell3.SB0.route_sel\[41\] _04456_ _04462_ net914
+ vssd1 vssd1 vccd1 vccd1 _04463_ sky130_fd_sc_hd__a311oi_4
XFILLER_64_330 vssd1 vssd1 vccd1 vccd1 sky130_fd_sc_hd__fill_1
XANTENNA__11049__A0 net49 vssd1 vssd1 vccd1 vccd1 sky130_fd_sc_hd__diode_2
X_06652_ cell3.SB0.route_sel\[68\] vssd1 vssd1 vccd1 vccd1 _01722_ sky130_fd_sc_hd__inv_2
X_09371_ _04391_ _04393_ _04394_ vssd1 vssd1 vccd1 vccd1 _04395_ sky130_fd_sc_hd__a21oi_1
X_06583_ cell2.SB0.route_sel\[125\] vssd1 vssd1 vccd1 vccd1 _01653_ sky130_fd_sc_hd__inv_2
X_08322_ net509 _01956_ vssd1 vssd1 vccd1 vccd1 _03360_ sky130_fd_sc_hd__nand2_1
XANTENNA__07610__A net355 vssd1 vssd1 vccd1 vccd1 sky130_fd_sc_hd__diode_2
X_08253_ net536 _02719_ _03292_ net535 vssd1 vssd1 vccd1 vccd1 _03293_ sky130_fd_sc_hd__o211a_1
XFILLER_33_794 vssd1 vssd1 vccd1 vccd1 sky130_fd_sc_hd__fill_1
XANTENNA__09009__A3 bus3_1\[11\] vssd1 vssd1 vccd1 vccd1 sky130_fd_sc_hd__diode_2
X_07204_ cell0.SB0.route_sel\[94\] cell0.SB0.route_sel\[95\] vssd1 vssd1 vccd1 vccd1
+ _02264_ sky130_fd_sc_hd__nand2_1
XFILLER_119_833 vssd1 vssd1 vccd1 vccd1 sky130_fd_sc_hd__fill_1
X_08184_ net542 _02211_ _03223_ net541 vssd1 vssd1 vccd1 vccd1 _03224_ sky130_fd_sc_hd__o211a_1
XANTENNA__08217__B2 bus1_0\[0\] vssd1 vssd1 vccd1 vccd1 sky130_fd_sc_hd__diode_2
XANTENNA__08217__A1 bus1_0\[1\] vssd1 vssd1 vccd1 vccd1 sky130_fd_sc_hd__diode_2
XFILLER_20_477 vssd1 vssd1 vccd1 vccd1 sky130_fd_sc_hd__fill_2
XTAP_TAPCELL_ROW_95_1736 vssd1 vccd1 sky130_fd_sc_hd__tapvpwrvgnd_1
X_07135_ cell0.SB0.route_sel\[86\] cell0.SB0.route_sel\[87\] vssd1 vssd1 vccd1 vccd1
+ _02197_ sky130_fd_sc_hd__nand2_1
X_07066_ _02122_ _02127_ _02128_ _02123_ vssd1 vssd1 vccd1 vccd1 _02130_ sky130_fd_sc_hd__o31a_1
XFILLER_3_109 vssd1 vssd1 vccd1 vccd1 sky130_fd_sc_hd__fill_2
XANTENNA__07609__X _02658_ vssd1 vssd1 vccd1 vccd1 sky130_fd_sc_hd__diode_2
Xoutput230 net230 vssd1 vssd1 vccd1 vccd1 SBwest_out[0] sky130_fd_sc_hd__buf_2
Xoutput241 net241 vssd1 vssd1 vccd1 vccd1 SBwest_out[1] sky130_fd_sc_hd__buf_2
Xoutput252 net252 vssd1 vssd1 vccd1 vccd1 SBwest_out[2] sky130_fd_sc_hd__buf_2
XTAP_TAPCELL_ROW_7_415 vssd1 vccd1 sky130_fd_sc_hd__tapvpwrvgnd_1
XFILLER_58_27 vssd1 vssd1 vccd1 vccd1 sky130_fd_sc_hd__fill_1
XANTENNA__10732__C1 net352 vssd1 vssd1 vccd1 vccd1 sky130_fd_sc_hd__diode_2
XFILLER_101_210 vssd1 vssd1 vccd1 vccd1 sky130_fd_sc_hd__fill_1
XTAP_TAPCELL_ROW_126_2202 vssd1 vccd1 sky130_fd_sc_hd__tapvpwrvgnd_1
XFILLER_101_265 vssd1 vssd1 vccd1 vccd1 sky130_fd_sc_hd__fill_1
X_07968_ cell0.LEI0.config_data\[38\] _03011_ _03009_ _03008_ vssd1 vssd1 vccd1 vccd1
+ _03012_ sky130_fd_sc_hd__o211a_1
X_09707_ cell3.SB0.route_sel\[123\] cell3.SB0.route_sel\[122\] vssd1 vssd1 vccd1 vccd1
+ _04720_ sky130_fd_sc_hd__nand2_1
X_06919_ net267 _01985_ vssd1 vssd1 vccd1 vccd1 _01986_ sky130_fd_sc_hd__nand2_4
XANTENNA__06951__A1 net339 vssd1 vssd1 vccd1 vccd1 sky130_fd_sc_hd__diode_2
XANTENNA_fanout933_A net934 vssd1 vssd1 vccd1 vccd1 sky130_fd_sc_hd__diode_2
XFILLER_83_661 vssd1 vssd1 vccd1 vccd1 sky130_fd_sc_hd__fill_1
XFILLER_83_650 vssd1 vssd1 vccd1 vccd1 sky130_fd_sc_hd__fill_1
XFILLER_67_190 vssd1 vssd1 vccd1 vccd1 sky130_fd_sc_hd__fill_1
X_07899_ _01568_ _02939_ _02942_ _02932_ vssd1 vssd1 vccd1 vccd1 _02943_ sky130_fd_sc_hd__o31a_1
XFILLER_130_21 vssd1 vssd1 vccd1 vccd1 sky130_fd_sc_hd__fill_4
X_09638_ net381 net380 vssd1 vssd1 vccd1 vccd1 _04654_ sky130_fd_sc_hd__nand2_1
XFILLER_83_694 vssd1 vssd1 vccd1 vccd1 sky130_fd_sc_hd__fill_4
XANTENNA__07900__A0 net344 vssd1 vssd1 vccd1 vccd1 sky130_fd_sc_hd__diode_2
XFILLER_43_503 vssd1 vssd1 vccd1 vccd1 sky130_fd_sc_hd__fill_1
XTAP_TAPCELL_ROW_26_701 vssd1 vccd1 sky130_fd_sc_hd__tapvpwrvgnd_1
X_09569_ _02243_ _04584_ _04586_ vssd1 vssd1 vccd1 vccd1 _04587_ sky130_fd_sc_hd__o21ai_1
XFILLER_130_65 vssd1 vssd1 vccd1 vccd1 sky130_fd_sc_hd__fill_4
XTAP_TAPCELL_ROW_104_1865 vssd1 vccd1 sky130_fd_sc_hd__tapvpwrvgnd_1
XFILLER_90_25 vssd1 vssd1 vccd1 vccd1 sky130_fd_sc_hd__fill_2
X_12580_ cell3.SB0.route_sel\[45\] cell3.SB0.route_sel\[44\] net878 vssd1 vssd1 vccd1
+ vccd1 _01009_ sky130_fd_sc_hd__mux2_1
X_11600_ cell0.CB_1.config_dataA\[21\] cell0.CB_1.config_dataA\[20\] net859 vssd1
+ vssd1 vccd1 vccd1 _00041_ sky130_fd_sc_hd__mux2_1
XFILLER_142_3 vccd1 vssd1 vccd1 vssd1 sky130_ef_sc_hd__decap_40_12
X_11531_ _06354_ _02538_ vssd1 vssd1 vccd1 vccd1 net253 sky130_fd_sc_hd__and2b_1
XANTENNA__08335__B _02277_ vssd1 vssd1 vccd1 vccd1 sky130_fd_sc_hd__diode_2
XTAP_TAPCELL_ROW_137_2364 vssd1 vccd1 sky130_fd_sc_hd__tapvpwrvgnd_1
X_14250_ clknet_leaf_18_clk _01222_ net614 vssd1 vssd1 vccd1 vccd1 cell2.SB0.route_sel\[35\]
+ sky130_fd_sc_hd__dfstp_1
XFILLER_7_426 vccd1 vssd1 vccd1 vssd1 sky130_ef_sc_hd__decap_40_12
X_11462_ _01979_ _06308_ vssd1 vssd1 vccd1 vccd1 net213 sky130_fd_sc_hd__and2_1
X_14181_ clknet_leaf_58_clk _01153_ net720 vssd1 vssd1 vccd1 vccd1 cell3.CB_0.config_dataB\[16\]
+ sky130_fd_sc_hd__dfstp_1
XANTENNA__11212__A0 net49 vssd1 vssd1 vccd1 vccd1 sky130_fd_sc_hd__diode_2
X_10413_ net312 cell2.CB_0.le_outB net318 net304 cell2.LEI0.config_data\[39\] cell2.LEI0.config_data\[40\]
+ vssd1 vssd1 vccd1 vccd1 _05412_ sky130_fd_sc_hd__mux4_1
XFILLER_99_45 vssd1 vssd1 vccd1 vccd1 sky130_fd_sc_hd__fill_2
X_13201_ clknet_leaf_6_clk _00173_ net567 vssd1 vssd1 vccd1 vccd1 cell0.LE_0A.config_data\[8\]
+ sky130_fd_sc_hd__dfrtp_1
X_11393_ _02037_ _06262_ vssd1 vssd1 vccd1 vccd1 net228 sky130_fd_sc_hd__nor2_1
XANTENNA__08759__A2 _03533_ vssd1 vssd1 vccd1 vccd1 sky130_fd_sc_hd__diode_2
XANTENNA_input62_A CBnorth_in[7] vssd1 vssd1 vccd1 vccd1 sky130_fd_sc_hd__diode_2
X_10344_ cell2.CB_0.config_dataB\[4\] _05313_ _05320_ _05342_ _01755_ vssd1 vssd1
+ vccd1 vccd1 _05343_ sky130_fd_sc_hd__a32o_1
XANTENNA__10566__A2 net272 vssd1 vssd1 vccd1 vccd1 sky130_fd_sc_hd__diode_2
X_13132_ clknet_leaf_127_clk _00104_ net577 vssd1 vssd1 vccd1 vccd1 cell0.CB_1.config_dataB\[9\]
+ sky130_fd_sc_hd__dfstp_1
XPHY_EDGE_ROW_36_Left_179 vssd1 vssd1 vccd1 vccd1 sky130_fd_sc_hd__decap_3
XANTENNA__10318__A2 _05148_ vssd1 vssd1 vccd1 vccd1 sky130_fd_sc_hd__diode_2
X_10275_ _05268_ _05275_ _05264_ vssd1 vssd1 vccd1 vccd1 _05276_ sky130_fd_sc_hd__mux2_1
XFILLER_3_665 vssd1 vssd1 vccd1 vccd1 sky130_fd_sc_hd__fill_4
XFILLER_2_153 vccd1 vssd1 vccd1 vssd1 sky130_ef_sc_hd__decap_40_12
X_13063_ clknet_leaf_125_clk _00035_ net583 vssd1 vssd1 vccd1 vccd1 cell0.CB_1.config_dataA\[15\]
+ sky130_fd_sc_hd__dfstp_1
X_12014_ cell0.SB0.route_sel\[120\] cell0.SB0.route_sel\[119\] net774 vssd1 vssd1
+ vccd1 vccd1 _00451_ sky130_fd_sc_hd__mux2_1
XFILLER_2_197 vccd1 vssd1 vccd1 vssd1 sky130_ef_sc_hd__decap_40_12
XANTENNA_output149_A net149 vssd1 vssd1 vccd1 vccd1 sky130_fd_sc_hd__diode_2
XANTENNA__08392__B1 _02040_ vssd1 vssd1 vccd1 vccd1 sky130_fd_sc_hd__diode_2
XANTENNA__11279__A0 _05111_ vssd1 vssd1 vccd1 vccd1 sky130_fd_sc_hd__diode_2
Xfanout490 cell1.CB_1.config_dataA\[11\] vssd1 vssd1 vccd1 vccd1 net490 sky130_fd_sc_hd__buf_2
X_13965_ clknet_leaf_41_clk _00937_ net642 vssd1 vssd1 vccd1 vccd1 cell2.LEI0.config_data\[22\]
+ sky130_fd_sc_hd__dfrtp_1
XPHY_EDGE_ROW_45_Left_188 vssd1 vssd1 vccd1 vccd1 sky130_fd_sc_hd__decap_3
XANTENNA__08144__A0 bus1_0\[6\] vssd1 vssd1 vccd1 vccd1 sky130_fd_sc_hd__diode_2
X_12916_ net1377 cell3.LE_1A.config_data\[3\] net954 vssd1 vssd1 vccd1 vccd1 _01345_
+ sky130_fd_sc_hd__mux2_1
X_13896_ clknet_leaf_41_clk _00868_ net642 vssd1 vssd1 vccd1 vccd1 cell2.LE_1A.reset_mode
+ sky130_fd_sc_hd__dfrtp_1
XFILLER_73_160 vssd1 vssd1 vccd1 vccd1 sky130_fd_sc_hd__fill_2
XTAP_TAPCELL_ROW_66_1304 vssd1 vccd1 sky130_fd_sc_hd__tapvpwrvgnd_1
XANTENNA__08695__A1 _03514_ vssd1 vssd1 vccd1 vccd1 sky130_fd_sc_hd__diode_2
XANTENNA__08695__B2 _03517_ vssd1 vssd1 vccd1 vccd1 sky130_fd_sc_hd__diode_2
XANTENNA_clkload8_A clknet_4_8_0_clk vssd1 vssd1 vccd1 vccd1 sky130_fd_sc_hd__diode_2
XANTENNA__12747__S net929 vssd1 vssd1 vccd1 vccd1 sky130_fd_sc_hd__diode_2
X_12847_ cell2.SB0.route_sel\[89\] cell2.SB0.route_sel\[88\] net832 vssd1 vssd1 vccd1
+ vccd1 _01276_ sky130_fd_sc_hd__mux2_1
XANTENNA__11504__X net243 vssd1 vssd1 vccd1 vccd1 sky130_fd_sc_hd__diode_2
X_12778_ cell2.SB0.route_sel\[20\] cell2.SB0.route_sel\[19\] net816 vssd1 vssd1 vccd1
+ vccd1 _01207_ sky130_fd_sc_hd__mux2_1
X_11729_ net1048 net997 net808 vssd1 vssd1 vccd1 vccd1 _00167_ sky130_fd_sc_hd__mux2_1
X_14448_ clknet_leaf_60_clk net1434 net735 vssd1 vssd1 vccd1 vccd1 cell3.LEI0.config_data\[13\]
+ sky130_fd_sc_hd__dfrtp_1
XANTENNA__11203__B1 _05924_ vssd1 vssd1 vccd1 vccd1 sky130_fd_sc_hd__diode_2
XANTENNA__14036__Q cell3.SB0.route_sel\[44\] vssd1 vssd1 vccd1 vccd1 sky130_fd_sc_hd__diode_2
XPHY_EDGE_ROW_54_Left_197 vssd1 vssd1 vccd1 vccd1 sky130_fd_sc_hd__decap_3
XTAP_TAPCELL_ROW_12_483 vssd1 vccd1 sky130_fd_sc_hd__tapvpwrvgnd_1
XTAP_TAPCELL_ROW_12_494 vssd1 vccd1 sky130_fd_sc_hd__tapvpwrvgnd_1
XFILLER_127_162 vssd1 vssd1 vccd1 vccd1 sky130_fd_sc_hd__fill_1
X_14379_ clknet_leaf_70_clk _01351_ net731 vssd1 vssd1 vccd1 vccd1 cell3.LE_1A.config_data\[10\]
+ sky130_fd_sc_hd__dfrtp_1
XANTENNA__10557__A2 _05510_ vssd1 vssd1 vccd1 vccd1 sky130_fd_sc_hd__diode_2
XTAP_TAPCELL_ROW_77_1466 vssd1 vccd1 sky130_fd_sc_hd__tapvpwrvgnd_1
XFILLER_115_335 vssd1 vssd1 vccd1 vccd1 sky130_fd_sc_hd__fill_1
XANTENNA__07422__A2 net361 vssd1 vssd1 vccd1 vccd1 sky130_fd_sc_hd__diode_2
XFILLER_131_839 vssd1 vssd1 vccd1 vccd1 sky130_fd_sc_hd__fill_1
X_08940_ net463 net464 vssd1 vssd1 vccd1 vccd1 _03972_ sky130_fd_sc_hd__and2b_1
XTAP_TAPCELL_ROW_90_1655 vssd1 vccd1 sky130_fd_sc_hd__tapvpwrvgnd_1
X_08871_ net473 _03841_ vssd1 vssd1 vccd1 vccd1 _03903_ sky130_fd_sc_hd__or2_1
XANTENNA__10190__A0 net63 vssd1 vssd1 vccd1 vccd1 sky130_fd_sc_hd__diode_2
XANTENNA__10015__B _04498_ vssd1 vssd1 vccd1 vccd1 sky130_fd_sc_hd__diode_2
XFILLER_96_263 vssd1 vssd1 vccd1 vccd1 sky130_fd_sc_hd__fill_2
XFILLER_57_617 vssd1 vssd1 vccd1 vccd1 sky130_fd_sc_hd__fill_1
X_07822_ cell1.SB0.route_sel\[44\] cell1.SB0.route_sel\[45\] vssd1 vssd1 vccd1 vccd1
+ _02867_ sky130_fd_sc_hd__nand2b_1
XFILLER_111_585 vssd1 vssd1 vccd1 vccd1 sky130_fd_sc_hd__fill_1
XANTENNA__09804__B _04298_ vssd1 vssd1 vccd1 vccd1 sky130_fd_sc_hd__diode_2
XFILLER_84_414 vssd1 vssd1 vccd1 vccd1 sky130_fd_sc_hd__fill_4
X_07753_ net343 _01863_ _02026_ vssd1 vssd1 vccd1 vccd1 _02799_ sky130_fd_sc_hd__nor3_2
X_06704_ cell2.CB_0.config_dataA\[19\] vssd1 vssd1 vccd1 vccd1 _01774_ sky130_fd_sc_hd__inv_2
X_07684_ net330 _01884_ _02646_ vssd1 vssd1 vccd1 vccd1 _02732_ sky130_fd_sc_hd__or3_1
XANTENNA__08686__A1 _03537_ vssd1 vssd1 vccd1 vccd1 sky130_fd_sc_hd__diode_2
XANTENNA__08686__B2 _03540_ vssd1 vssd1 vccd1 vccd1 sky130_fd_sc_hd__diode_2
XANTENNA__08280__A1_N _02136_ vssd1 vssd1 vccd1 vccd1 sky130_fd_sc_hd__diode_2
XANTENNA__07489__A2 _01932_ vssd1 vssd1 vccd1 vccd1 sky130_fd_sc_hd__diode_2
XTAP_TAPCELL_ROW_121_2121 vssd1 vccd1 sky130_fd_sc_hd__tapvpwrvgnd_1
X_06635_ cell3.SB0.route_sel\[43\] vssd1 vssd1 vccd1 vccd1 _01705_ sky130_fd_sc_hd__inv_2
X_09423_ _04426_ _04442_ _04444_ vssd1 vssd1 vccd1 vccd1 _04446_ sky130_fd_sc_hd__and3_1
XFILLER_44_29 vssd1 vssd1 vccd1 vccd1 sky130_fd_sc_hd__fill_1
XFILLER_25_558 vssd1 vssd1 vccd1 vccd1 sky130_fd_sc_hd__fill_2
X_09354_ _01901_ _02087_ vssd1 vssd1 vccd1 vccd1 _04378_ sky130_fd_sc_hd__nor2_1
XANTENNA_fanout347_A cell0.CB_0.le_outB vssd1 vssd1 vccd1 vccd1 sky130_fd_sc_hd__diode_2
XFILLER_100_35 vssd1 vssd1 vccd1 vccd1 sky130_fd_sc_hd__fill_1
X_06566_ cell2.SB0.route_sel\[93\] vssd1 vssd1 vccd1 vccd1 _01636_ sky130_fd_sc_hd__inv_2
X_08305_ net344 net347 cell0.LEI0.config_data\[21\] vssd1 vssd1 vccd1 vccd1 _03343_
+ sky130_fd_sc_hd__mux2_1
X_09285_ _04305_ _04309_ _04302_ vssd1 vssd1 vccd1 vccd1 _04311_ sky130_fd_sc_hd__o21ai_1
X_06497_ cell2.SB0.route_sel\[6\] vssd1 vssd1 vccd1 vccd1 _01567_ sky130_fd_sc_hd__inv_2
XTAP_TAPCELL_ROW_31_770 vssd1 vccd1 sky130_fd_sc_hd__tapvpwrvgnd_1
X_08236_ net537 _02211_ _03275_ net535 vssd1 vssd1 vccd1 vccd1 _03276_ sky130_fd_sc_hd__o211a_1
XTAP_TAPCELL_ROW_119_2094 vssd1 vccd1 sky130_fd_sc_hd__tapvpwrvgnd_1
XANTENNA__09938__A1 _04671_ vssd1 vssd1 vccd1 vccd1 sky130_fd_sc_hd__diode_2
XANTENNA__09538__Y _04557_ vssd1 vssd1 vccd1 vccd1 sky130_fd_sc_hd__diode_2
X_08167_ cell0.CB_1.config_dataA\[8\] cell0.CB_1.config_dataA\[7\] vssd1 vssd1 vccd1
+ vccd1 _03207_ sky130_fd_sc_hd__nor2_1
X_07118_ _02100_ _02180_ vssd1 vssd1 vccd1 vccd1 _02181_ sky130_fd_sc_hd__nor2_1
XANTENNA__10548__A2 _04362_ vssd1 vssd1 vccd1 vccd1 sky130_fd_sc_hd__diode_2
XANTENNA_fanout302_X net302 vssd1 vssd1 vccd1 vccd1 sky130_fd_sc_hd__diode_2
XTAP_TAPCELL_ROW_132_2283 vssd1 vccd1 sky130_fd_sc_hd__tapvpwrvgnd_1
XFILLER_106_335 vssd1 vssd1 vccd1 vccd1 sky130_fd_sc_hd__fill_1
XANTENNA_fanout883_A net884 vssd1 vssd1 vccd1 vccd1 sky130_fd_sc_hd__diode_2
XANTENNA__13263__SET_B net751 vssd1 vssd1 vccd1 vccd1 sky130_fd_sc_hd__diode_2
X_08098_ net524 _02526_ _03139_ net523 vssd1 vssd1 vccd1 vccd1 _03140_ sky130_fd_sc_hd__o211a_1
XTAP_TAPCELL_ROW_132_2294 vssd1 vccd1 sky130_fd_sc_hd__tapvpwrvgnd_1
X_07049_ _02109_ net348 _02012_ vssd1 vssd1 vccd1 vccd1 _02113_ sky130_fd_sc_hd__and3b_1
XFILLER_114_390 vssd1 vssd1 vccd1 vccd1 sky130_fd_sc_hd__fill_1
XANTENNA__09554__X _04573_ vssd1 vssd1 vccd1 vccd1 sky130_fd_sc_hd__diode_2
X_10060_ _01822_ net305 net315 net302 cell2.LEI0.config_data\[45\] cell2.LEI0.config_data\[46\]
+ vssd1 vssd1 vccd1 vccd1 _05064_ sky130_fd_sc_hd__mux4_1
XFILLER_102_596 vccd1 vssd1 vccd1 vssd1 sky130_ef_sc_hd__decap_40_12
XFILLER_87_285 vssd1 vssd1 vccd1 vccd1 sky130_fd_sc_hd__fill_8
XFILLER_85_47 vssd1 vssd1 vccd1 vccd1 sky130_fd_sc_hd__fill_8
XANTENNA_fanout936_X net936 vssd1 vssd1 vccd1 vccd1 sky130_fd_sc_hd__diode_2
XANTENNA__08110__S _03087_ vssd1 vssd1 vccd1 vccd1 sky130_fd_sc_hd__diode_2
XFILLER_18_41 vccd1 vssd1 vccd1 vssd1 sky130_ef_sc_hd__decap_40_12
XANTENNA__11136__A1_N _05879_ vssd1 vssd1 vccd1 vccd1 sky130_fd_sc_hd__diode_2
X_10962_ _05915_ _04371_ vssd1 vssd1 vccd1 vccd1 _05916_ sky130_fd_sc_hd__nand2b_2
XTAP_TAPCELL_ROW_106_1905 vssd1 vccd1 sky130_fd_sc_hd__tapvpwrvgnd_1
XANTENNA__09874__A0 bus3_2\[8\] vssd1 vssd1 vccd1 vccd1 sky130_fd_sc_hd__diode_2
X_13750_ clknet_leaf_108_clk _00722_ net652 vssd1 vssd1 vccd1 vccd1 cell1.SB0.route_sel\[27\]
+ sky130_fd_sc_hd__dfstp_1
XFILLER_141_97 vssd1 vssd1 vccd1 vccd1 sky130_fd_sc_hd__fill_1
XANTENNA__09730__A net272 vssd1 vssd1 vccd1 vccd1 sky130_fd_sc_hd__diode_2
X_12701_ cell3.CB_1.config_dataA\[18\] cell3.CB_1.config_dataA\[17\] net939 vssd1
+ vssd1 vccd1 vccd1 _01130_ sky130_fd_sc_hd__mux2_1
XTAP_TAPCELL_ROW_48_1034 vssd1 vccd1 sky130_fd_sc_hd__tapvpwrvgnd_1
XTAP_TAPCELL_ROW_48_1023 vssd1 vccd1 sky130_fd_sc_hd__tapvpwrvgnd_1
XTAP_TAPCELL_ROW_39_892 vssd1 vccd1 sky130_fd_sc_hd__tapvpwrvgnd_1
XANTENNA__07802__X _02847_ vssd1 vssd1 vccd1 vccd1 sky130_fd_sc_hd__diode_2
X_13681_ clknet_leaf_30_clk _00653_ net620 vssd1 vssd1 vccd1 vccd1 cell2.CB_0.config_dataB\[8\]
+ sky130_fd_sc_hd__dfstp_1
X_10893_ _04714_ _05846_ vssd1 vssd1 vccd1 vccd1 _05847_ sky130_fd_sc_hd__or2_4
XANTENNA__11324__X net157 vssd1 vssd1 vccd1 vccd1 sky130_fd_sc_hd__diode_2
X_12632_ cell3.SB0.route_sel\[97\] cell3.SB0.route_sel\[96\] net922 vssd1 vssd1 vccd1
+ vccd1 _01061_ sky130_fd_sc_hd__mux2_1
XTAP_TAPCELL_ROW_61_1223 vssd1 vccd1 sky130_fd_sc_hd__tapvpwrvgnd_1
XFILLER_24_580 vssd1 vssd1 vccd1 vccd1 sky130_fd_sc_hd__fill_4
XANTENNA__10236__B2 _05156_ vssd1 vssd1 vccd1 vccd1 sky130_fd_sc_hd__diode_2
XANTENNA__10236__A1 _05152_ vssd1 vssd1 vccd1 vccd1 sky130_fd_sc_hd__diode_2
X_12563_ cell3.SB0.route_sel\[28\] cell3.SB0.route_sel\[27\] net910 vssd1 vssd1 vccd1
+ vccd1 _00992_ sky130_fd_sc_hd__mux2_1
XFILLER_8_713 vccd1 vssd1 vccd1 vssd1 sky130_ef_sc_hd__decap_40_12
X_12494_ net1145 cell2.LEI0.config_data\[7\] net847 vssd1 vssd1 vccd1 vccd1 _00923_
+ sky130_fd_sc_hd__mux2_1
X_11514_ _01625_ cell2.SB0.route_sel\[74\] vssd1 vssd1 vccd1 vccd1 _06343_ sky130_fd_sc_hd__nand2_1
X_14302_ clknet_leaf_13_clk _01274_ net590 vssd1 vssd1 vccd1 vccd1 cell2.SB0.route_sel\[87\]
+ sky130_fd_sc_hd__dfstp_1
XFILLER_7_223 vssd1 vssd1 vccd1 vccd1 sky130_fd_sc_hd__fill_1
X_14233_ clknet_leaf_20_clk _01205_ net624 vssd1 vssd1 vccd1 vccd1 cell2.SB0.route_sel\[18\]
+ sky130_fd_sc_hd__dfstp_1
XFILLER_7_234 vssd1 vssd1 vccd1 vccd1 sky130_fd_sc_hd__fill_1
X_11445_ cell1.SB0.route_sel\[17\] cell1.SB0.route_sel\[16\] vssd1 vssd1 vccd1 vccd1
+ _06297_ sky130_fd_sc_hd__nand2b_1
XANTENNA__10539__A2 net10 vssd1 vssd1 vccd1 vccd1 sky130_fd_sc_hd__diode_2
X_14164_ clknet_leaf_74_clk _01136_ net727 vssd1 vssd1 vccd1 vccd1 cell3.CB_1.config_dataA\[24\]
+ sky130_fd_sc_hd__dfstp_1
XANTENNA__08601__A1 net32 vssd1 vssd1 vccd1 vccd1 sky130_fd_sc_hd__diode_2
XANTENNA_input65_X net65 vssd1 vssd1 vccd1 vccd1 sky130_fd_sc_hd__diode_2
X_11376_ cell0.SB0.route_sel\[41\] cell0.SB0.route_sel\[40\] vssd1 vssd1 vccd1 vccd1
+ _06251_ sky130_fd_sc_hd__nor2_1
X_10327_ _05320_ _05323_ _05325_ cell2.CB_0.config_dataB\[2\] vssd1 vssd1 vccd1 vccd1
+ _05326_ sky130_fd_sc_hd__o22a_1
X_14095_ clknet_leaf_77_clk _01067_ net712 vssd1 vssd1 vccd1 vccd1 cell3.SB0.route_sel\[103\]
+ sky130_fd_sc_hd__dfstp_1
XTAP_TAPCELL_ROW_59_1196 vssd1 vccd1 sky130_fd_sc_hd__tapvpwrvgnd_1
X_13115_ clknet_leaf_3_clk _00087_ net565 vssd1 vssd1 vccd1 vccd1 cell0.CB_0.config_dataA\[17\]
+ sky130_fd_sc_hd__dfstp_2
X_10258_ net36 net37 net38 net39 net413 cell2.CB_0.config_dataA\[16\] vssd1 vssd1
+ vccd1 vccd1 _05259_ sky130_fd_sc_hd__mux4_1
X_13046_ clknet_leaf_13_clk _00018_ net597 vssd1 vssd1 vccd1 vccd1 cell0.LE_1B.reset_val
+ sky130_fd_sc_hd__dfrtp_1
XFILLER_3_473 vccd1 vssd1 vccd1 vssd1 sky130_ef_sc_hd__decap_40_12
XTAP_TAPCELL_ROW_72_1385 vssd1 vccd1 sky130_fd_sc_hd__tapvpwrvgnd_1
X_10189_ net36 net37 net38 net39 net422 net420 vssd1 vssd1 vccd1 vccd1 _05190_ sky130_fd_sc_hd__mux4_1
XFILLER_93_222 vssd1 vssd1 vccd1 vccd1 sky130_fd_sc_hd__fill_2
XFILLER_78_274 vssd1 vssd1 vccd1 vccd1 sky130_fd_sc_hd__fill_2
XFILLER_66_425 vssd1 vssd1 vccd1 vccd1 sky130_fd_sc_hd__fill_1
X_13948_ clknet_leaf_34_clk _00920_ net638 vssd1 vssd1 vccd1 vccd1 cell2.LEI0.config_data\[5\]
+ sky130_fd_sc_hd__dfrtp_1
XANTENNA__08132__A3 bus1_0\[15\] vssd1 vssd1 vccd1 vccd1 sky130_fd_sc_hd__diode_2
X_13879_ clknet_leaf_54_clk _00851_ net644 vssd1 vssd1 vccd1 vccd1 cell2.LE_1A.config_data\[2\]
+ sky130_fd_sc_hd__dfrtp_1
XANTENNA__12477__S net824 vssd1 vssd1 vccd1 vccd1 sky130_fd_sc_hd__diode_2
X_06420_ net507 vssd1 vssd1 vccd1 vccd1 _01490_ sky130_fd_sc_hd__inv_2
XTAP_TAPCELL_ROW_17_564 vssd1 vccd1 sky130_fd_sc_hd__tapvpwrvgnd_1
XFILLER_34_344 vssd1 vssd1 vccd1 vccd1 sky130_fd_sc_hd__fill_1
XANTENNA__10227__A1 net305 vssd1 vssd1 vccd1 vccd1 sky130_fd_sc_hd__diode_2
XPHY_EDGE_ROW_62_Left_205 vssd1 vssd1 vccd1 vccd1 sky130_fd_sc_hd__decap_3
XFILLER_15_591 vssd1 vssd1 vccd1 vccd1 sky130_fd_sc_hd__fill_1
X_09070_ _04089_ _04092_ _04096_ cell1.CB_0.config_dataB\[13\] vssd1 vssd1 vccd1 vccd1
+ _04100_ sky130_fd_sc_hd__o211a_1
X_08021_ net533 _02585_ vssd1 vssd1 vccd1 vccd1 _03063_ sky130_fd_sc_hd__nand2_1
XFILLER_116_611 vssd1 vssd1 vccd1 vccd1 sky130_fd_sc_hd__fill_1
XANTENNA__11727__A1 net129 vssd1 vssd1 vccd1 vccd1 sky130_fd_sc_hd__diode_2
XANTENNA__12940__S net933 vssd1 vssd1 vccd1 vccd1 sky130_fd_sc_hd__diode_2
XPHY_EDGE_ROW_123_Right_123 vssd1 vssd1 vccd1 vccd1 sky130_fd_sc_hd__decap_3
XFILLER_116_699 vssd1 vssd1 vccd1 vccd1 sky130_fd_sc_hd__fill_1
XFILLER_116_677 vssd1 vssd1 vccd1 vccd1 sky130_fd_sc_hd__fill_1
X_09972_ _04671_ _04958_ _04975_ vssd1 vssd1 vccd1 vccd1 _04976_ sky130_fd_sc_hd__a21bo_1
XFILLER_104_817 vssd1 vssd1 vccd1 vccd1 sky130_fd_sc_hd__fill_1
XANTENNA__13336__SET_B net674 vssd1 vssd1 vccd1 vccd1 sky130_fd_sc_hd__diode_2
X_08923_ net467 _03817_ _03954_ cell1.CB_0.config_dataA\[11\] vssd1 vssd1 vccd1 vccd1
+ _03955_ sky130_fd_sc_hd__o211a_1
XANTENNA_fanout297_A net298 vssd1 vssd1 vccd1 vccd1 sky130_fd_sc_hd__diode_2
XPHY_EDGE_ROW_71_Left_214 vssd1 vssd1 vccd1 vccd1 sky130_fd_sc_hd__decap_3
X_08854_ net470 _03885_ _03882_ cell1.CB_0.config_dataA\[6\] vssd1 vssd1 vccd1 vccd1
+ _03886_ sky130_fd_sc_hd__o211a_1
XFILLER_111_393 vssd1 vssd1 vccd1 vccd1 sky130_fd_sc_hd__fill_4
X_08785_ _03814_ _03815_ _03816_ _02515_ vssd1 vssd1 vccd1 vccd1 _03817_ sky130_fd_sc_hd__a31o_2
X_07805_ _02824_ _02847_ _02849_ vssd1 vssd1 vccd1 vccd1 _02850_ sky130_fd_sc_hd__a21o_1
X_07736_ _02780_ _02782_ vssd1 vssd1 vccd1 vccd1 bus1_0\[3\] sky130_fd_sc_hd__and2_2
XANTENNA__08659__A1 _02444_ vssd1 vssd1 vccd1 vccd1 sky130_fd_sc_hd__diode_2
XANTENNA__10967__Y _05921_ vssd1 vssd1 vccd1 vccd1 sky130_fd_sc_hd__diode_2
XANTENNA_fanout631_A net632 vssd1 vssd1 vccd1 vccd1 sky130_fd_sc_hd__diode_2
XANTENNA_fanout729_A net733 vssd1 vssd1 vccd1 vccd1 sky130_fd_sc_hd__diode_2
X_07667_ cell0.SB0.route_sel\[17\] cell0.SB0.route_sel\[16\] _02711_ _02714_ vssd1
+ vssd1 vccd1 vccd1 _02715_ sky130_fd_sc_hd__a22oi_1
XANTENNA__08437__Y _03473_ vssd1 vssd1 vccd1 vccd1 sky130_fd_sc_hd__diode_2
XTAP_TAPCELL_ROW_36_851 vssd1 vccd1 sky130_fd_sc_hd__tapvpwrvgnd_1
XTAP_TAPCELL_ROW_101_1824 vssd1 vccd1 sky130_fd_sc_hd__tapvpwrvgnd_1
X_09406_ bus3_2\[5\] _04426_ vssd1 vssd1 vccd1 vccd1 _04429_ sky130_fd_sc_hd__and2_1
X_06618_ cell3.SB0.route_sel\[14\] vssd1 vssd1 vccd1 vccd1 _01688_ sky130_fd_sc_hd__inv_2
XPHY_EDGE_ROW_80_Left_223 vssd1 vssd1 vccd1 vccd1 sky130_fd_sc_hd__decap_3
X_07598_ _02647_ vssd1 vssd1 vccd1 vccd1 _02648_ sky130_fd_sc_hd__inv_2
X_09337_ _04353_ _04361_ _04355_ vssd1 vssd1 vccd1 vccd1 _04362_ sky130_fd_sc_hd__a21oi_4
X_06549_ cell2.SB0.route_sel\[61\] vssd1 vssd1 vccd1 vccd1 _01619_ sky130_fd_sc_hd__inv_2
XANTENNA__09084__A1 _03894_ vssd1 vssd1 vccd1 vccd1 sky130_fd_sc_hd__diode_2
X_09268_ cell2.SB0.route_sel\[16\] cell2.SB0.route_sel\[17\] _04293_ vssd1 vssd1 vccd1
+ vccd1 _04294_ sky130_fd_sc_hd__a21oi_1
XANTENNA__09549__X _04568_ vssd1 vssd1 vccd1 vccd1 sky130_fd_sc_hd__diode_2
XANTENNA__09084__B2 _03890_ vssd1 vssd1 vccd1 vccd1 sky130_fd_sc_hd__diode_2
XTAP_TAPCELL_ROW_134_2323 vssd1 vccd1 sky130_fd_sc_hd__tapvpwrvgnd_1
XTAP_TAPCELL_ROW_134_2312 vssd1 vccd1 sky130_fd_sc_hd__tapvpwrvgnd_1
X_08219_ cell0.CB_1.config_dataA\[12\] _03252_ _03255_ _03258_ vssd1 vssd1 vccd1 vccd1
+ _03259_ sky130_fd_sc_hd__a22o_1
XFILLER_126_419 vssd1 vssd1 vccd1 vccd1 sky130_fd_sc_hd__fill_1
X_09199_ cell3.SB0.route_sel\[0\] _01673_ cell3.SB0.route_sel\[3\] _01675_ _04226_
+ vssd1 vssd1 vccd1 vccd1 _04227_ sky130_fd_sc_hd__a221o_1
XFILLER_5_727 vssd1 vssd1 vccd1 vccd1 sky130_fd_sc_hd__fill_1
X_11230_ _06181_ _06178_ _06142_ vssd1 vssd1 vccd1 vccd1 _06182_ sky130_fd_sc_hd__mux2_1
XANTENNA__13687__SET_B net619 vssd1 vssd1 vccd1 vccd1 sky130_fd_sc_hd__diode_2
XFILLER_105_3 vccd1 vssd1 vccd1 vssd1 sky130_ef_sc_hd__decap_40_12
XFILLER_4_248 vssd1 vssd1 vccd1 vccd1 sky130_fd_sc_hd__fill_4
XFILLER_20_20 vssd1 vssd1 vccd1 vccd1 sky130_fd_sc_hd__fill_8
XFILLER_136_53 vccd1 vssd1 vccd1 vssd1 sky130_ef_sc_hd__decap_40_12
X_11161_ _05879_ _06109_ _06110_ _05884_ vssd1 vssd1 vccd1 vccd1 _06113_ sky130_fd_sc_hd__a2bb2o_1
XFILLER_20_53 vssd1 vssd1 vccd1 vccd1 sky130_fd_sc_hd__fill_8
XANTENNA__10941__A2 _05890_ vssd1 vssd1 vccd1 vccd1 sky130_fd_sc_hd__diode_2
X_10112_ _01638_ cell2.SB0.route_sel\[103\] cell2.SB0.route_sel\[100\] _01640_ _05112_
+ vssd1 vssd1 vccd1 vccd1 _05113_ sky130_fd_sc_hd__a221o_2
X_11092_ _01796_ net272 _05849_ vssd1 vssd1 vccd1 vccd1 _06044_ sky130_fd_sc_hd__or3_1
XTAP_TAPCELL_ROW_112_1986 vssd1 vccd1 sky130_fd_sc_hd__tapvpwrvgnd_1
X_10043_ _05043_ _05046_ _05045_ cell2.CB_1.config_dataB\[18\] vssd1 vssd1 vccd1 vccd1
+ _05047_ sky130_fd_sc_hd__and4bb_1
Xhold40 cell0.LE_0A.config_data\[10\] vssd1 vssd1 vccd1 vccd1 net999 sky130_fd_sc_hd__dlygate4sd3_1
XFILLER_76_734 vssd1 vssd1 vccd1 vccd1 sky130_fd_sc_hd__fill_1
XANTENNA__08898__B2 _03894_ vssd1 vssd1 vccd1 vccd1 sky130_fd_sc_hd__diode_2
XANTENNA__08898__A1 _03890_ vssd1 vssd1 vccd1 vccd1 sky130_fd_sc_hd__diode_2
XFILLER_48_425 vssd1 vssd1 vccd1 vccd1 sky130_fd_sc_hd__fill_1
XFILLER_29_51 vssd1 vssd1 vccd1 vccd1 sky130_fd_sc_hd__fill_4
XANTENNA_input25_A CBeast_in[31] vssd1 vssd1 vccd1 vccd1 sky130_fd_sc_hd__diode_2
Xhold62 _00516_ vssd1 vssd1 vccd1 vccd1 net1021 sky130_fd_sc_hd__dlygate4sd3_1
Xhold73 cell1.LE_0B.config_data\[6\] vssd1 vssd1 vccd1 vccd1 net1032 sky130_fd_sc_hd__dlygate4sd3_1
Xhold51 cell1.LE_0B.config_data\[5\] vssd1 vssd1 vccd1 vccd1 net1010 sky130_fd_sc_hd__dlygate4sd3_1
XFILLER_29_84 vssd1 vssd1 vccd1 vccd1 sky130_fd_sc_hd__fill_1
Xhold95 _00878_ vssd1 vssd1 vccd1 vccd1 net1054 sky130_fd_sc_hd__dlygate4sd3_1
Xhold84 cell2.LE_0A.config_data\[5\] vssd1 vssd1 vccd1 vccd1 net1043 sky130_fd_sc_hd__dlygate4sd3_1
XANTENNA__09847__A0 bus3_2\[6\] vssd1 vssd1 vccd1 vccd1 sky130_fd_sc_hd__diode_2
X_13802_ clknet_leaf_112_clk _00774_ net656 vssd1 vssd1 vccd1 vccd1 cell1.SB0.route_sel\[79\]
+ sky130_fd_sc_hd__dfstp_1
X_11994_ cell0.SB0.route_sel\[100\] cell0.SB0.route_sel\[99\] net766 vssd1 vssd1 vccd1
+ vccd1 _00431_ sky130_fd_sc_hd__mux2_1
XPHY_EDGE_ROW_119_Left_262 vssd1 vssd1 vccd1 vccd1 sky130_fd_sc_hd__decap_3
X_10945_ cell3.SB0.route_sel\[37\] cell3.SB0.route_sel\[36\] vssd1 vssd1 vccd1 vccd1
+ _05899_ sky130_fd_sc_hd__and2b_1
X_13733_ clknet_leaf_106_clk _00705_ net660 vssd1 vssd1 vccd1 vccd1 cell1.SB0.route_sel\[10\]
+ sky130_fd_sc_hd__dfstp_1
X_10876_ cell3.LE_1B.config_data\[2\] cell3.LE_1B.config_data\[3\] net292 vssd1 vssd1
+ vccd1 vccd1 _05832_ sky130_fd_sc_hd__mux2_1
X_13664_ clknet_leaf_45_clk _00636_ net630 vssd1 vssd1 vccd1 vccd1 cell2.CB_1.config_dataA\[16\]
+ sky130_fd_sc_hd__dfstp_1
XANTENNA__07873__A2 _02916_ vssd1 vssd1 vccd1 vccd1 sky130_fd_sc_hd__diode_2
XTAP_TAPCELL_ROW_14_512 vssd1 vccd1 sky130_fd_sc_hd__tapvpwrvgnd_1
XANTENNA__10893__X _05847_ vssd1 vssd1 vccd1 vccd1 sky130_fd_sc_hd__diode_2
XANTENNA__09075__A1 bus3_1\[1\] vssd1 vssd1 vccd1 vccd1 sky130_fd_sc_hd__diode_2
X_12615_ cell3.SB0.route_sel\[80\] cell3.SB0.route_sel\[79\] net880 vssd1 vssd1 vccd1
+ vccd1 _01044_ sky130_fd_sc_hd__mux2_1
XTAP_TAPCELL_ROW_14_523 vssd1 vccd1 sky130_fd_sc_hd__tapvpwrvgnd_1
X_13595_ clknet_leaf_88_clk _00567_ net688 vssd1 vssd1 vccd1 vccd1 cell1.LEI0.config_data\[16\]
+ sky130_fd_sc_hd__dfrtp_1
X_12546_ cell3.SB0.route_sel\[11\] cell3.SB0.route_sel\[10\] net935 vssd1 vssd1 vccd1
+ vccd1 _00975_ sky130_fd_sc_hd__mux2_1
X_12477_ net1091 net1039 net824 vssd1 vssd1 vccd1 vccd1 _00907_ sky130_fd_sc_hd__mux2_1
XFILLER_8_598 vssd1 vssd1 vccd1 vccd1 sky130_fd_sc_hd__fill_1
XANTENNA__08523__B _03529_ vssd1 vssd1 vccd1 vccd1 sky130_fd_sc_hd__diode_2
XPHY_EDGE_ROW_128_Left_271 vssd1 vssd1 vccd1 vccd1 sky130_fd_sc_hd__decap_3
X_14216_ clknet_leaf_15_clk _01188_ net625 vssd1 vssd1 vccd1 vccd1 cell2.SB0.route_sel\[1\]
+ sky130_fd_sc_hd__dfstp_1
XANTENNA_4 _00505_ vssd1 vssd1 vccd1 vccd1 sky130_fd_sc_hd__diode_2
X_11428_ _01482_ cell0.SB0.route_sel\[113\] _01486_ cell0.SB0.route_sel\[114\] _06285_
+ vssd1 vssd1 vccd1 vccd1 _06286_ sky130_fd_sc_hd__o221a_1
X_11359_ clknet_leaf_66_clk cell3.LE_1B.edge_mode vssd1 vssd1 vccd1 vccd1 cell3.LE_1B.sel_clk
+ sky130_fd_sc_hd__xnor2_2
X_14147_ clknet_leaf_68_clk _01119_ net727 vssd1 vssd1 vccd1 vccd1 cell3.CB_1.config_dataA\[7\]
+ sky130_fd_sc_hd__dfstp_1
XTAP_TAPCELL_ROW_74_1425 vssd1 vccd1 sky130_fd_sc_hd__tapvpwrvgnd_1
XTAP_TAPCELL_ROW_74_1414 vssd1 vccd1 sky130_fd_sc_hd__tapvpwrvgnd_1
XANTENNA__07928__A3 bus2_0\[11\] vssd1 vssd1 vccd1 vccd1 sky130_fd_sc_hd__diode_2
XFILLER_6_77 vssd1 vssd1 vccd1 vccd1 sky130_fd_sc_hd__fill_4
XANTENNA__09194__X _04222_ vssd1 vssd1 vccd1 vccd1 sky130_fd_sc_hd__diode_2
XANTENNA__09871__A_N _04527_ vssd1 vssd1 vccd1 vccd1 sky130_fd_sc_hd__diode_2
XFILLER_3_281 vccd1 vssd1 vccd1 vssd1 sky130_ef_sc_hd__decap_40_12
X_14078_ clknet_leaf_82_clk _01050_ net670 vssd1 vssd1 vccd1 vccd1 cell3.SB0.route_sel\[86\]
+ sky130_fd_sc_hd__dfstp_1
XANTENNA__10284__A1_N _05139_ vssd1 vssd1 vccd1 vccd1 sky130_fd_sc_hd__diode_2
X_13029_ clknet_leaf_119_clk net1205 net595 vssd1 vssd1 vccd1 vccd1 cell0.LE_1B.config_data\[1\]
+ sky130_fd_sc_hd__dfrtp_1
XANTENNA__09550__A2 _04568_ vssd1 vssd1 vccd1 vccd1 sky130_fd_sc_hd__diode_2
XANTENNA_clkbuf_leaf_6_clk_A clknet_4_1_0_clk vssd1 vssd1 vccd1 vccd1 sky130_fd_sc_hd__diode_2
X_08570_ net31 net32 net2 net3 net492 net490 vssd1 vssd1 vccd1 vccd1 _03606_ sky130_fd_sc_hd__mux4_1
XANTENNA__12437__A2 net549 vssd1 vssd1 vccd1 vccd1 sky130_fd_sc_hd__diode_2
XPHY_EDGE_ROW_137_Left_280 vssd1 vssd1 vccd1 vccd1 sky130_fd_sc_hd__decap_3
X_07521_ _01970_ _02365_ vssd1 vssd1 vccd1 vccd1 _02573_ sky130_fd_sc_hd__or2_1
XTAP_TAPCELL_ROW_85_1576 vssd1 vccd1 sky130_fd_sc_hd__tapvpwrvgnd_1
XFILLER_81_269 vssd1 vssd1 vccd1 vccd1 sky130_fd_sc_hd__fill_1
XANTENNA__07313__B2 net330 vssd1 vssd1 vccd1 vccd1 sky130_fd_sc_hd__diode_2
XTAP_TAPCELL_ROW_85_1587 vssd1 vccd1 sky130_fd_sc_hd__tapvpwrvgnd_1
XTAP_TAPCELL_ROW_33_810 vssd1 vccd1 sky130_fd_sc_hd__tapvpwrvgnd_1
XFILLER_35_697 vssd1 vssd1 vccd1 vccd1 sky130_fd_sc_hd__fill_4
X_07452_ _02502_ _02504_ _02505_ vssd1 vssd1 vccd1 vccd1 _02506_ sky130_fd_sc_hd__a21o_1
X_07383_ _02153_ _02367_ vssd1 vssd1 vccd1 vccd1 _02439_ sky130_fd_sc_hd__or2_1
X_06403_ cell0.SB0.route_sel\[83\] vssd1 vssd1 vccd1 vccd1 _01473_ sky130_fd_sc_hd__inv_2
X_09122_ _04151_ vssd1 vssd1 vccd1 vccd1 _04152_ sky130_fd_sc_hd__inv_2
XANTENNA__08274__C1 net351 vssd1 vssd1 vccd1 vccd1 sky130_fd_sc_hd__diode_2
XTAP_TAPCELL_ROW_116_2053 vssd1 vccd1 sky130_fd_sc_hd__tapvpwrvgnd_1
XTAP_TAPCELL_ROW_116_2042 vssd1 vccd1 sky130_fd_sc_hd__tapvpwrvgnd_1
XFILLER_108_419 vssd1 vssd1 vccd1 vccd1 sky130_fd_sc_hd__fill_1
X_09053_ cell1.LEI0.config_data\[3\] _01821_ _04082_ cell1.LEI0.config_data\[4\] vssd1
+ vssd1 vccd1 vccd1 _04083_ sky130_fd_sc_hd__o211a_1
Xhold510 cell3.LEI0.config_data\[41\] vssd1 vssd1 vccd1 vccd1 net1469 sky130_fd_sc_hd__dlygate4sd3_1
X_08004_ _03041_ _03042_ _03044_ _03045_ vssd1 vssd1 vccd1 vccd1 _03046_ sky130_fd_sc_hd__o22a_1
XANTENNA__08433__B _03468_ vssd1 vssd1 vccd1 vccd1 sky130_fd_sc_hd__diode_2
Xhold521 cell2.LE_1A.dff1_out vssd1 vssd1 vccd1 vccd1 net1480 sky130_fd_sc_hd__dlygate4sd3_1
Xhold543 cell2.LEI0.config_data\[44\] vssd1 vssd1 vccd1 vccd1 net1502 sky130_fd_sc_hd__dlygate4sd3_1
XFILLER_104_614 vssd1 vssd1 vccd1 vccd1 sky130_fd_sc_hd__fill_1
XANTENNA__07919__A3 bus2_0\[3\] vssd1 vssd1 vccd1 vccd1 sky130_fd_sc_hd__diode_2
Xhold532 _00191_ vssd1 vssd1 vccd1 vccd1 net1491 sky130_fd_sc_hd__dlygate4sd3_1
Xhold554 cell1.LEI0.config_data\[37\] vssd1 vssd1 vccd1 vccd1 net1513 sky130_fd_sc_hd__dlygate4sd3_1
Xhold565 cell3.LEI0.config_data\[28\] vssd1 vssd1 vccd1 vccd1 net1524 sky130_fd_sc_hd__dlygate4sd3_1
Xhold576 cell1.LE_1A.reset_val vssd1 vssd1 vccd1 vccd1 net1535 sky130_fd_sc_hd__dlygate4sd3_1
Xhold587 cell1.LE_0A.reset_val vssd1 vssd1 vccd1 vccd1 net1546 sky130_fd_sc_hd__dlygate4sd3_1
X_09955_ bus3_2\[0\] bus3_2\[2\] bus3_2\[1\] bus3_2\[3\] net405 net406 vssd1 vssd1
+ vccd1 vccd1 _04959_ sky130_fd_sc_hd__mux4_1
XFILLER_89_358 vssd1 vssd1 vccd1 vccd1 sky130_fd_sc_hd__fill_1
XANTENNA_fanout581_A net602 vssd1 vssd1 vccd1 vccd1 sky130_fd_sc_hd__diode_2
X_09886_ _04891_ vssd1 vssd1 vccd1 vccd1 _04892_ sky130_fd_sc_hd__inv_2
X_08906_ net467 _03881_ vssd1 vssd1 vccd1 vccd1 _03938_ sky130_fd_sc_hd__nand2_1
X_08837_ cell1.SB0.route_sel\[13\] cell1.SB0.route_sel\[12\] vssd1 vssd1 vccd1 vccd1
+ _03869_ sky130_fd_sc_hd__nand2b_1
XANTENNA_fanout846_A net854 vssd1 vssd1 vccd1 vccd1 sky130_fd_sc_hd__diode_2
XANTENNA__10203__B _05084_ vssd1 vssd1 vccd1 vccd1 sky130_fd_sc_hd__diode_2
XFILLER_73_737 vssd1 vssd1 vccd1 vccd1 sky130_fd_sc_hd__fill_1
X_08768_ cell1.LE_1B.config_data\[1\] cell1.LE_1B.config_data\[0\] _03735_ vssd1 vssd1
+ vccd1 vccd1 _03802_ sky130_fd_sc_hd__mux2_1
X_08699_ _03732_ vssd1 vssd1 vccd1 vccd1 _03733_ sky130_fd_sc_hd__inv_2
X_07719_ net75 _02763_ vssd1 vssd1 vccd1 vccd1 _02766_ sky130_fd_sc_hd__nand2_1
XANTENNA__07304__A1 net4 vssd1 vssd1 vccd1 vccd1 sky130_fd_sc_hd__diode_2
X_10730_ cell3.LE_1A.dff0_out cell3.LE_1A.dff1_out cell3.LE_1A.reset_val vssd1 vssd1
+ vccd1 vccd1 cell3.LE_1A.dff_out sky130_fd_sc_hd__mux2_1
XANTENNA__07855__A2 _02894_ vssd1 vssd1 vccd1 vccd1 sky130_fd_sc_hd__diode_2
XFILLER_41_623 vssd1 vssd1 vccd1 vccd1 sky130_fd_sc_hd__fill_1
XFILLER_40_100 vssd1 vssd1 vccd1 vccd1 sky130_fd_sc_hd__fill_1
XTAP_TAPCELL_ROW_0_295 vssd1 vccd1 sky130_fd_sc_hd__tapvpwrvgnd_1
X_10661_ cell3.CB_1.config_dataA\[13\] cell3.CB_1.config_dataA\[12\] vssd1 vssd1 vccd1
+ vccd1 _05619_ sky130_fd_sc_hd__or2_1
X_12400_ net404 cell2.CB_1.config_dataB\[9\] net846 vssd1 vssd1 vccd1 vccd1 _00833_
+ sky130_fd_sc_hd__mux2_1
X_10592_ net273 _05548_ _05491_ vssd1 vssd1 vccd1 vccd1 _05550_ sky130_fd_sc_hd__a21o_1
X_13380_ clknet_leaf_132_clk _00352_ net559 vssd1 vssd1 vccd1 vccd1 cell0.SB0.route_sel\[21\]
+ sky130_fd_sc_hd__dfstp_1
XFILLER_21_391 vssd1 vssd1 vccd1 vccd1 sky130_fd_sc_hd__fill_1
X_12331_ cell1.SB0.route_sel\[69\] cell1.SB0.route_sel\[68\] net869 vssd1 vssd1 vccd1
+ vccd1 _00764_ sky130_fd_sc_hd__mux2_1
XFILLER_107_430 vssd1 vssd1 vccd1 vccd1 sky130_fd_sc_hd__fill_1
X_12262_ cell1.SB0.route_sel\[0\] cell1.CB_1.config_dataB\[24\] net885 vssd1 vssd1
+ vccd1 vccd1 _00695_ sky130_fd_sc_hd__mux2_1
XFILLER_135_783 vssd1 vssd1 vccd1 vccd1 sky130_fd_sc_hd__fill_1
X_11213_ _06163_ _06164_ _01801_ vssd1 vssd1 vccd1 vccd1 _06165_ sky130_fd_sc_hd__mux2_1
X_14001_ clknet_leaf_75_clk _00973_ net725 vssd1 vssd1 vccd1 vccd1 cell3.SB0.route_sel\[9\]
+ sky130_fd_sc_hd__dfstp_1
XFILLER_5_557 vssd1 vssd1 vccd1 vccd1 sky130_fd_sc_hd__fill_2
XANTENNA__10375__A0 net63 vssd1 vssd1 vccd1 vccd1 sky130_fd_sc_hd__diode_2
X_12193_ cell2.CB_1.config_dataA\[6\] net445 net924 vssd1 vssd1 vccd1 vccd1 _00626_
+ sky130_fd_sc_hd__mux2_1
XTAP_TAPCELL_ROW_56_1155 vssd1 vccd1 sky130_fd_sc_hd__tapvpwrvgnd_1
XTAP_TAPCELL_ROW_56_1144 vssd1 vccd1 sky130_fd_sc_hd__tapvpwrvgnd_1
X_11144_ net45 _06078_ _06080_ net46 cell3.CB_0.config_dataB\[8\] vssd1 vssd1 vccd1
+ vccd1 _06096_ sky130_fd_sc_hd__a221o_1
X_11075_ _06027_ _06028_ _05961_ vssd1 vssd1 vccd1 vccd1 _06029_ sky130_fd_sc_hd__mux2_1
XFILLER_1_785 vssd1 vssd1 vccd1 vccd1 sky130_fd_sc_hd__fill_8
Xinput130 config_en vssd1 vssd1 vccd1 vccd1 net130 sky130_fd_sc_hd__clkbuf_2
X_10026_ cell2.CB_1.config_dataB\[14\] _04996_ _05012_ _05029_ vssd1 vssd1 vccd1 vccd1
+ _05030_ sky130_fd_sc_hd__a31oi_4
XANTENNA_input28_X net28 vssd1 vssd1 vccd1 vccd1 sky130_fd_sc_hd__diode_2
XANTENNA__09742__X bus2_0\[3\] vssd1 vssd1 vccd1 vccd1 sky130_fd_sc_hd__diode_2
XANTENNA__10113__B _05113_ vssd1 vssd1 vccd1 vccd1 sky130_fd_sc_hd__diode_2
XANTENNA__07543__A1 bus3_2\[15\] vssd1 vssd1 vccd1 vccd1 sky130_fd_sc_hd__diode_2
XFILLER_49_789 vssd1 vssd1 vccd1 vccd1 sky130_fd_sc_hd__fill_2
X_11977_ cell0.SB0.route_sel\[83\] cell0.SB0.route_sel\[82\] net785 vssd1 vssd1 vccd1
+ vccd1 _00414_ sky130_fd_sc_hd__mux2_1
X_13716_ clknet_leaf_28_clk _00688_ net618 vssd1 vssd1 vccd1 vccd1 cell2.CB_0.config_dataA\[18\]
+ sky130_fd_sc_hd__dfstp_1
XANTENNA__09835__A3 bus3_2\[15\] vssd1 vssd1 vccd1 vccd1 sky130_fd_sc_hd__diode_2
X_10928_ _01726_ cell3.SB0.route_sel\[79\] _01727_ cell3.SB0.route_sel\[76\] _05881_
+ vssd1 vssd1 vccd1 vccd1 _05882_ sky130_fd_sc_hd__a221o_1
XANTENNA__10850__A1 net20 vssd1 vssd1 vccd1 vccd1 sky130_fd_sc_hd__diode_2
X_13647_ clknet_leaf_36_clk _00619_ net646 vssd1 vssd1 vccd1 vccd1 cell2.LE_1B.reset_mode
+ sky130_fd_sc_hd__dfrtp_1
X_10859_ net13 _05796_ _05798_ net14 cell3.CB_1.config_dataB\[18\] vssd1 vssd1 vccd1
+ vccd1 _05815_ sky130_fd_sc_hd__a221o_1
XANTENNA__11512__X _06342_ vssd1 vssd1 vccd1 vccd1 sky130_fd_sc_hd__diode_2
XFILLER_31_177 vssd1 vssd1 vccd1 vccd1 sky130_fd_sc_hd__fill_1
X_13578_ clknet_1_0__leaf_cell1.LE_0A.sel_clk _00550_ net751 vssd1 vssd1 vccd1 vccd1
+ cell1.LE_0A.dff0_out sky130_fd_sc_hd__dfrtp_1
X_12529_ cell2.LEI0.config_data\[43\] cell2.LEI0.config_data\[42\] net838 vssd1 vssd1
+ vccd1 vccd1 _00958_ sky130_fd_sc_hd__mux2_1
XANTENNA__09917__X cell2.CB_1.le_outA vssd1 vssd1 vccd1 vccd1 sky130_fd_sc_hd__diode_2
XFILLER_68_3 vssd1 vssd1 vccd1 vccd1 sky130_fd_sc_hd__fill_1
XANTENNA__08821__X _03853_ vssd1 vssd1 vccd1 vccd1 sky130_fd_sc_hd__diode_2
XFILLER_141_775 vssd1 vssd1 vccd1 vccd1 sky130_fd_sc_hd__fill_8
Xfanout308 cell2.CB_0.le_outB vssd1 vssd1 vccd1 vccd1 net308 sky130_fd_sc_hd__buf_2
XANTENNA__09771__A2 bus3_2\[1\] vssd1 vssd1 vccd1 vccd1 sky130_fd_sc_hd__diode_2
XFILLER_141_797 vccd1 vssd1 vccd1 vssd1 sky130_ef_sc_hd__decap_40_12
XANTENNA__10118__A0 net63 vssd1 vssd1 vccd1 vccd1 sky130_fd_sc_hd__diode_2
XFILLER_101_617 vssd1 vssd1 vccd1 vccd1 sky130_fd_sc_hd__fill_2
XFILLER_98_199 vssd1 vssd1 vccd1 vccd1 sky130_fd_sc_hd__fill_8
X_09740_ cell2.SB0.route_sel\[25\] cell2.SB0.route_sel\[24\] vssd1 vssd1 vccd1 vccd1
+ _04749_ sky130_fd_sc_hd__nand2b_1
XFILLER_39_200 vssd1 vssd1 vccd1 vccd1 sky130_fd_sc_hd__fill_1
X_06952_ _02011_ _02012_ net348 vssd1 vssd1 vccd1 vccd1 _02018_ sky130_fd_sc_hd__and3b_1
.ends
