* NGSPICE file created from team_07.ext - technology: sky130A

* Black-box entry subcircuit for sky130_fd_sc_hd__fill_2 abstract view
.subckt sky130_fd_sc_hd__fill_2 VGND VNB VPB VPWR
.ends

* Black-box entry subcircuit for sky130_fd_sc_hd__tapvpwrvgnd_1 abstract view
.subckt sky130_fd_sc_hd__tapvpwrvgnd_1 VGND VPWR
.ends

* Black-box entry subcircuit for sky130_fd_sc_hd__dfrtp_2 abstract view
.subckt sky130_fd_sc_hd__dfrtp_2 CLK D RESET_B VGND VNB VPB VPWR Q
.ends

* Black-box entry subcircuit for sky130_fd_sc_hd__inv_2 abstract view
.subckt sky130_fd_sc_hd__inv_2 A VGND VNB VPB VPWR Y
.ends

* Black-box entry subcircuit for sky130_fd_sc_hd__dlygate4sd3_1 abstract view
.subckt sky130_fd_sc_hd__dlygate4sd3_1 A VGND VNB VPB VPWR X
.ends

* Black-box entry subcircuit for sky130_fd_sc_hd__or2_2 abstract view
.subckt sky130_fd_sc_hd__or2_2 A B VGND VNB VPB VPWR X
.ends

* Black-box entry subcircuit for sky130_fd_sc_hd__clkbuf_8 abstract view
.subckt sky130_fd_sc_hd__clkbuf_8 A VGND VNB VPB VPWR X
.ends

* Black-box entry subcircuit for sky130_fd_sc_hd__diode_2 abstract view
.subckt sky130_fd_sc_hd__diode_2 DIODE VGND VNB VPB VPWR
.ends

* Black-box entry subcircuit for sky130_fd_sc_hd__fill_4 abstract view
.subckt sky130_fd_sc_hd__fill_4 VGND VNB VPB VPWR
.ends

* Black-box entry subcircuit for sky130_fd_sc_hd__a22o_2 abstract view
.subckt sky130_fd_sc_hd__a22o_2 A1 A2 B1 B2 VGND VNB VPB VPWR X
.ends

* Black-box entry subcircuit for sky130_fd_sc_hd__fill_1 abstract view
.subckt sky130_fd_sc_hd__fill_1 VGND VNB VPB VPWR
.ends

* Black-box entry subcircuit for sky130_fd_sc_hd__nand2_2 abstract view
.subckt sky130_fd_sc_hd__nand2_2 A B VGND VNB VPB VPWR Y
.ends

* Black-box entry subcircuit for sky130_fd_sc_hd__a21o_2 abstract view
.subckt sky130_fd_sc_hd__a21o_2 A1 A2 B1 VGND VNB VPB VPWR X
.ends

* Black-box entry subcircuit for sky130_fd_sc_hd__decap_3 abstract view
.subckt sky130_fd_sc_hd__decap_3 VGND VNB VPB VPWR
.ends

* Black-box entry subcircuit for sky130_fd_sc_hd__a221o_2 abstract view
.subckt sky130_fd_sc_hd__a221o_2 A1 A2 B1 B2 C1 VGND VNB VPB VPWR X
.ends

* Black-box entry subcircuit for sky130_fd_sc_hd__a21oi_2 abstract view
.subckt sky130_fd_sc_hd__a21oi_2 A1 A2 B1 VGND VNB VPB VPWR Y
.ends

* Black-box entry subcircuit for sky130_ef_sc_hd__decap_40_12 abstract view
.subckt sky130_ef_sc_hd__decap_40_12 VNB VPB VGND VPWR
.ends

* Black-box entry subcircuit for sky130_fd_sc_hd__fill_8 abstract view
.subckt sky130_fd_sc_hd__fill_8 VGND VNB VPB VPWR
.ends

* Black-box entry subcircuit for sky130_fd_sc_hd__and2_2 abstract view
.subckt sky130_fd_sc_hd__and2_2 A B VGND VNB VPB VPWR X
.ends

* Black-box entry subcircuit for sky130_fd_sc_hd__mux2_1 abstract view
.subckt sky130_fd_sc_hd__mux2_1 A0 A1 S VGND VNB VPB VPWR X
.ends

* Black-box entry subcircuit for sky130_fd_sc_hd__clkdlybuf4s25_1 abstract view
.subckt sky130_fd_sc_hd__clkdlybuf4s25_1 A VGND VNB VPB VPWR X
.ends

* Black-box entry subcircuit for sky130_fd_sc_hd__dfstp_2 abstract view
.subckt sky130_fd_sc_hd__dfstp_2 CLK D SET_B VGND VNB VPB VPWR Q
.ends

* Black-box entry subcircuit for sky130_fd_sc_hd__and4_2 abstract view
.subckt sky130_fd_sc_hd__and4_2 A B C D VGND VNB VPB VPWR X
.ends

* Black-box entry subcircuit for sky130_fd_sc_hd__xnor2_2 abstract view
.subckt sky130_fd_sc_hd__xnor2_2 A B VGND VNB VPB VPWR Y
.ends

* Black-box entry subcircuit for sky130_fd_sc_hd__and3_2 abstract view
.subckt sky130_fd_sc_hd__and3_2 A B C VGND VNB VPB VPWR X
.ends

* Black-box entry subcircuit for sky130_fd_sc_hd__clkbuf_4 abstract view
.subckt sky130_fd_sc_hd__clkbuf_4 A VGND VNB VPB VPWR X
.ends

* Black-box entry subcircuit for sky130_fd_sc_hd__buf_2 abstract view
.subckt sky130_fd_sc_hd__buf_2 A VGND VNB VPB VPWR X
.ends

* Black-box entry subcircuit for sky130_fd_sc_hd__o31ai_2 abstract view
.subckt sky130_fd_sc_hd__o31ai_2 A1 A2 A3 B1 VGND VNB VPB VPWR Y
.ends

* Black-box entry subcircuit for sky130_fd_sc_hd__o221a_2 abstract view
.subckt sky130_fd_sc_hd__o221a_2 A1 A2 B1 B2 C1 VGND VNB VPB VPWR X
.ends

* Black-box entry subcircuit for sky130_fd_sc_hd__o21a_2 abstract view
.subckt sky130_fd_sc_hd__o21a_2 A1 A2 B1 VGND VNB VPB VPWR X
.ends

* Black-box entry subcircuit for sky130_fd_sc_hd__and3b_2 abstract view
.subckt sky130_fd_sc_hd__and3b_2 A_N B C VGND VNB VPB VPWR X
.ends

* Black-box entry subcircuit for sky130_fd_sc_hd__a211o_2 abstract view
.subckt sky130_fd_sc_hd__a211o_2 A1 A2 B1 C1 VGND VNB VPB VPWR X
.ends

* Black-box entry subcircuit for sky130_fd_sc_hd__or3_2 abstract view
.subckt sky130_fd_sc_hd__or3_2 A B C VGND VNB VPB VPWR X
.ends

* Black-box entry subcircuit for sky130_fd_sc_hd__o21ba_2 abstract view
.subckt sky130_fd_sc_hd__o21ba_2 A1 A2 B1_N VGND VNB VPB VPWR X
.ends

* Black-box entry subcircuit for sky130_fd_sc_hd__and4bb_2 abstract view
.subckt sky130_fd_sc_hd__and4bb_2 A_N B_N C D VGND VNB VPB VPWR X
.ends

* Black-box entry subcircuit for sky130_fd_sc_hd__nor2_2 abstract view
.subckt sky130_fd_sc_hd__nor2_2 A B VGND VNB VPB VPWR Y
.ends

* Black-box entry subcircuit for sky130_fd_sc_hd__a2111oi_2 abstract view
.subckt sky130_fd_sc_hd__a2111oi_2 A1 A2 B1 C1 D1 VGND VNB VPB VPWR Y
.ends

* Black-box entry subcircuit for sky130_fd_sc_hd__or4b_2 abstract view
.subckt sky130_fd_sc_hd__or4b_2 A B C D_N VGND VNB VPB VPWR X
.ends

* Black-box entry subcircuit for sky130_fd_sc_hd__o2111a_2 abstract view
.subckt sky130_fd_sc_hd__o2111a_2 A1 A2 B1 C1 D1 VGND VNB VPB VPWR X
.ends

* Black-box entry subcircuit for sky130_fd_sc_hd__o21ai_2 abstract view
.subckt sky130_fd_sc_hd__o21ai_2 A1 A2 B1 VGND VNB VPB VPWR Y
.ends

* Black-box entry subcircuit for sky130_fd_sc_hd__o211a_2 abstract view
.subckt sky130_fd_sc_hd__o211a_2 A1 A2 B1 C1 VGND VNB VPB VPWR X
.ends

* Black-box entry subcircuit for sky130_fd_sc_hd__or4_2 abstract view
.subckt sky130_fd_sc_hd__or4_2 A B C D VGND VNB VPB VPWR X
.ends

* Black-box entry subcircuit for sky130_fd_sc_hd__nor3_2 abstract view
.subckt sky130_fd_sc_hd__nor3_2 A B C VGND VNB VPB VPWR Y
.ends

* Black-box entry subcircuit for sky130_fd_sc_hd__o22a_2 abstract view
.subckt sky130_fd_sc_hd__o22a_2 A1 A2 B1 B2 VGND VNB VPB VPWR X
.ends

* Black-box entry subcircuit for sky130_fd_sc_hd__xor2_2 abstract view
.subckt sky130_fd_sc_hd__xor2_2 A B VGND VNB VPB VPWR X
.ends

* Black-box entry subcircuit for sky130_fd_sc_hd__a31o_2 abstract view
.subckt sky130_fd_sc_hd__a31o_2 A1 A2 A3 B1 VGND VNB VPB VPWR X
.ends

* Black-box entry subcircuit for sky130_fd_sc_hd__clkbuf_16 abstract view
.subckt sky130_fd_sc_hd__clkbuf_16 A VGND VNB VPB VPWR X
.ends

* Black-box entry subcircuit for sky130_fd_sc_hd__o2bb2a_2 abstract view
.subckt sky130_fd_sc_hd__o2bb2a_2 A1_N A2_N B1 B2 VGND VNB VPB VPWR X
.ends

* Black-box entry subcircuit for sky130_fd_sc_hd__nand2b_2 abstract view
.subckt sky130_fd_sc_hd__nand2b_2 A_N B VGND VNB VPB VPWR Y
.ends

* Black-box entry subcircuit for sky130_fd_sc_hd__buf_4 abstract view
.subckt sky130_fd_sc_hd__buf_4 A VGND VNB VPB VPWR X
.ends

* Black-box entry subcircuit for sky130_fd_sc_hd__a32o_2 abstract view
.subckt sky130_fd_sc_hd__a32o_2 A1 A2 A3 B1 B2 VGND VNB VPB VPWR X
.ends

* Black-box entry subcircuit for sky130_fd_sc_hd__o221ai_2 abstract view
.subckt sky130_fd_sc_hd__o221ai_2 A1 A2 B1 B2 C1 VGND VNB VPB VPWR Y
.ends

* Black-box entry subcircuit for sky130_fd_sc_hd__or4bb_2 abstract view
.subckt sky130_fd_sc_hd__or4bb_2 A B C_N D_N VGND VNB VPB VPWR X
.ends

* Black-box entry subcircuit for sky130_fd_sc_hd__a41oi_2 abstract view
.subckt sky130_fd_sc_hd__a41oi_2 A1 A2 A3 A4 B1 VGND VNB VPB VPWR Y
.ends

* Black-box entry subcircuit for sky130_fd_sc_hd__o32a_2 abstract view
.subckt sky130_fd_sc_hd__o32a_2 A1 A2 A3 B1 B2 VGND VNB VPB VPWR X
.ends

* Black-box entry subcircuit for sky130_fd_sc_hd__a2bb2o_2 abstract view
.subckt sky130_fd_sc_hd__a2bb2o_2 A1_N A2_N B1 B2 VGND VNB VPB VPWR X
.ends

* Black-box entry subcircuit for sky130_fd_sc_hd__o32ai_2 abstract view
.subckt sky130_fd_sc_hd__o32ai_2 A1 A2 A3 B1 B2 VGND VNB VPB VPWR Y
.ends

* Black-box entry subcircuit for sky130_fd_sc_hd__and2b_2 abstract view
.subckt sky130_fd_sc_hd__and2b_2 A_N B VGND VNB VPB VPWR X
.ends

* Black-box entry subcircuit for sky130_fd_sc_hd__o31a_2 abstract view
.subckt sky130_fd_sc_hd__o31a_2 A1 A2 A3 B1 VGND VNB VPB VPWR X
.ends

* Black-box entry subcircuit for sky130_fd_sc_hd__a2111o_2 abstract view
.subckt sky130_fd_sc_hd__a2111o_2 A1 A2 B1 C1 D1 VGND VNB VPB VPWR X
.ends

* Black-box entry subcircuit for sky130_fd_sc_hd__nand3_2 abstract view
.subckt sky130_fd_sc_hd__nand3_2 A B C VGND VNB VPB VPWR Y
.ends

* Black-box entry subcircuit for sky130_fd_sc_hd__or3b_2 abstract view
.subckt sky130_fd_sc_hd__or3b_2 A B C_N VGND VNB VPB VPWR X
.ends

* Black-box entry subcircuit for sky130_fd_sc_hd__nand3b_2 abstract view
.subckt sky130_fd_sc_hd__nand3b_2 A_N B C VGND VNB VPB VPWR Y
.ends

* Black-box entry subcircuit for sky130_fd_sc_hd__nand4_2 abstract view
.subckt sky130_fd_sc_hd__nand4_2 A B C D VGND VNB VPB VPWR Y
.ends

* Black-box entry subcircuit for sky130_fd_sc_hd__conb_1 abstract view
.subckt sky130_fd_sc_hd__conb_1 VGND VNB VPB VPWR HI LO
.ends

* Black-box entry subcircuit for sky130_fd_sc_hd__buf_1 abstract view
.subckt sky130_fd_sc_hd__buf_1 A VGND VNB VPB VPWR X
.ends

* Black-box entry subcircuit for sky130_fd_sc_hd__a21bo_2 abstract view
.subckt sky130_fd_sc_hd__a21bo_2 A1 A2 B1_N VGND VNB VPB VPWR X
.ends

* Black-box entry subcircuit for sky130_fd_sc_hd__a22oi_2 abstract view
.subckt sky130_fd_sc_hd__a22oi_2 A1 A2 B1 B2 VGND VNB VPB VPWR Y
.ends

* Black-box entry subcircuit for sky130_fd_sc_hd__o311a_2 abstract view
.subckt sky130_fd_sc_hd__o311a_2 A1 A2 A3 B1 C1 VGND VNB VPB VPWR X
.ends

* Black-box entry subcircuit for sky130_fd_sc_hd__o22ai_2 abstract view
.subckt sky130_fd_sc_hd__o22ai_2 A1 A2 B1 B2 VGND VNB VPB VPWR Y
.ends

* Black-box entry subcircuit for sky130_fd_sc_hd__o2111ai_2 abstract view
.subckt sky130_fd_sc_hd__o2111ai_2 A1 A2 B1 C1 D1 VGND VNB VPB VPWR Y
.ends

* Black-box entry subcircuit for sky130_fd_sc_hd__o21bai_2 abstract view
.subckt sky130_fd_sc_hd__o21bai_2 A1 A2 B1_N VGND VNB VPB VPWR Y
.ends

* Black-box entry subcircuit for sky130_fd_sc_hd__a31oi_2 abstract view
.subckt sky130_fd_sc_hd__a31oi_2 A1 A2 A3 B1 VGND VNB VPB VPWR Y
.ends

* Black-box entry subcircuit for sky130_fd_sc_hd__and4b_2 abstract view
.subckt sky130_fd_sc_hd__and4b_2 A_N B C D VGND VNB VPB VPWR X
.ends

* Black-box entry subcircuit for sky130_fd_sc_hd__a311oi_2 abstract view
.subckt sky130_fd_sc_hd__a311oi_2 A1 A2 A3 B1 C1 VGND VNB VPB VPWR Y
.ends

.subckt team_07 clk en gpio_in[0] gpio_in[10] gpio_in[11] gpio_in[12] gpio_in[13]
+ gpio_in[14] gpio_in[15] gpio_in[16] gpio_in[17] gpio_in[18] gpio_in[19] gpio_in[1]
+ gpio_in[20] gpio_in[21] gpio_in[22] gpio_in[23] gpio_in[24] gpio_in[25] gpio_in[26]
+ gpio_in[27] gpio_in[28] gpio_in[29] gpio_in[2] gpio_in[30] gpio_in[31] gpio_in[32]
+ gpio_in[33] gpio_in[3] gpio_in[4] gpio_in[5] gpio_in[6] gpio_in[7] gpio_in[8] gpio_in[9]
+ gpio_oeb[0] gpio_oeb[10] gpio_oeb[11] gpio_oeb[12] gpio_oeb[13] gpio_oeb[14] gpio_oeb[15]
+ gpio_oeb[16] gpio_oeb[17] gpio_oeb[18] gpio_oeb[19] gpio_oeb[1] gpio_oeb[20] gpio_oeb[21]
+ gpio_oeb[22] gpio_oeb[23] gpio_oeb[24] gpio_oeb[25] gpio_oeb[26] gpio_oeb[27] gpio_oeb[28]
+ gpio_oeb[29] gpio_oeb[2] gpio_oeb[30] gpio_oeb[31] gpio_oeb[32] gpio_oeb[33] gpio_oeb[3]
+ gpio_oeb[4] gpio_oeb[5] gpio_oeb[6] gpio_oeb[7] gpio_oeb[8] gpio_oeb[9] gpio_out[0]
+ gpio_out[10] gpio_out[11] gpio_out[12] gpio_out[13] gpio_out[14] gpio_out[15] gpio_out[16]
+ gpio_out[17] gpio_out[18] gpio_out[19] gpio_out[1] gpio_out[20] gpio_out[21] gpio_out[22]
+ gpio_out[23] gpio_out[24] gpio_out[25] gpio_out[26] gpio_out[27] gpio_out[28] gpio_out[29]
+ gpio_out[2] gpio_out[30] gpio_out[31] gpio_out[32] gpio_out[33] gpio_out[3] gpio_out[4]
+ gpio_out[5] gpio_out[6] gpio_out[7] gpio_out[8] gpio_out[9] nrst vccd1 vssd1
XFILLER_22_155 vssd1 vssd1 vccd1 vccd1 sky130_fd_sc_hd__fill_2
XTAP_TAPCELL_ROW_9_126 vssd1 vccd1 sky130_fd_sc_hd__tapvpwrvgnd_1
XFILLER_26_85 vssd1 vssd1 vccd1 vccd1 sky130_fd_sc_hd__fill_2
X_0985_ clkload8/A _0985_/D load_slew39/X vssd1 vssd1 vccd1 vccd1 _0985_/Q sky130_fd_sc_hd__dfrtp_2
X_0419_ _0419_/A vssd1 vssd1 vccd1 vccd1 _0662_/A sky130_fd_sc_hd__inv_2
XFILLER_10_169 vssd1 vssd1 vccd1 vccd1 sky130_fd_sc_hd__fill_2
Xhold170 _0944_/Q vssd1 vssd1 vccd1 vccd1 _0855_/S sky130_fd_sc_hd__dlygate4sd3_1
Xhold181 _0924_/Q vssd1 vssd1 vccd1 vccd1 _0452_/B sky130_fd_sc_hd__dlygate4sd3_1
XTAP_TAPCELL_ROW_20_175 vssd1 vccd1 sky130_fd_sc_hd__tapvpwrvgnd_1
XFILLER_18_225 vssd1 vssd1 vccd1 vccd1 sky130_fd_sc_hd__fill_2
X_0770_ _0770_/A _0770_/B vssd1 vssd1 vccd1 vccd1 _0771_/B sky130_fd_sc_hd__or2_2
X_0968_ clkload8/A _0968_/D load_slew39/X vssd1 vssd1 vccd1 vccd1 _0968_/Q sky130_fd_sc_hd__dfrtp_2
Xclkbuf_4_12_0_clk clkbuf_0_clk/X vssd1 vssd1 vccd1 vccd1 _0990_/CLK sky130_fd_sc_hd__clkbuf_8
X_0899_ clkload0/A _0899_/D _0913_/SET_B vssd1 vssd1 vccd1 vccd1 _0899_/Q sky130_fd_sc_hd__dfrtp_2
XANTENNA_fanout38_A fanout40/X vssd1 vssd1 vccd1 vccd1 sky130_fd_sc_hd__diode_2
XFILLER_15_217 vssd1 vssd1 vccd1 vccd1 sky130_fd_sc_hd__fill_4
X_0822_ _0881_/Q _0877_/Q _0882_/Q _0876_/Q vssd1 vssd1 vccd1 vccd1 _0823_/B sky130_fd_sc_hd__a22o_2
XFILLER_21_209 vssd1 vssd1 vccd1 vccd1 sky130_fd_sc_hd__fill_1
X_0753_ _0872_/Q _0869_/Q vssd1 vssd1 vccd1 vccd1 _0769_/A sky130_fd_sc_hd__nand2_2
X_0684_ _0683_/B _0683_/C _0885_/Q vssd1 vssd1 vccd1 vccd1 _0714_/C sky130_fd_sc_hd__a21o_2
XFILLER_20_253 vssd1 vssd1 vccd1 vccd1 sky130_fd_sc_hd__fill_2
XPHY_EDGE_ROW_8_Left_47 vssd1 vssd1 vccd1 vccd1 sky130_fd_sc_hd__decap_3
XFILLER_11_220 vssd1 vssd1 vccd1 vccd1 sky130_fd_sc_hd__fill_4
X_0805_ _0880_/Q _0877_/Q vssd1 vssd1 vccd1 vccd1 _0809_/A sky130_fd_sc_hd__nand2_2
X_0736_ _0883_/Q _0742_/B _0735_/X vssd1 vssd1 vccd1 vccd1 _0883_/D sky130_fd_sc_hd__a21o_2
X_0667_ input3/X _0585_/A _0651_/B _0651_/A _0657_/Y vssd1 vssd1 vccd1 vccd1 _0667_/X
+ sky130_fd_sc_hd__a221o_2
X_0598_ _0996_/Q _0594_/C _0997_/Q vssd1 vssd1 vccd1 vccd1 _0598_/Y sky130_fd_sc_hd__a21oi_2
XFILLER_29_85 vssd1 vccd1 vssd1 vccd1 sky130_ef_sc_hd__decap_40_12
XFILLER_29_74 vssd1 vssd1 vccd1 vccd1 sky130_fd_sc_hd__fill_1
XFILLER_29_30 vssd1 vssd1 vccd1 vccd1 sky130_fd_sc_hd__fill_8
XANTENNA_input18_A nrst vssd1 vssd1 vccd1 vccd1 sky130_fd_sc_hd__diode_2
X_0521_ _0975_/Q _0525_/C vssd1 vssd1 vccd1 vccd1 _0523_/B sky130_fd_sc_hd__or2_2
X_0452_ _0454_/A _0452_/B vssd1 vssd1 vccd1 vccd1 _0934_/D sky130_fd_sc_hd__and2_2
XFILLER_34_197 vssd1 vssd1 vccd1 vccd1 sky130_fd_sc_hd__fill_2
X_0719_ _0867_/Q _0901_/Q _0951_/Q vssd1 vssd1 vccd1 vccd1 _0867_/D sky130_fd_sc_hd__mux2_1
XFILLER_15_54 vssd1 vssd1 vccd1 vccd1 sky130_fd_sc_hd__fill_2
XFILLER_31_42 vssd1 vssd1 vccd1 vccd1 sky130_fd_sc_hd__fill_4
Xoutput20 _1069_/X vssd1 vssd1 vccd1 vccd1 gpio_out[17] sky130_fd_sc_hd__clkdlybuf4s25_1
XFILLER_16_164 vssd1 vssd1 vccd1 vccd1 sky130_fd_sc_hd__fill_2
XFILLER_16_197 vssd1 vssd1 vccd1 vccd1 sky130_fd_sc_hd__fill_1
X_0504_ _0504_/A vssd1 vssd1 vccd1 vccd1 _0969_/D sky130_fd_sc_hd__inv_2
X_0435_ input2/X vssd1 vssd1 vccd1 vccd1 _0435_/Y sky130_fd_sc_hd__inv_2
XANTENNA_clkbuf_4_8_0_clk_X clkload7/A vssd1 vssd1 vccd1 vccd1 sky130_fd_sc_hd__diode_2
XFILLER_13_167 vssd1 vssd1 vccd1 vccd1 sky130_fd_sc_hd__fill_1
XPHY_EDGE_ROW_37_Left_76 vssd1 vssd1 vccd1 vccd1 sky130_fd_sc_hd__decap_3
XFILLER_26_31 vssd1 vssd1 vccd1 vccd1 sky130_fd_sc_hd__fill_1
X_0984_ clkload8/A _0984_/D fanout38/X vssd1 vssd1 vccd1 vccd1 _0984_/Q sky130_fd_sc_hd__dfrtp_2
XFILLER_8_160 vssd1 vssd1 vccd1 vccd1 sky130_fd_sc_hd__fill_8
X_0418_ _0547_/B vssd1 vssd1 vccd1 vccd1 _0660_/A sky130_fd_sc_hd__inv_2
XFILLER_10_137 vssd1 vssd1 vccd1 vccd1 sky130_fd_sc_hd__fill_2
XTAP_TAPCELL_ROW_20_176 vssd1 vccd1 sky130_fd_sc_hd__tapvpwrvgnd_1
Xhold160 _0941_/Q vssd1 vssd1 vccd1 vccd1 _0460_/B sky130_fd_sc_hd__dlygate4sd3_1
Xhold171 _0946_/Q vssd1 vssd1 vccd1 vccd1 hold171/X sky130_fd_sc_hd__dlygate4sd3_1
Xhold182 _0922_/Q vssd1 vssd1 vccd1 vccd1 _0453_/B sky130_fd_sc_hd__dlygate4sd3_1
XTAP_TAPCELL_ROW_28_210 vssd1 vccd1 sky130_fd_sc_hd__tapvpwrvgnd_1
XTAP_TAPCELL_ROW_11_132 vssd1 vccd1 sky130_fd_sc_hd__tapvpwrvgnd_1
XTAP_TAPCELL_ROW_34_235 vssd1 vccd1 sky130_fd_sc_hd__tapvpwrvgnd_1
X_0967_ clkload7/A _0967_/D fanout46/X vssd1 vssd1 vccd1 vccd1 _0967_/Q sky130_fd_sc_hd__dfrtp_2
XFILLER_32_251 vssd1 vssd1 vccd1 vccd1 sky130_fd_sc_hd__fill_1
X_0898_ _0898_/CLK _0898_/D fanout45/X vssd1 vssd1 vccd1 vccd1 _0898_/Q sky130_fd_sc_hd__dfstp_2
XPHY_EDGE_ROW_12_Right_12 vssd1 vssd1 vccd1 vccd1 sky130_fd_sc_hd__decap_3
XPHY_EDGE_ROW_21_Right_21 vssd1 vssd1 vccd1 vccd1 sky130_fd_sc_hd__decap_3
XFILLER_15_229 vssd1 vssd1 vccd1 vccd1 sky130_fd_sc_hd__fill_1
XPHY_EDGE_ROW_30_Right_30 vssd1 vssd1 vccd1 vccd1 sky130_fd_sc_hd__decap_3
XFILLER_2_111 vssd1 vssd1 vccd1 vccd1 sky130_fd_sc_hd__fill_4
XFILLER_0_47 vssd1 vssd1 vccd1 vccd1 sky130_fd_sc_hd__fill_1
X_0821_ _0876_/Q _0881_/Q _0877_/Q _0882_/Q vssd1 vssd1 vccd1 vccd1 _0831_/B sky130_fd_sc_hd__and4_2
X_0752_ _0752_/A _0752_/B vssd1 vssd1 vccd1 vccd1 _0752_/Y sky130_fd_sc_hd__xnor2_2
X_0683_ _0885_/Q _0683_/B _0683_/C vssd1 vssd1 vccd1 vccd1 _0683_/X sky130_fd_sc_hd__and3_2
XPHY_EDGE_ROW_24_Left_63 vssd1 vssd1 vccd1 vccd1 sky130_fd_sc_hd__decap_3
XFILLER_20_243 vssd1 vssd1 vccd1 vccd1 sky130_fd_sc_hd__fill_2
XFILLER_11_254 vssd1 vssd1 vccd1 vccd1 sky130_fd_sc_hd__fill_1
Xclkbuf_4_11_0_clk clkbuf_0_clk/X vssd1 vssd1 vccd1 vccd1 clkload9/A sky130_fd_sc_hd__clkbuf_8
Xload_slew42 fanout41/X vssd1 vssd1 vccd1 vccd1 _0882_/SET_B sky130_fd_sc_hd__clkbuf_4
Xload_slew31 fanout30/X vssd1 vssd1 vccd1 vccd1 _0911_/SET_B sky130_fd_sc_hd__buf_2
X_0804_ _0796_/B _0802_/X _0815_/A _0796_/Y vssd1 vssd1 vccd1 vccd1 _0893_/D sky130_fd_sc_hd__o31ai_2
X_0735_ _0867_/Q _0871_/Q _0948_/Q vssd1 vssd1 vccd1 vccd1 _0735_/X sky130_fd_sc_hd__and3_2
X_0666_ _0638_/A _0989_/D _0585_/A input3/X _0651_/X vssd1 vssd1 vccd1 vccd1 _0668_/D
+ sky130_fd_sc_hd__o221a_2
X_0597_ _0996_/Q _0594_/C _0596_/Y vssd1 vssd1 vccd1 vccd1 _0996_/D sky130_fd_sc_hd__o21a_2
XFILLER_29_97 vssd1 vccd1 vssd1 vccd1 sky130_ef_sc_hd__decap_40_12
XFILLER_29_64 vssd1 vssd1 vccd1 vccd1 sky130_fd_sc_hd__fill_8
X_0520_ _0525_/C _0523_/A _0520_/C vssd1 vssd1 vccd1 vccd1 _0974_/D sky130_fd_sc_hd__and3b_2
X_0451_ _0454_/A _0451_/B vssd1 vssd1 vccd1 vccd1 _0935_/D sky130_fd_sc_hd__and2_2
X_0718_ _0696_/Y _0697_/X _0716_/X _0717_/X vssd1 vssd1 vccd1 vccd1 _1069_/A sky130_fd_sc_hd__a211o_2
XPHY_EDGE_ROW_6_Right_6 vssd1 vssd1 vccd1 vccd1 sky130_fd_sc_hd__decap_3
X_0649_ _0650_/A _0996_/D vssd1 vssd1 vccd1 vccd1 _0668_/C sky130_fd_sc_hd__or2_2
XPHY_EDGE_ROW_11_Left_50 vssd1 vssd1 vccd1 vccd1 sky130_fd_sc_hd__decap_3
XFILLER_25_154 vssd1 vssd1 vccd1 vccd1 sky130_fd_sc_hd__fill_2
XFILLER_0_253 vssd1 vssd1 vccd1 vccd1 sky130_fd_sc_hd__fill_2
XFILLER_31_157 vssd1 vssd1 vccd1 vccd1 sky130_fd_sc_hd__fill_2
X_0503_ _0526_/A _0503_/B _0503_/C vssd1 vssd1 vccd1 vccd1 _0504_/A sky130_fd_sc_hd__or3_2
X_0434_ input9/X vssd1 vssd1 vccd1 vccd1 _0434_/Y sky130_fd_sc_hd__inv_2
XTAP_TAPCELL_ROW_17_160 vssd1 vccd1 sky130_fd_sc_hd__tapvpwrvgnd_1
XFILLER_22_157 vssd1 vssd1 vccd1 vccd1 sky130_fd_sc_hd__fill_1
XFILLER_13_113 vssd1 vssd1 vccd1 vccd1 sky130_fd_sc_hd__fill_2
XFILLER_26_98 vssd1 vssd1 vccd1 vccd1 sky130_fd_sc_hd__fill_1
X_0983_ clkload3/A _0983_/D fanout36/X vssd1 vssd1 vccd1 vccd1 _0983_/Q sky130_fd_sc_hd__dfrtp_2
XTAP_TAPCELL_ROW_6_109 vssd1 vccd1 sky130_fd_sc_hd__tapvpwrvgnd_1
X_0417_ _0900_/Q vssd1 vssd1 vccd1 vccd1 _0417_/Y sky130_fd_sc_hd__inv_2
Xhold150 _0939_/Q vssd1 vssd1 vccd1 vccd1 hold150/X sky130_fd_sc_hd__dlygate4sd3_1
Xhold161 _0899_/Q vssd1 vssd1 vccd1 vccd1 hold161/X sky130_fd_sc_hd__dlygate4sd3_1
Xhold172 _0925_/Q vssd1 vssd1 vccd1 vccd1 _0451_/B sky130_fd_sc_hd__dlygate4sd3_1
Xhold183 _0979_/Q vssd1 vssd1 vccd1 vccd1 hold183/X sky130_fd_sc_hd__dlygate4sd3_1
XFILLER_18_227 vssd1 vssd1 vccd1 vccd1 sky130_fd_sc_hd__fill_1
XTAP_TAPCELL_ROW_28_211 vssd1 vccd1 sky130_fd_sc_hd__tapvpwrvgnd_1
XFILLER_18_249 vssd1 vssd1 vccd1 vccd1 sky130_fd_sc_hd__fill_2
XTAP_TAPCELL_ROW_11_133 vssd1 vccd1 sky130_fd_sc_hd__tapvpwrvgnd_1
XTAP_TAPCELL_ROW_34_236 vssd1 vccd1 sky130_fd_sc_hd__tapvpwrvgnd_1
X_0897_ _0898_/CLK _0897_/D fanout45/X vssd1 vssd1 vccd1 vccd1 _0897_/Q sky130_fd_sc_hd__dfstp_2
X_0966_ clkload8/A _0966_/D load_slew39/X vssd1 vssd1 vccd1 vccd1 _0966_/Q sky130_fd_sc_hd__dfrtp_2
X_0820_ _0820_/A _0820_/B vssd1 vssd1 vccd1 vccd1 _0833_/C sky130_fd_sc_hd__xnor2_2
X_0751_ _0746_/A _0746_/B _0746_/C vssd1 vssd1 vccd1 vccd1 _0752_/B sky130_fd_sc_hd__o21ba_2
X_0682_ _0892_/Q _0884_/Q _0891_/Q _0883_/Q vssd1 vssd1 vccd1 vccd1 _0683_/C sky130_fd_sc_hd__a22o_2
XTAP_TAPCELL_ROW_0_80 vssd1 vccd1 sky130_fd_sc_hd__tapvpwrvgnd_1
XFILLER_20_222 vssd1 vssd1 vccd1 vccd1 sky130_fd_sc_hd__fill_4
X_0949_ clkload1/A _0949_/D _0913_/SET_B vssd1 vssd1 vccd1 vccd1 _0949_/Q sky130_fd_sc_hd__dfrtp_2
X_0803_ _0802_/B _0802_/C _0802_/A vssd1 vssd1 vccd1 vccd1 _0815_/A sky130_fd_sc_hd__a21oi_2
X_0734_ _0882_/Q _0908_/Q _0958_/Q vssd1 vssd1 vccd1 vccd1 _0882_/D sky130_fd_sc_hd__mux2_1
X_0665_ _0665_/A _0665_/B _0665_/C _0665_/D vssd1 vssd1 vccd1 vccd1 _0670_/A sky130_fd_sc_hd__and4_2
X_0596_ _0996_/Q _0594_/C _0594_/A vssd1 vssd1 vccd1 vccd1 _0596_/Y sky130_fd_sc_hd__a21oi_2
XFILLER_37_174 vssd1 vssd1 vccd1 vccd1 sky130_fd_sc_hd__fill_2
XFILLER_4_229 vssd1 vssd1 vccd1 vccd1 sky130_fd_sc_hd__fill_4
XFILLER_4_218 vssd1 vssd1 vccd1 vccd1 sky130_fd_sc_hd__fill_2
XFILLER_29_54 vssd1 vssd1 vccd1 vccd1 sky130_fd_sc_hd__fill_2
XFILLER_28_163 vssd1 vssd1 vccd1 vccd1 sky130_fd_sc_hd__fill_1
XFILLER_28_141 vssd1 vssd1 vccd1 vccd1 sky130_fd_sc_hd__fill_4
XFILLER_28_185 vssd1 vssd1 vccd1 vccd1 sky130_fd_sc_hd__fill_4
X_0450_ _0454_/A _0450_/B vssd1 vssd1 vccd1 vccd1 _0936_/D sky130_fd_sc_hd__and2_2
X_0717_ _0704_/C _0693_/Y _0694_/Y _0695_/X vssd1 vssd1 vccd1 vccd1 _0717_/X sky130_fd_sc_hd__a22o_2
X_0648_ _0980_/D _0981_/D _0982_/D _0979_/D vssd1 vssd1 vccd1 vccd1 _0983_/D sky130_fd_sc_hd__and4bb_2
X_0579_ _0990_/Q _0583_/D _0991_/Q vssd1 vssd1 vccd1 vccd1 _0581_/B sky130_fd_sc_hd__a21oi_2
XFILLER_15_45 vssd1 vssd1 vccd1 vccd1 sky130_fd_sc_hd__fill_1
XFILLER_25_111 vssd1 vssd1 vccd1 vccd1 sky130_fd_sc_hd__fill_1
Xclkbuf_4_10_0_clk clkbuf_0_clk/X vssd1 vssd1 vccd1 vccd1 _0898_/CLK sky130_fd_sc_hd__clkbuf_8
XFILLER_31_55 vssd1 vssd1 vccd1 vccd1 sky130_fd_sc_hd__fill_1
XFILLER_0_221 vssd1 vssd1 vccd1 vccd1 sky130_fd_sc_hd__fill_2
XFILLER_16_166 vssd1 vssd1 vccd1 vccd1 sky130_fd_sc_hd__fill_1
X_0502_ _0969_/Q _0509_/D vssd1 vssd1 vccd1 vccd1 _0503_/C sky130_fd_sc_hd__nor2_2
X_0433_ _0986_/Q vssd1 vssd1 vccd1 vccd1 _0433_/Y sky130_fd_sc_hd__inv_2
XTAP_TAPCELL_ROW_17_161 vssd1 vccd1 sky130_fd_sc_hd__tapvpwrvgnd_1
XFILLER_26_55 vssd1 vssd1 vccd1 vccd1 sky130_fd_sc_hd__fill_1
XTAP_TAPCELL_ROW_23_186 vssd1 vccd1 sky130_fd_sc_hd__tapvpwrvgnd_1
X_0982_ clkload3/A _0982_/D fanout27/X vssd1 vssd1 vccd1 vccd1 _0982_/Q sky130_fd_sc_hd__dfrtp_2
X_0416_ _0454_/A vssd1 vssd1 vccd1 vccd1 _0416_/Y sky130_fd_sc_hd__inv_2
XFILLER_10_139 vssd1 vssd1 vccd1 vccd1 sky130_fd_sc_hd__fill_1
Xhold140 _0601_/X vssd1 vssd1 vccd1 vccd1 _0929_/D sky130_fd_sc_hd__dlygate4sd3_1
Xhold151 _0613_/X vssd1 vssd1 vccd1 vccd1 _0920_/D sky130_fd_sc_hd__dlygate4sd3_1
Xhold162 _0845_/Y vssd1 vssd1 vccd1 vccd1 _0846_/B sky130_fd_sc_hd__dlygate4sd3_1
Xhold173 _0947_/Q vssd1 vssd1 vccd1 vccd1 hold173/X sky130_fd_sc_hd__dlygate4sd3_1
Xhold184 _0958_/Q vssd1 vssd1 vccd1 vccd1 _0954_/D sky130_fd_sc_hd__dlygate4sd3_1
XTAP_TAPCELL_ROW_28_212 vssd1 vccd1 sky130_fd_sc_hd__tapvpwrvgnd_1
XTAP_TAPCELL_ROW_11_134 vssd1 vccd1 sky130_fd_sc_hd__tapvpwrvgnd_1
XFILLER_5_110 vssd1 vssd1 vccd1 vccd1 sky130_fd_sc_hd__fill_2
XFILLER_17_250 vssd1 vssd1 vccd1 vccd1 sky130_fd_sc_hd__fill_4
XTAP_TAPCELL_ROW_34_237 vssd1 vccd1 sky130_fd_sc_hd__tapvpwrvgnd_1
XFILLER_32_253 vssd1 vssd1 vccd1 vccd1 sky130_fd_sc_hd__fill_2
X_0896_ clkload9/A _0896_/D fanout45/X vssd1 vssd1 vccd1 vccd1 _0896_/Q sky130_fd_sc_hd__dfstp_2
X_0965_ clkload8/A _0965_/D load_slew39/X vssd1 vssd1 vccd1 vccd1 _0965_/Q sky130_fd_sc_hd__dfrtp_2
XFILLER_4_91 vssd1 vssd1 vccd1 vccd1 sky130_fd_sc_hd__fill_1
XFILLER_23_67 vssd1 vssd1 vccd1 vccd1 sky130_fd_sc_hd__fill_1
XFILLER_23_34 vssd1 vssd1 vccd1 vccd1 sky130_fd_sc_hd__fill_1
XFILLER_14_253 vssd1 vssd1 vccd1 vccd1 sky130_fd_sc_hd__fill_2
X_0750_ _0742_/B _0748_/X _0752_/A _0742_/Y vssd1 vssd1 vccd1 vccd1 _0885_/D sky130_fd_sc_hd__o31ai_2
X_0681_ _0891_/Q _0883_/Q vssd1 vssd1 vccd1 vccd1 _0710_/A sky130_fd_sc_hd__and2_2
XTAP_TAPCELL_ROW_0_81 vssd1 vccd1 sky130_fd_sc_hd__tapvpwrvgnd_1
X_0948_ clkload2/A _0948_/D fanout34/X vssd1 vssd1 vccd1 vccd1 _0948_/Q sky130_fd_sc_hd__dfrtp_2
XFILLER_20_245 vssd1 vssd1 vccd1 vccd1 sky130_fd_sc_hd__fill_1
X_0879_ _0903_/CLK _0879_/D _0882_/SET_B vssd1 vssd1 vccd1 vccd1 _0879_/Q sky130_fd_sc_hd__dfstp_2
XANTENNA_fanout36_A fanout40/X vssd1 vssd1 vccd1 vccd1 sky130_fd_sc_hd__diode_2
XFILLER_34_11 vssd1 vssd1 vccd1 vccd1 sky130_fd_sc_hd__fill_2
XFILLER_11_234 vssd1 vccd1 vssd1 vccd1 sky130_ef_sc_hd__decap_40_12
Xload_slew44 fanout43/X vssd1 vssd1 vccd1 vccd1 _0895_/SET_B sky130_fd_sc_hd__buf_2
X_0802_ _0802_/A _0802_/B _0802_/C vssd1 vssd1 vccd1 vccd1 _0802_/X sky130_fd_sc_hd__and3_2
X_0733_ _0881_/Q _0907_/Q _0958_/Q vssd1 vssd1 vccd1 vccd1 _0881_/D sky130_fd_sc_hd__mux2_1
X_0664_ _0638_/A _0989_/D _0652_/Y _0656_/Y _0660_/Y vssd1 vssd1 vccd1 vccd1 _0665_/D
+ sky130_fd_sc_hd__a2111oi_2
X_0595_ _0654_/B vssd1 vssd1 vccd1 vccd1 _0995_/D sky130_fd_sc_hd__inv_2
XFILLER_29_109 vssd1 vssd1 vccd1 vccd1 sky130_fd_sc_hd__fill_2
XFILLER_29_11 vssd1 vssd1 vccd1 vccd1 sky130_fd_sc_hd__fill_2
XFILLER_28_131 vssd1 vssd1 vccd1 vccd1 sky130_fd_sc_hd__fill_8
X_1001_ clkload1/A _1001_/D _1001_/SET_B vssd1 vssd1 vccd1 vccd1 _1001_/Q sky130_fd_sc_hd__dfstp_2
XFILLER_19_153 vssd1 vssd1 vccd1 vccd1 sky130_fd_sc_hd__fill_2
X_0716_ _0716_/A _0716_/B _0716_/C _0713_/X vssd1 vssd1 vccd1 vccd1 _0716_/X sky130_fd_sc_hd__or4b_2
X_0647_ _0650_/A _0977_/D _0629_/Y _0632_/Y _0646_/Y vssd1 vssd1 vccd1 vccd1 _0964_/D
+ sky130_fd_sc_hd__o2111a_2
X_0578_ _0590_/A _0578_/B vssd1 vssd1 vccd1 vccd1 _0990_/D sky130_fd_sc_hd__nor2_2
XFILLER_25_178 vssd1 vssd1 vccd1 vccd1 sky130_fd_sc_hd__fill_1
XFILLER_25_156 vssd1 vssd1 vccd1 vccd1 sky130_fd_sc_hd__fill_1
XANTENNA_input16_A gpio_in[8] vssd1 vssd1 vccd1 vccd1 sky130_fd_sc_hd__diode_2
XFILLER_16_156 vssd1 vssd1 vccd1 vccd1 sky130_fd_sc_hd__fill_8
X_0501_ _0969_/Q _0509_/D vssd1 vssd1 vccd1 vccd1 _0503_/B sky130_fd_sc_hd__and2_2
X_0432_ _0985_/Q vssd1 vssd1 vccd1 vccd1 _0564_/A sky130_fd_sc_hd__inv_2
XTAP_TAPCELL_ROW_17_162 vssd1 vccd1 sky130_fd_sc_hd__tapvpwrvgnd_1
XANTENNA_input8_A gpio_in[15] vssd1 vssd1 vccd1 vccd1 sky130_fd_sc_hd__diode_2
XFILLER_26_78 vssd1 vssd1 vccd1 vccd1 sky130_fd_sc_hd__fill_4
XFILLER_26_45 vssd1 vssd1 vccd1 vccd1 sky130_fd_sc_hd__fill_1
XFILLER_13_159 vssd1 vssd1 vccd1 vccd1 sky130_fd_sc_hd__fill_1
XTAP_TAPCELL_ROW_23_187 vssd1 vccd1 sky130_fd_sc_hd__tapvpwrvgnd_1
XFILLER_21_181 vssd1 vssd1 vccd1 vccd1 sky130_fd_sc_hd__fill_2
X_0981_ clkload3/A _0981_/D fanout36/X vssd1 vssd1 vccd1 vccd1 _0981_/Q sky130_fd_sc_hd__dfrtp_2
XFILLER_8_141 vssd1 vssd1 vccd1 vccd1 sky130_fd_sc_hd__fill_2
X_0415_ _0982_/Q vssd1 vssd1 vccd1 vccd1 _0415_/Y sky130_fd_sc_hd__inv_2
Xhold130 _0936_/Q vssd1 vssd1 vccd1 vccd1 hold130/X sky130_fd_sc_hd__dlygate4sd3_1
Xhold141 _0933_/Q vssd1 vssd1 vccd1 vccd1 hold141/X sky130_fd_sc_hd__dlygate4sd3_1
Xhold152 _0935_/Q vssd1 vssd1 vccd1 vccd1 hold152/X sky130_fd_sc_hd__dlygate4sd3_1
Xhold163 _0923_/Q vssd1 vssd1 vccd1 vccd1 hold163/X sky130_fd_sc_hd__dlygate4sd3_1
Xhold174 _0889_/Q vssd1 vssd1 vccd1 vccd1 hold174/X sky130_fd_sc_hd__dlygate4sd3_1
Xhold185 _0949_/Q vssd1 vssd1 vccd1 vccd1 _0464_/B sky130_fd_sc_hd__dlygate4sd3_1
XTAP_TAPCELL_ROW_11_135 vssd1 vccd1 sky130_fd_sc_hd__tapvpwrvgnd_1
X_0964_ _0977_/CLK _0964_/D load_slew49/X vssd1 vssd1 vccd1 vccd1 _0964_/Q sky130_fd_sc_hd__dfrtp_2
XTAP_TAPCELL_ROW_34_238 vssd1 vccd1 sky130_fd_sc_hd__tapvpwrvgnd_1
X_0895_ clkload9/A _0895_/D _0895_/SET_B vssd1 vssd1 vccd1 vccd1 _0895_/Q sky130_fd_sc_hd__dfstp_2
XFILLER_23_79 vssd1 vccd1 vssd1 vccd1 sky130_ef_sc_hd__decap_40_12
XFILLER_14_221 vssd1 vssd1 vccd1 vccd1 sky130_fd_sc_hd__fill_1
X_0680_ _0892_/Q _0884_/Q vssd1 vssd1 vccd1 vccd1 _0680_/Y sky130_fd_sc_hd__nand2_2
XTAP_TAPCELL_ROW_0_82 vssd1 vccd1 sky130_fd_sc_hd__tapvpwrvgnd_1
X_0947_ clkload7/A _0947_/D fanout34/X vssd1 vssd1 vccd1 vccd1 _0947_/Q sky130_fd_sc_hd__dfrtp_2
X_0878_ _0903_/CLK _0878_/D _0882_/SET_B vssd1 vssd1 vccd1 vccd1 _0878_/Q sky130_fd_sc_hd__dfstp_2
XANTENNA_fanout29_A fanout35/X vssd1 vssd1 vccd1 vccd1 sky130_fd_sc_hd__diode_2
XFILLER_11_246 vssd1 vssd1 vccd1 vccd1 sky130_fd_sc_hd__fill_8
Xclkload0 clkload0/A vssd1 vssd1 vccd1 vccd1 clkload0/X sky130_fd_sc_hd__clkbuf_4
XPHY_EDGE_ROW_28_Left_67 vssd1 vssd1 vccd1 vccd1 sky130_fd_sc_hd__decap_3
X_0801_ _0800_/B _0800_/C _0800_/A vssd1 vssd1 vccd1 vccd1 _0802_/C sky130_fd_sc_hd__o21ai_2
X_0732_ _0880_/Q _0906_/Q _0958_/Q vssd1 vssd1 vccd1 vccd1 _0880_/D sky130_fd_sc_hd__mux2_1
X_0663_ _0663_/A _0663_/B _0663_/C _0663_/D vssd1 vssd1 vccd1 vccd1 _0665_/C sky130_fd_sc_hd__and4_2
X_0594_ _0594_/A _0594_/B _0594_/C vssd1 vssd1 vccd1 vccd1 _0654_/B sky130_fd_sc_hd__or3_2
X_1000_ clkload1/A input9/X _1001_/SET_B vssd1 vssd1 vccd1 vccd1 _1000_/Q sky130_fd_sc_hd__dfstp_2
XFILLER_19_165 vssd1 vssd1 vccd1 vccd1 sky130_fd_sc_hd__fill_2
XFILLER_34_157 vssd1 vssd1 vccd1 vccd1 sky130_fd_sc_hd__fill_2
XANTENNA_clkbuf_0_clk_A clk vssd1 vssd1 vccd1 vccd1 sky130_fd_sc_hd__diode_2
X_0715_ _0894_/Q _0688_/A _0688_/Y _0714_/X _0707_/A vssd1 vssd1 vccd1 vccd1 _0716_/C
+ sky130_fd_sc_hd__o221a_2
XANTENNA_clkbuf_4_9_0_clk_A clkbuf_0_clk/X vssd1 vssd1 vccd1 vccd1 sky130_fd_sc_hd__diode_2
X_0646_ _0650_/A _0977_/D _0633_/Y _0635_/X _0645_/X vssd1 vssd1 vccd1 vccd1 _0646_/Y
+ sky130_fd_sc_hd__a2111oi_2
X_0577_ _0990_/Q _0583_/D vssd1 vssd1 vccd1 vccd1 _0578_/B sky130_fd_sc_hd__xnor2_2
XFILLER_31_68 vssd1 vssd1 vccd1 vccd1 sky130_fd_sc_hd__fill_1
XFILLER_31_46 vssd1 vssd1 vccd1 vccd1 sky130_fd_sc_hd__fill_1
XFILLER_0_223 vssd1 vssd1 vccd1 vccd1 sky130_fd_sc_hd__fill_1
XFILLER_0_234 vssd1 vssd1 vccd1 vccd1 sky130_fd_sc_hd__fill_4
XPHY_EDGE_ROW_19_Right_19 vssd1 vssd1 vccd1 vccd1 sky130_fd_sc_hd__decap_3
X_0500_ _0481_/X _0486_/X _0499_/X _0458_/A vssd1 vssd1 vccd1 vccd1 _0968_/D sky130_fd_sc_hd__o211a_2
X_0431_ input8/X vssd1 vssd1 vccd1 vccd1 _0653_/A sky130_fd_sc_hd__inv_2
XPHY_EDGE_ROW_28_Right_28 vssd1 vssd1 vccd1 vccd1 sky130_fd_sc_hd__decap_3
XPHY_EDGE_ROW_37_Right_37 vssd1 vssd1 vccd1 vccd1 sky130_fd_sc_hd__decap_3
XFILLER_15_190 vssd1 vssd1 vccd1 vccd1 sky130_fd_sc_hd__fill_4
XFILLER_30_182 vssd1 vssd1 vccd1 vccd1 sky130_fd_sc_hd__fill_1
XPHY_EDGE_ROW_15_Left_54 vssd1 vssd1 vccd1 vccd1 sky130_fd_sc_hd__decap_3
XFILLER_7_81 vssd1 vssd1 vccd1 vccd1 sky130_fd_sc_hd__fill_4
X_0629_ input8/X _0978_/D vssd1 vssd1 vccd1 vccd1 _0629_/Y sky130_fd_sc_hd__xnor2_2
XTAP_TAPCELL_ROW_23_188 vssd1 vccd1 sky130_fd_sc_hd__tapvpwrvgnd_1
XTAP_TAPCELL_ROW_8_120 vssd1 vccd1 sky130_fd_sc_hd__tapvpwrvgnd_1
XFILLER_3_39 vssd1 vssd1 vccd1 vccd1 sky130_fd_sc_hd__fill_1
X_0980_ clkload3/A _0980_/D fanout27/X vssd1 vssd1 vccd1 vccd1 _0980_/Q sky130_fd_sc_hd__dfrtp_2
XFILLER_12_182 vssd1 vssd1 vccd1 vccd1 sky130_fd_sc_hd__fill_1
XFILLER_8_197 vssd1 vssd1 vccd1 vccd1 sky130_fd_sc_hd__fill_4
X_0414_ _0983_/Q vssd1 vssd1 vccd1 vccd1 _0414_/Y sky130_fd_sc_hd__inv_2
Xhold120 _0950_/Q vssd1 vssd1 vccd1 vccd1 _0959_/D sky130_fd_sc_hd__dlygate4sd3_1
Xhold131 _0610_/X vssd1 vssd1 vccd1 vccd1 _0923_/D sky130_fd_sc_hd__dlygate4sd3_1
Xhold142 _0603_/X vssd1 vssd1 vccd1 vccd1 _0928_/D sky130_fd_sc_hd__dlygate4sd3_1
Xhold153 _0611_/X vssd1 vssd1 vccd1 vccd1 _0922_/D sky130_fd_sc_hd__dlygate4sd3_1
Xhold164 _0614_/X vssd1 vssd1 vccd1 vccd1 _0919_/D sky130_fd_sc_hd__dlygate4sd3_1
Xhold175 _0897_/Q vssd1 vssd1 vccd1 vccd1 hold175/X sky130_fd_sc_hd__dlygate4sd3_1
XPHY_EDGE_ROW_0_Left_39 vssd1 vssd1 vccd1 vccd1 sky130_fd_sc_hd__decap_3
XFILLER_37_12 vssd1 vssd1 vccd1 vccd1 sky130_fd_sc_hd__fill_4
XTAP_TAPCELL_ROW_34_239 vssd1 vccd1 sky130_fd_sc_hd__tapvpwrvgnd_1
X_0894_ clkload9/A _0894_/D _0895_/SET_B vssd1 vssd1 vccd1 vccd1 _0894_/Q sky130_fd_sc_hd__dfstp_2
X_0963_ clkload7/A _0963_/D fanout34/X vssd1 vssd1 vccd1 vccd1 _0963_/Q sky130_fd_sc_hd__dfrtp_2
XFILLER_2_115 vssd1 vssd1 vccd1 vccd1 sky130_fd_sc_hd__fill_2
XFILLER_0_29 vssd1 vssd1 vccd1 vccd1 sky130_fd_sc_hd__fill_1
XTAP_TAPCELL_ROW_0_83 vssd1 vccd1 sky130_fd_sc_hd__tapvpwrvgnd_1
XFILLER_36_6 vssd1 vssd1 vccd1 vccd1 sky130_fd_sc_hd__fill_1
X_0877_ clkload7/A _0877_/D _0882_/SET_B vssd1 vssd1 vccd1 vccd1 _0877_/Q sky130_fd_sc_hd__dfstp_2
X_0946_ clkload6/A _0946_/D fanout29/X vssd1 vssd1 vccd1 vccd1 _0946_/Q sky130_fd_sc_hd__dfstp_2
XTAP_TAPCELL_ROW_30_220 vssd1 vccd1 sky130_fd_sc_hd__tapvpwrvgnd_1
XFILLER_34_13 vssd1 vssd1 vccd1 vccd1 sky130_fd_sc_hd__fill_1
XFILLER_18_69 vssd1 vssd1 vccd1 vccd1 sky130_fd_sc_hd__fill_1
Xclkload1 clkload1/A vssd1 vssd1 vccd1 vccd1 clkload1/X sky130_fd_sc_hd__clkbuf_4
XFILLER_34_57 vssd1 vssd1 vccd1 vccd1 sky130_fd_sc_hd__fill_4
XFILLER_34_35 vssd1 vssd1 vccd1 vccd1 sky130_fd_sc_hd__fill_4
XFILLER_34_24 vssd1 vssd1 vccd1 vccd1 sky130_fd_sc_hd__fill_4
XPHY_EDGE_ROW_3_Left_42 vssd1 vssd1 vccd1 vccd1 sky130_fd_sc_hd__decap_3
X_0800_ _0800_/A _0800_/B _0800_/C vssd1 vssd1 vccd1 vccd1 _0802_/B sky130_fd_sc_hd__or3_2
X_0731_ _0879_/Q _0905_/Q _0958_/Q vssd1 vssd1 vccd1 vccd1 _0879_/D sky130_fd_sc_hd__mux2_1
X_0662_ _0662_/A _0985_/D vssd1 vssd1 vccd1 vccd1 _0663_/D sky130_fd_sc_hd__nand2_2
X_0593_ _0993_/Q _0994_/Q _0995_/Q _0593_/D vssd1 vssd1 vccd1 vccd1 _0594_/C sky130_fd_sc_hd__and4_2
XFILLER_34_3 vssd1 vssd1 vccd1 vccd1 sky130_fd_sc_hd__fill_8
XANTENNA_clkbuf_4_5_0_clk_A clkbuf_0_clk/X vssd1 vssd1 vccd1 vccd1 sky130_fd_sc_hd__diode_2
X_0929_ _0990_/CLK _0929_/D fanout48/A vssd1 vssd1 vccd1 vccd1 _0929_/Q sky130_fd_sc_hd__dfrtp_2
XFILLER_20_26 vssd1 vssd1 vccd1 vccd1 sky130_fd_sc_hd__fill_2
XFILLER_29_13 vssd1 vssd1 vccd1 vccd1 sky130_fd_sc_hd__fill_1
XFILLER_19_155 vssd1 vssd1 vccd1 vccd1 sky130_fd_sc_hd__fill_1
XFILLER_34_136 vssd1 vssd1 vccd1 vccd1 sky130_fd_sc_hd__fill_2
X_0714_ _0894_/Q _0886_/Q _0714_/C _0714_/D vssd1 vssd1 vccd1 vccd1 _0714_/X sky130_fd_sc_hd__and4_2
X_0645_ _0645_/A _0645_/B _0645_/C _0645_/D vssd1 vssd1 vccd1 vccd1 _0645_/X sky130_fd_sc_hd__or4_2
X_0576_ _0590_/A _0576_/B _0583_/D vssd1 vssd1 vccd1 vccd1 _0989_/D sky130_fd_sc_hd__nor3_2
XFILLER_16_169 vssd1 vccd1 vssd1 vccd1 sky130_ef_sc_hd__decap_40_12
XFILLER_24_191 vssd1 vssd1 vccd1 vccd1 sky130_fd_sc_hd__fill_4
X_0430_ input7/X vssd1 vssd1 vccd1 vccd1 _0650_/A sky130_fd_sc_hd__inv_2
XFILLER_22_139 vssd1 vssd1 vccd1 vccd1 sky130_fd_sc_hd__fill_1
X_0628_ _0628_/A _0628_/B vssd1 vssd1 vccd1 vccd1 _0981_/D sky130_fd_sc_hd__nor2_2
X_0559_ _0942_/Q _0984_/Q vssd1 vssd1 vccd1 vccd1 _0564_/B sky130_fd_sc_hd__nand2_2
XFILLER_26_69 vssd1 vssd1 vccd1 vccd1 sky130_fd_sc_hd__fill_4
XTAP_TAPCELL_ROW_23_189 vssd1 vccd1 sky130_fd_sc_hd__tapvpwrvgnd_1
XTAP_TAPCELL_ROW_8_121 vssd1 vccd1 sky130_fd_sc_hd__tapvpwrvgnd_1
XANTENNA_clkbuf_4_13_0_clk_A clkbuf_0_clk/X vssd1 vssd1 vccd1 vccd1 sky130_fd_sc_hd__diode_2
XTAP_TAPCELL_ROW_14_145 vssd1 vccd1 sky130_fd_sc_hd__tapvpwrvgnd_1
XPHY_EDGE_ROW_32_Left_71 vssd1 vssd1 vccd1 vccd1 sky130_fd_sc_hd__decap_3
XFILLER_8_132 vssd1 vssd1 vccd1 vccd1 sky130_fd_sc_hd__fill_8
Xhold121 _0953_/Q vssd1 vssd1 vccd1 vccd1 _0961_/D sky130_fd_sc_hd__dlygate4sd3_1
Xhold132 _0932_/Q vssd1 vssd1 vccd1 vccd1 hold132/X sky130_fd_sc_hd__dlygate4sd3_1
Xhold143 _0943_/Q vssd1 vssd1 vccd1 vccd1 hold143/X sky130_fd_sc_hd__dlygate4sd3_1
Xhold154 _0937_/Q vssd1 vssd1 vccd1 vccd1 hold154/X sky130_fd_sc_hd__dlygate4sd3_1
Xhold165 _0952_/Q vssd1 vssd1 vccd1 vccd1 hold165/X sky130_fd_sc_hd__dlygate4sd3_1
Xhold176 _0929_/Q vssd1 vssd1 vccd1 vccd1 _0447_/A sky130_fd_sc_hd__dlygate4sd3_1
XFILLER_37_57 vssd1 vssd1 vccd1 vccd1 sky130_fd_sc_hd__fill_8
XFILLER_26_253 vssd1 vssd1 vccd1 vccd1 sky130_fd_sc_hd__fill_2
X_0893_ _0898_/CLK _0893_/D _0895_/SET_B vssd1 vssd1 vccd1 vccd1 _0893_/Q sky130_fd_sc_hd__dfstp_2
X_0962_ clkload5/A _0962_/D fanout33/X vssd1 vssd1 vccd1 vccd1 _0962_/Q sky130_fd_sc_hd__dfrtp_2
XFILLER_4_190 vssd1 vssd1 vccd1 vccd1 sky130_fd_sc_hd__fill_4
XTAP_TAPCELL_ROW_0_84 vssd1 vccd1 sky130_fd_sc_hd__tapvpwrvgnd_1
XTAP_TAPCELL_ROW_30_221 vssd1 vccd1 sky130_fd_sc_hd__tapvpwrvgnd_1
XFILLER_20_226 vssd1 vssd1 vccd1 vccd1 sky130_fd_sc_hd__fill_2
X_0876_ _0898_/CLK _0876_/D _0882_/SET_B vssd1 vssd1 vccd1 vccd1 _0876_/Q sky130_fd_sc_hd__dfstp_2
X_0945_ clkload5/A _0945_/D fanout29/X vssd1 vssd1 vccd1 vccd1 _0945_/Q sky130_fd_sc_hd__dfrtp_2
XANTENNA_clkbuf_4_1_0_clk_A clkbuf_0_clk/X vssd1 vssd1 vccd1 vccd1 sky130_fd_sc_hd__diode_2
Xclkload2 clkload2/A vssd1 vssd1 vccd1 vccd1 clkload2/X sky130_fd_sc_hd__clkbuf_4
Xload_slew47 fanout46/X vssd1 vssd1 vccd1 vccd1 _0919_/SET_B sky130_fd_sc_hd__clkbuf_4
XANTENNA__0871__CLK clkload7/A vssd1 vssd1 vccd1 vccd1 sky130_fd_sc_hd__diode_2
X_0730_ _0878_/Q _0904_/Q _0958_/Q vssd1 vssd1 vccd1 vccd1 _0878_/D sky130_fd_sc_hd__mux2_1
X_0661_ _0662_/A _0985_/D _0990_/D _0659_/A vssd1 vssd1 vccd1 vccd1 _0663_/C sky130_fd_sc_hd__o22a_2
X_0592_ _0995_/Q _0592_/B vssd1 vssd1 vccd1 vccd1 _0594_/B sky130_fd_sc_hd__nor2_2
XFILLER_27_3 vssd1 vccd1 vssd1 vccd1 sky130_ef_sc_hd__decap_40_12
X_0859_ _0911_/Q _0912_/Q _0863_/S vssd1 vssd1 vccd1 vccd1 _0911_/D sky130_fd_sc_hd__mux2_1
X_0928_ _0939_/CLK _0928_/D load_slew49/X vssd1 vssd1 vccd1 vccd1 _0928_/Q sky130_fd_sc_hd__dfrtp_2
XFILLER_28_145 vssd1 vssd1 vccd1 vccd1 sky130_fd_sc_hd__fill_1
XFILLER_28_101 vssd1 vssd1 vccd1 vccd1 sky130_fd_sc_hd__fill_2
XANTENNA_fanout34_A fanout35/X vssd1 vssd1 vccd1 vccd1 sky130_fd_sc_hd__diode_2
XFILLER_28_189 vssd1 vssd1 vccd1 vccd1 sky130_fd_sc_hd__fill_1
XFILLER_3_244 vssd1 vssd1 vccd1 vccd1 sky130_fd_sc_hd__fill_2
XFILLER_19_167 vssd1 vssd1 vccd1 vccd1 sky130_fd_sc_hd__fill_1
XFILLER_34_159 vssd1 vssd1 vccd1 vccd1 sky130_fd_sc_hd__fill_1
X_0713_ _0711_/Y _0712_/X _0708_/X _0710_/X vssd1 vssd1 vccd1 vccd1 _0713_/X sky130_fd_sc_hd__o211a_2
X_0644_ input4/X _0974_/D vssd1 vssd1 vccd1 vccd1 _0645_/D sky130_fd_sc_hd__xor2_2
X_0575_ _0987_/Q _0988_/Q _0989_/Q _0575_/D vssd1 vssd1 vccd1 vccd1 _0583_/D sky130_fd_sc_hd__and4_2
XFILLER_0_225 vssd1 vssd1 vccd1 vccd1 sky130_fd_sc_hd__fill_2
XPHY_EDGE_ROW_1_Right_1 vssd1 vssd1 vccd1 vccd1 sky130_fd_sc_hd__decap_3
XFILLER_30_151 vssd1 vccd1 vssd1 vccd1 sky130_ef_sc_hd__decap_40_12
X_0627_ _0981_/Q _0625_/B _0414_/Y vssd1 vssd1 vccd1 vccd1 _0628_/B sky130_fd_sc_hd__o21ai_2
X_0558_ _0558_/A _0558_/B _0558_/C _0558_/D vssd1 vssd1 vccd1 vccd1 _0558_/X sky130_fd_sc_hd__and4_2
X_0489_ _0481_/X _0486_/X _0458_/A vssd1 vssd1 vccd1 vccd1 _0523_/A sky130_fd_sc_hd__o21a_2
XFILLER_26_15 vssd1 vccd1 vssd1 vccd1 sky130_ef_sc_hd__decap_40_12
XTAP_TAPCELL_ROW_8_122 vssd1 vccd1 sky130_fd_sc_hd__tapvpwrvgnd_1
XANTENNA_input14_A gpio_in[6] vssd1 vssd1 vccd1 vccd1 sky130_fd_sc_hd__diode_2
XTAP_TAPCELL_ROW_14_146 vssd1 vccd1 sky130_fd_sc_hd__tapvpwrvgnd_1
XFILLER_8_188 vssd1 vssd1 vccd1 vccd1 sky130_fd_sc_hd__fill_2
XTAP_TAPCELL_ROW_37_249 vssd1 vccd1 sky130_fd_sc_hd__tapvpwrvgnd_1
Xhold122 _1000_/Q vssd1 vssd1 vccd1 vccd1 _0999_/D sky130_fd_sc_hd__dlygate4sd3_1
Xhold133 _0605_/X vssd1 vssd1 vccd1 vccd1 _0927_/D sky130_fd_sc_hd__dlygate4sd3_1
Xhold144 _0615_/X vssd1 vssd1 vccd1 vccd1 _0942_/D sky130_fd_sc_hd__dlygate4sd3_1
XANTENNA_input6_A gpio_in[13] vssd1 vssd1 vccd1 vccd1 sky130_fd_sc_hd__diode_2
Xhold155 _0609_/X vssd1 vssd1 vccd1 vccd1 _0924_/D sky130_fd_sc_hd__dlygate4sd3_1
Xhold166 _0926_/Q vssd1 vssd1 vccd1 vccd1 _0450_/B sky130_fd_sc_hd__dlygate4sd3_1
Xhold177 _0980_/Q vssd1 vssd1 vccd1 vccd1 hold177/X sky130_fd_sc_hd__dlygate4sd3_1
XFILLER_37_25 vssd1 vssd1 vccd1 vccd1 sky130_fd_sc_hd__fill_8
XFILLER_17_254 vssd1 vssd1 vccd1 vccd1 sky130_fd_sc_hd__fill_1
X_0961_ clkload7/A _0961_/D fanout34/X vssd1 vssd1 vccd1 vccd1 _0961_/Q sky130_fd_sc_hd__dfrtp_2
X_0892_ _0898_/CLK _0892_/D _0895_/SET_B vssd1 vssd1 vccd1 vccd1 _0892_/Q sky130_fd_sc_hd__dfstp_2
XFILLER_2_139 vssd1 vssd1 vccd1 vccd1 sky130_fd_sc_hd__fill_1
XFILLER_2_117 vssd1 vssd1 vccd1 vccd1 sky130_fd_sc_hd__fill_1
XFILLER_14_235 vssd1 vssd1 vccd1 vccd1 sky130_fd_sc_hd__fill_4
Xfanout50 fanout52/X vssd1 vssd1 vccd1 vccd1 fanout50/X sky130_fd_sc_hd__clkdlybuf4s25_1
XTAP_TAPCELL_ROW_0_85 vssd1 vccd1 sky130_fd_sc_hd__tapvpwrvgnd_1
X_0944_ clkload1/A _0944_/D _0913_/SET_B vssd1 vssd1 vccd1 vccd1 _0944_/Q sky130_fd_sc_hd__dfrtp_2
XFILLER_20_205 vssd1 vssd1 vccd1 vccd1 sky130_fd_sc_hd__fill_2
X_0875_ _0898_/CLK _0875_/D _0882_/SET_B vssd1 vssd1 vccd1 vccd1 _0875_/Q sky130_fd_sc_hd__dfstp_2
Xclkload3 clkload3/A vssd1 vssd1 vccd1 vccd1 clkload3/X sky130_fd_sc_hd__clkbuf_4
Xload_slew37 fanout36/X vssd1 vssd1 vccd1 vccd1 load_slew37/X sky130_fd_sc_hd__clkbuf_4
Xload_slew26 fanout25/X vssd1 vssd1 vccd1 vccd1 _0913_/SET_B sky130_fd_sc_hd__clkbuf_4
XFILLER_24_81 vssd1 vssd1 vccd1 vccd1 sky130_fd_sc_hd__fill_2
X_0660_ _0660_/A _0984_/D vssd1 vssd1 vccd1 vccd1 _0660_/Y sky130_fd_sc_hd__xnor2_2
X_0591_ _0651_/B vssd1 vssd1 vccd1 vccd1 _0994_/D sky130_fd_sc_hd__inv_2
XFILLER_6_253 vssd1 vssd1 vccd1 vccd1 sky130_fd_sc_hd__fill_2
XFILLER_37_113 vssd1 vssd1 vccd1 vccd1 sky130_fd_sc_hd__fill_1
X_0927_ _0938_/CLK _0927_/D load_slew49/X vssd1 vssd1 vccd1 vccd1 _0927_/Q sky130_fd_sc_hd__dfrtp_2
X_0858_ _0910_/Q _0911_/Q _0863_/S vssd1 vssd1 vccd1 vccd1 _0910_/D sky130_fd_sc_hd__mux2_1
X_0789_ _0875_/Q _0879_/Q _0961_/Q vssd1 vssd1 vccd1 vccd1 _0789_/X sky130_fd_sc_hd__and3_2
XFILLER_34_149 vssd1 vssd1 vccd1 vccd1 sky130_fd_sc_hd__fill_8
X_0712_ _0683_/B _0680_/Y _0710_/A _0602_/Y vssd1 vssd1 vccd1 vccd1 _0712_/X sky130_fd_sc_hd__a31o_2
X_0643_ _0660_/A _0965_/D _0504_/A _0421_/A _0642_/Y vssd1 vssd1 vccd1 vccd1 _0645_/C
+ sky130_fd_sc_hd__a221o_2
X_0574_ _0989_/Q _0574_/B vssd1 vssd1 vccd1 vccd1 _0576_/B sky130_fd_sc_hd__nor2_2
XTAP_TAPCELL_ROW_26_199 vssd1 vccd1 sky130_fd_sc_hd__tapvpwrvgnd_1
Xclkbuf_0_clk clk vssd1 vssd1 vccd1 vccd1 clkbuf_0_clk/X sky130_fd_sc_hd__clkbuf_16
XFILLER_30_163 vssd1 vssd1 vccd1 vccd1 sky130_fd_sc_hd__fill_4
XFILLER_30_141 vssd1 vssd1 vccd1 vccd1 sky130_fd_sc_hd__fill_2
X_0626_ hold177/X _0445_/B _0625_/Y vssd1 vssd1 vccd1 vccd1 _0980_/D sky130_fd_sc_hd__o21a_2
X_0557_ _0633_/A _0992_/Q _0536_/Y _0541_/Y _0548_/Y vssd1 vssd1 vccd1 vccd1 _0558_/D
+ sky130_fd_sc_hd__o2111a_2
XPHY_EDGE_ROW_15_Right_15 vssd1 vssd1 vccd1 vccd1 sky130_fd_sc_hd__decap_3
X_0488_ _0930_/D _0488_/B vssd1 vssd1 vccd1 vccd1 _0965_/D sky130_fd_sc_hd__nor2_2
XPHY_EDGE_ROW_24_Right_24 vssd1 vssd1 vccd1 vccd1 sky130_fd_sc_hd__decap_3
XFILLER_26_27 vssd1 vssd1 vccd1 vccd1 sky130_fd_sc_hd__fill_1
XPHY_EDGE_ROW_33_Right_33 vssd1 vssd1 vccd1 vccd1 sky130_fd_sc_hd__decap_3
XFILLER_12_141 vssd1 vssd1 vccd1 vccd1 sky130_fd_sc_hd__fill_2
XFILLER_12_152 vssd1 vssd1 vccd1 vccd1 sky130_fd_sc_hd__fill_4
XTAP_TAPCELL_ROW_14_147 vssd1 vccd1 sky130_fd_sc_hd__tapvpwrvgnd_1
XTAP_TAPCELL_ROW_3_96 vssd1 vccd1 sky130_fd_sc_hd__tapvpwrvgnd_1
XPHY_EDGE_ROW_19_Left_58 vssd1 vssd1 vccd1 vccd1 sky130_fd_sc_hd__decap_3
Xhold123 _0957_/Q vssd1 vssd1 vccd1 vccd1 _0953_/D sky130_fd_sc_hd__dlygate4sd3_1
Xhold134 _0931_/Q vssd1 vssd1 vccd1 vccd1 hold134/X sky130_fd_sc_hd__dlygate4sd3_1
Xhold145 _0938_/Q vssd1 vssd1 vccd1 vccd1 hold145/X sky130_fd_sc_hd__dlygate4sd3_1
Xhold156 _0893_/Q vssd1 vssd1 vccd1 vccd1 _0796_/A sky130_fd_sc_hd__dlygate4sd3_1
Xhold167 _0909_/Q vssd1 vssd1 vccd1 vccd1 hold167/X sky130_fd_sc_hd__dlygate4sd3_1
Xhold178 _0921_/Q vssd1 vssd1 vccd1 vccd1 _0454_/B sky130_fd_sc_hd__dlygate4sd3_1
X_0609_ _0416_/Y _0924_/Q hold154/X vssd1 vssd1 vccd1 vccd1 _0609_/X sky130_fd_sc_hd__a21o_2
XFILLER_5_126 vssd1 vssd1 vccd1 vccd1 sky130_fd_sc_hd__fill_4
X_0960_ clkload1/A _0960_/D fanout25/X vssd1 vssd1 vccd1 vccd1 _0960_/Q sky130_fd_sc_hd__dfrtp_2
X_0891_ clkload9/A _0891_/D _0895_/SET_B vssd1 vssd1 vccd1 vccd1 _0891_/Q sky130_fd_sc_hd__dfstp_2
XFILLER_4_181 vssd1 vssd1 vccd1 vccd1 sky130_fd_sc_hd__fill_1
XFILLER_23_225 vssd1 vssd1 vccd1 vccd1 sky130_fd_sc_hd__fill_4
XTAP_TAPCELL_ROW_33_231 vssd1 vccd1 sky130_fd_sc_hd__tapvpwrvgnd_1
Xfanout40 _0466_/X vssd1 vssd1 vccd1 vccd1 fanout40/X sky130_fd_sc_hd__clkdlybuf4s25_1
XTAP_TAPCELL_ROW_0_86 vssd1 vccd1 sky130_fd_sc_hd__tapvpwrvgnd_1
X_0874_ clkload2/A _0874_/D fanout34/X vssd1 vssd1 vccd1 vccd1 _0874_/Q sky130_fd_sc_hd__dfstp_2
X_0943_ clkload3/A _0943_/D _1001_/SET_B vssd1 vssd1 vccd1 vccd1 _0943_/Q sky130_fd_sc_hd__dfrtp_2
Xclkload10 _0990_/CLK vssd1 vssd1 vccd1 vccd1 clkload10/X sky130_fd_sc_hd__clkbuf_4
XFILLER_20_228 vssd1 vssd1 vccd1 vccd1 sky130_fd_sc_hd__fill_1
Xclkload4 clkload4/A vssd1 vssd1 vccd1 vccd1 clkload4/X sky130_fd_sc_hd__clkbuf_4
Xload_slew49 fanout48/X vssd1 vssd1 vccd1 vccd1 load_slew49/X sky130_fd_sc_hd__clkbuf_4
X_0590_ _0590_/A _0590_/B _0592_/B vssd1 vssd1 vccd1 vccd1 _0651_/B sky130_fd_sc_hd__or3_2
X_0857_ hold167/X _0941_/D _0856_/Y vssd1 vssd1 vccd1 vccd1 _0909_/D sky130_fd_sc_hd__o21a_2
X_0926_ _0938_/CLK _0926_/D load_slew49/X vssd1 vssd1 vccd1 vccd1 _0926_/Q sky130_fd_sc_hd__dfrtp_2
X_0788_ _0778_/A _0786_/Y _0890_/Q _0948_/Q vssd1 vssd1 vccd1 vccd1 _0890_/D sky130_fd_sc_hd__o2bb2a_2
XPHY_EDGE_ROW_7_Left_46 vssd1 vssd1 vccd1 vccd1 sky130_fd_sc_hd__decap_3
XFILLER_3_202 vssd1 vccd1 vssd1 vccd1 sky130_ef_sc_hd__decap_40_12
X_0711_ _0683_/B _0680_/Y _0710_/A vssd1 vssd1 vccd1 vccd1 _0711_/Y sky130_fd_sc_hd__a21oi_2
X_0642_ _0656_/A _0968_/D vssd1 vssd1 vccd1 vccd1 _0642_/Y sky130_fd_sc_hd__xnor2_2
X_0573_ _0590_/A _0573_/B _0574_/B vssd1 vssd1 vccd1 vccd1 _0988_/D sky130_fd_sc_hd__nor3_2
XFILLER_32_3 vssd1 vssd1 vccd1 vccd1 sky130_fd_sc_hd__fill_4
XFILLER_33_150 vssd1 vssd1 vccd1 vccd1 sky130_fd_sc_hd__fill_4
X_0909_ clkload3/A _0909_/D _1001_/SET_B vssd1 vssd1 vccd1 vccd1 _0909_/Q sky130_fd_sc_hd__dfrtp_2
XFILLER_0_238 vssd1 vssd1 vccd1 vccd1 sky130_fd_sc_hd__fill_2
XFILLER_16_139 vssd1 vssd1 vccd1 vccd1 sky130_fd_sc_hd__fill_1
XFILLER_24_161 vssd1 vssd1 vccd1 vccd1 sky130_fd_sc_hd__fill_1
XFILLER_21_94 vssd1 vccd1 vssd1 vccd1 sky130_ef_sc_hd__decap_40_12
XFILLER_15_194 vssd1 vssd1 vccd1 vccd1 sky130_fd_sc_hd__fill_2
X_0625_ _0983_/Q _0625_/B vssd1 vssd1 vccd1 vccd1 _0625_/Y sky130_fd_sc_hd__nor2_2
XFILLER_7_85 vssd1 vssd1 vccd1 vccd1 sky130_fd_sc_hd__fill_2
X_0556_ _0541_/B _0433_/Y _0996_/Q _0650_/A vssd1 vssd1 vccd1 vccd1 _0558_/C sky130_fd_sc_hd__o22a_2
X_0487_ _0481_/X _0486_/X _0965_/Q vssd1 vssd1 vccd1 vccd1 _0488_/B sky130_fd_sc_hd__o21a_2
XFILLER_38_253 vssd1 vssd1 vccd1 vccd1 sky130_fd_sc_hd__fill_2
XTAP_TAPCELL_ROW_14_148 vssd1 vccd1 sky130_fd_sc_hd__tapvpwrvgnd_1
XFILLER_12_197 vssd1 vssd1 vccd1 vccd1 sky130_fd_sc_hd__fill_1
XTAP_TAPCELL_ROW_3_97 vssd1 vccd1 sky130_fd_sc_hd__tapvpwrvgnd_1
XTAP_TAPCELL_ROW_22_181 vssd1 vccd1 sky130_fd_sc_hd__tapvpwrvgnd_1
XFILLER_8_168 vssd1 vssd1 vccd1 vccd1 sky130_fd_sc_hd__fill_2
XFILLER_35_223 vssd1 vssd1 vccd1 vccd1 sky130_fd_sc_hd__fill_1
Xhold124 _0954_/Q vssd1 vssd1 vccd1 vccd1 _0962_/D sky130_fd_sc_hd__dlygate4sd3_1
Xhold135 _0607_/X vssd1 vssd1 vccd1 vccd1 _0926_/D sky130_fd_sc_hd__dlygate4sd3_1
Xhold146 _0612_/X vssd1 vssd1 vccd1 vccd1 _0921_/D sky130_fd_sc_hd__dlygate4sd3_1
Xhold157 _0961_/Q vssd1 vssd1 vccd1 vccd1 _0950_/D sky130_fd_sc_hd__dlygate4sd3_1
Xhold168 _0909_/Q vssd1 vssd1 vccd1 vccd1 hold168/X sky130_fd_sc_hd__dlygate4sd3_1
Xhold179 _0928_/Q vssd1 vssd1 vccd1 vccd1 _0448_/B sky130_fd_sc_hd__dlygate4sd3_1
X_0608_ _0416_/Y _0925_/Q hold136/X vssd1 vssd1 vccd1 vccd1 _0608_/X sky130_fd_sc_hd__a21o_2
X_0539_ _0637_/A _0990_/Q vssd1 vssd1 vccd1 vccd1 _0539_/Y sky130_fd_sc_hd__nand2b_2
XTAP_TAPCELL_ROW_5_105 vssd1 vccd1 sky130_fd_sc_hd__tapvpwrvgnd_1
XFILLER_37_16 vssd1 vssd1 vccd1 vccd1 sky130_fd_sc_hd__fill_2
XPHY_EDGE_ROW_36_Left_75 vssd1 vssd1 vccd1 vccd1 sky130_fd_sc_hd__decap_3
XPHY_EDGE_ROW_20_Left_59 vssd1 vssd1 vccd1 vccd1 sky130_fd_sc_hd__decap_3
X_0890_ clkload8/A _0890_/D _0919_/SET_B vssd1 vssd1 vccd1 vccd1 _0890_/Q sky130_fd_sc_hd__dfstp_2
XTAP_TAPCELL_ROW_33_232 vssd1 vccd1 sky130_fd_sc_hd__tapvpwrvgnd_1
Xfanout30 fanout35/X vssd1 vssd1 vccd1 vccd1 fanout30/X sky130_fd_sc_hd__clkdlybuf4s25_1
Xfanout41 fanout45/X vssd1 vssd1 vccd1 vccd1 fanout41/X sky130_fd_sc_hd__clkdlybuf4s25_1
Xfanout52 _0466_/X vssd1 vssd1 vccd1 vccd1 fanout52/X sky130_fd_sc_hd__clkdlybuf4s25_1
XFILLER_1_141 vssd1 vssd1 vccd1 vccd1 sky130_fd_sc_hd__fill_4
X_0873_ clkload7/A _0873_/D fanout32/X vssd1 vssd1 vccd1 vccd1 _0873_/Q sky130_fd_sc_hd__dfstp_2
X_0942_ clkload5/A _0942_/D fanout29/X vssd1 vssd1 vccd1 vccd1 _0942_/Q sky130_fd_sc_hd__dfrtp_2
Xclkload11 _0977_/CLK vssd1 vssd1 vccd1 vccd1 clkload11/X sky130_fd_sc_hd__clkbuf_4
XFILLER_9_252 vssd1 vssd1 vccd1 vccd1 sky130_fd_sc_hd__fill_2
Xclkload5 clkload5/A vssd1 vssd1 vccd1 vccd1 clkload5/X sky130_fd_sc_hd__clkbuf_4
Xload_slew39 fanout38/X vssd1 vssd1 vccd1 vccd1 load_slew39/X sky130_fd_sc_hd__buf_4
Xload_slew28 fanout27/X vssd1 vssd1 vccd1 vccd1 _1001_/SET_B sky130_fd_sc_hd__buf_2
XFILLER_24_83 vssd1 vssd1 vccd1 vccd1 sky130_fd_sc_hd__fill_1
XPHY_EDGE_ROW_23_Left_62 vssd1 vssd1 vccd1 vccd1 sky130_fd_sc_hd__decap_3
X_0856_ _0941_/D _0918_/Q hold143/X vssd1 vssd1 vccd1 vccd1 _0856_/Y sky130_fd_sc_hd__a21oi_2
X_0925_ _0990_/CLK _0925_/D fanout48/X vssd1 vssd1 vccd1 vccd1 _0925_/Q sky130_fd_sc_hd__dfrtp_2
X_0787_ _0778_/A _0785_/X _0786_/Y _0742_/B hold174/X vssd1 vssd1 vccd1 vccd1 _0889_/D
+ sky130_fd_sc_hd__a32o_2
XFILLER_28_159 vssd1 vssd1 vccd1 vccd1 sky130_fd_sc_hd__fill_4
XFILLER_10_85 vssd1 vssd1 vccd1 vccd1 sky130_fd_sc_hd__fill_2
XFILLER_3_214 vssd1 vssd1 vccd1 vccd1 sky130_fd_sc_hd__fill_2
XFILLER_19_50 vssd1 vssd1 vccd1 vccd1 sky130_fd_sc_hd__fill_1
XFILLER_34_107 vssd1 vssd1 vccd1 vccd1 sky130_fd_sc_hd__fill_2
X_0710_ _0710_/A _0710_/B vssd1 vssd1 vccd1 vccd1 _0710_/X sky130_fd_sc_hd__or2_2
X_0641_ _0660_/A _0965_/D _0504_/A _0421_/A _0640_/X vssd1 vssd1 vccd1 vccd1 _0645_/B
+ sky130_fd_sc_hd__o221ai_2
X_0572_ _0987_/Q _0988_/Q _0575_/D vssd1 vssd1 vccd1 vccd1 _0574_/B sky130_fd_sc_hd__and3_2
X_0839_ _0838_/A _0838_/B _0838_/C vssd1 vssd1 vccd1 vccd1 _0839_/Y sky130_fd_sc_hd__a21oi_2
X_0908_ clkload2/A _0908_/D fanout33/X vssd1 vssd1 vccd1 vccd1 _0908_/Q sky130_fd_sc_hd__dfstp_2
XANTENNA_fanout32_A fanout35/X vssd1 vssd1 vccd1 vccd1 sky130_fd_sc_hd__diode_2
XFILLER_24_195 vssd1 vssd1 vccd1 vccd1 sky130_fd_sc_hd__fill_1
XFILLER_21_40 vssd1 vssd1 vccd1 vccd1 sky130_fd_sc_hd__fill_2
XFILLER_15_151 vssd1 vssd1 vccd1 vccd1 sky130_fd_sc_hd__fill_8
XFILLER_30_143 vssd1 vssd1 vccd1 vccd1 sky130_fd_sc_hd__fill_1
X_0624_ _0956_/Q input2/X hold171/X input9/X vssd1 vssd1 vccd1 vccd1 _0946_/D sky130_fd_sc_hd__a22o_2
X_0555_ _0555_/A _0555_/B _0555_/C _0555_/D vssd1 vssd1 vccd1 vccd1 _0555_/X sky130_fd_sc_hd__and4_2
X_0486_ _0486_/A _0486_/B _0484_/X _0485_/X vssd1 vssd1 vccd1 vccd1 _0486_/X sky130_fd_sc_hd__or4bb_2
XPHY_EDGE_ROW_5_Right_5 vssd1 vssd1 vccd1 vccd1 sky130_fd_sc_hd__decap_3
XFILLER_26_29 vssd1 vssd1 vccd1 vccd1 sky130_fd_sc_hd__fill_2
XFILLER_21_110 vssd1 vssd1 vccd1 vccd1 sky130_fd_sc_hd__fill_2
XANTENNA_fanout35_X fanout35/X vssd1 vssd1 vccd1 vccd1 sky130_fd_sc_hd__diode_2
XFILLER_12_143 vssd1 vssd1 vccd1 vccd1 sky130_fd_sc_hd__fill_1
XFILLER_16_40 vssd1 vssd1 vccd1 vccd1 sky130_fd_sc_hd__fill_2
XTAP_TAPCELL_ROW_14_149 vssd1 vccd1 sky130_fd_sc_hd__tapvpwrvgnd_1
XTAP_TAPCELL_ROW_3_98 vssd1 vccd1 sky130_fd_sc_hd__tapvpwrvgnd_1
XTAP_TAPCELL_ROW_22_182 vssd1 vccd1 sky130_fd_sc_hd__tapvpwrvgnd_1
Xhold125 _0963_/Q vssd1 vssd1 vccd1 vccd1 _0947_/D sky130_fd_sc_hd__dlygate4sd3_1
Xhold136 _0930_/Q vssd1 vssd1 vccd1 vccd1 hold136/X sky130_fd_sc_hd__dlygate4sd3_1
Xhold147 _0885_/Q vssd1 vssd1 vccd1 vccd1 _0742_/A sky130_fd_sc_hd__dlygate4sd3_1
Xhold158 _0964_/Q vssd1 vssd1 vccd1 vccd1 _0455_/A sky130_fd_sc_hd__dlygate4sd3_1
Xhold169 _0927_/Q vssd1 vssd1 vccd1 vccd1 _0449_/B sky130_fd_sc_hd__dlygate4sd3_1
X_0607_ _0416_/Y _0926_/Q hold134/X vssd1 vssd1 vccd1 vccd1 _0607_/X sky130_fd_sc_hd__a21o_2
X_0538_ _0993_/Q input4/X vssd1 vssd1 vccd1 vccd1 _0538_/Y sky130_fd_sc_hd__nand2b_2
XTAP_TAPCELL_ROW_5_106 vssd1 vccd1 sky130_fd_sc_hd__tapvpwrvgnd_1
X_0469_ _0967_/Q _0658_/A vssd1 vssd1 vccd1 vccd1 _0469_/X sky130_fd_sc_hd__xor2_2
XTAP_TAPCELL_ROW_28_208 vssd1 vccd1 sky130_fd_sc_hd__tapvpwrvgnd_1
XANTENNA_input12_A gpio_in[4] vssd1 vssd1 vccd1 vccd1 sky130_fd_sc_hd__diode_2
XTAP_TAPCELL_ROW_10_130 vssd1 vccd1 sky130_fd_sc_hd__tapvpwrvgnd_1
XFILLER_4_194 vssd1 vssd1 vccd1 vccd1 sky130_fd_sc_hd__fill_2
XFILLER_4_87 vssd1 vssd1 vccd1 vccd1 sky130_fd_sc_hd__fill_4
XTAP_TAPCELL_ROW_33_233 vssd1 vccd1 sky130_fd_sc_hd__tapvpwrvgnd_1
XFILLER_23_205 vssd1 vssd1 vccd1 vccd1 sky130_fd_sc_hd__fill_4
XANTENNA_input4_A gpio_in[11] vssd1 vssd1 vccd1 vccd1 sky130_fd_sc_hd__diode_2
X_0941_ clkload5/A _0941_/D fanout29/X vssd1 vssd1 vccd1 vccd1 _0941_/Q sky130_fd_sc_hd__dfrtp_2
X_0872_ clkload2/A _0872_/D fanout32/X vssd1 vssd1 vccd1 vccd1 _0872_/Q sky130_fd_sc_hd__dfstp_2
Xclkload12 _0939_/CLK vssd1 vssd1 vccd1 vccd1 clkload12/X sky130_fd_sc_hd__clkbuf_4
Xclkload6 clkload6/A vssd1 vssd1 vccd1 vccd1 clkload6/X sky130_fd_sc_hd__clkbuf_4
XFILLER_24_51 vssd1 vssd1 vccd1 vccd1 sky130_fd_sc_hd__fill_2
X_0924_ _0939_/CLK _0924_/D fanout48/A vssd1 vssd1 vccd1 vccd1 _0924_/Q sky130_fd_sc_hd__dfrtp_2
X_0855_ _0908_/Q _0917_/Q _0855_/S vssd1 vssd1 vccd1 vccd1 _0908_/D sky130_fd_sc_hd__mux2_1
X_0786_ _0776_/C _0778_/B _0783_/B _0783_/C _0742_/B vssd1 vssd1 vccd1 vccd1 _0786_/Y
+ sky130_fd_sc_hd__a41oi_2
XFILLER_19_149 vssd1 vssd1 vccd1 vccd1 sky130_fd_sc_hd__fill_4
XFILLER_27_182 vssd1 vssd1 vccd1 vccd1 sky130_fd_sc_hd__fill_2
X_0640_ _0419_/A _0526_/A _0494_/B _0970_/D _0638_/A vssd1 vssd1 vccd1 vccd1 _0640_/X
+ sky130_fd_sc_hd__o32a_2
X_0571_ _0987_/Q _0575_/D _0988_/Q vssd1 vssd1 vccd1 vccd1 _0573_/B sky130_fd_sc_hd__a21oi_2
X_0907_ clkload2/A _0907_/D fanout32/X vssd1 vssd1 vccd1 vccd1 _0907_/Q sky130_fd_sc_hd__dfstp_2
X_0838_ _0838_/A _0838_/B _0838_/C vssd1 vssd1 vccd1 vccd1 _0838_/X sky130_fd_sc_hd__and3_2
Xoutput19 _1068_/X vssd1 vssd1 vccd1 vccd1 gpio_out[16] sky130_fd_sc_hd__clkdlybuf4s25_1
X_0769_ _0769_/A _0769_/B vssd1 vssd1 vccd1 vccd1 _0770_/B sky130_fd_sc_hd__nor2_2
XFILLER_24_130 vssd1 vssd1 vccd1 vccd1 sky130_fd_sc_hd__fill_2
XFILLER_30_100 vssd1 vssd1 vccd1 vccd1 sky130_fd_sc_hd__fill_4
X_0623_ _0417_/Y _0949_/Q _0465_/C _0434_/Y hold148/X vssd1 vssd1 vccd1 vccd1 _0623_/X
+ sky130_fd_sc_hd__a32o_2
X_0554_ _0657_/A _0988_/Q _0533_/Y _0534_/Y _0544_/Y vssd1 vssd1 vccd1 vccd1 _0555_/D
+ sky130_fd_sc_hd__o2111a_2
XFILLER_7_87 vssd1 vssd1 vccd1 vccd1 sky130_fd_sc_hd__fill_1
X_0485_ _0966_/Q _0662_/A _0978_/Q _0653_/A _0476_/Y vssd1 vssd1 vccd1 vccd1 _0485_/X
+ sky130_fd_sc_hd__o221a_2
XFILLER_21_144 vssd1 vccd1 vssd1 vccd1 sky130_ef_sc_hd__decap_40_12
XFILLER_21_177 vssd1 vssd1 vccd1 vccd1 sky130_fd_sc_hd__fill_4
XTAP_TAPCELL_ROW_22_183 vssd1 vccd1 sky130_fd_sc_hd__tapvpwrvgnd_1
XPHY_EDGE_ROW_11_Right_11 vssd1 vssd1 vccd1 vccd1 sky130_fd_sc_hd__decap_3
XTAP_TAPCELL_ROW_3_99 vssd1 vccd1 sky130_fd_sc_hd__tapvpwrvgnd_1
XPHY_EDGE_ROW_20_Right_20 vssd1 vssd1 vccd1 vccd1 sky130_fd_sc_hd__decap_3
XFILLER_35_225 vssd1 vssd1 vccd1 vccd1 sky130_fd_sc_hd__fill_2
Xhold126 _0962_/Q vssd1 vssd1 vccd1 vccd1 _0948_/D sky130_fd_sc_hd__dlygate4sd3_1
XFILLER_7_181 vssd1 vssd1 vccd1 vccd1 sky130_fd_sc_hd__fill_2
Xhold137 _0608_/X vssd1 vssd1 vccd1 vccd1 _0925_/D sky130_fd_sc_hd__dlygate4sd3_1
Xhold148 _0960_/Q vssd1 vssd1 vccd1 vccd1 hold148/X sky130_fd_sc_hd__dlygate4sd3_1
Xhold159 _0455_/X vssd1 vssd1 vccd1 vccd1 _0931_/D sky130_fd_sc_hd__dlygate4sd3_1
X_0606_ _0926_/Q _0931_/Q vssd1 vssd1 vccd1 vccd1 _0704_/C sky130_fd_sc_hd__or2_2
X_0537_ input7/X _0996_/Q vssd1 vssd1 vccd1 vccd1 _0537_/Y sky130_fd_sc_hd__nand2b_2
XTAP_TAPCELL_ROW_5_107 vssd1 vccd1 sky130_fd_sc_hd__tapvpwrvgnd_1
X_0468_ _0969_/Q _0657_/A _0514_/A input3/X vssd1 vssd1 vccd1 vccd1 _0481_/A sky130_fd_sc_hd__a2bb2o_2
XTAP_TAPCELL_ROW_28_209 vssd1 vccd1 sky130_fd_sc_hd__tapvpwrvgnd_1
XFILLER_17_225 vssd1 vssd1 vccd1 vccd1 sky130_fd_sc_hd__fill_1
XTAP_TAPCELL_ROW_10_131 vssd1 vccd1 sky130_fd_sc_hd__tapvpwrvgnd_1
XTAP_TAPCELL_ROW_33_234 vssd1 vccd1 sky130_fd_sc_hd__tapvpwrvgnd_1
Xfanout21 _0594_/A vssd1 vssd1 vccd1 vccd1 _0590_/A sky130_fd_sc_hd__clkdlybuf4s25_1
Xfanout32 fanout35/X vssd1 vssd1 vccd1 vccd1 fanout32/X sky130_fd_sc_hd__clkdlybuf4s25_1
Xfanout43 fanout45/X vssd1 vssd1 vccd1 vccd1 fanout43/X sky130_fd_sc_hd__clkdlybuf4s25_1
XTAP_TAPCELL_ROW_0_78 vssd1 vccd1 sky130_fd_sc_hd__tapvpwrvgnd_1
X_0940_ clkload3/A _0940_/D _1001_/SET_B vssd1 vssd1 vccd1 vccd1 _0940_/Q sky130_fd_sc_hd__dfstp_2
X_0871_ clkload7/A _0871_/D fanout41/X vssd1 vssd1 vccd1 vccd1 _0871_/Q sky130_fd_sc_hd__dfstp_2
Xclkload13 _0938_/CLK vssd1 vssd1 vccd1 vccd1 clkload13/X sky130_fd_sc_hd__clkbuf_4
XFILLER_9_254 vssd1 vssd1 vccd1 vccd1 sky130_fd_sc_hd__fill_1
Xclkload7 clkload7/A vssd1 vssd1 vccd1 vccd1 clkload7/X sky130_fd_sc_hd__clkbuf_4
XFILLER_24_85 vssd1 vssd1 vccd1 vccd1 sky130_fd_sc_hd__fill_8
XFILLER_10_253 vssd1 vssd1 vccd1 vccd1 sky130_fd_sc_hd__fill_2
XFILLER_6_213 vssd1 vccd1 vssd1 vccd1 sky130_ef_sc_hd__decap_40_12
X_0854_ _0907_/Q _0916_/Q _0854_/S vssd1 vssd1 vccd1 vccd1 _0907_/D sky130_fd_sc_hd__mux2_1
X_0923_ _0938_/CLK _0923_/D load_slew49/X vssd1 vssd1 vccd1 vccd1 _0923_/Q sky130_fd_sc_hd__dfrtp_2
X_0785_ _0778_/B _0783_/B _0783_/C _0776_/C vssd1 vssd1 vccd1 vccd1 _0785_/X sky130_fd_sc_hd__a31o_2
XFILLER_28_139 vssd1 vssd1 vccd1 vccd1 sky130_fd_sc_hd__fill_1
XFILLER_28_106 vssd1 vssd1 vccd1 vccd1 sky130_fd_sc_hd__fill_4
XFILLER_35_40 vssd1 vssd1 vccd1 vccd1 sky130_fd_sc_hd__fill_1
XFILLER_34_109 vssd1 vssd1 vccd1 vccd1 sky130_fd_sc_hd__fill_1
XFILLER_35_73 vssd1 vssd1 vccd1 vccd1 sky130_fd_sc_hd__fill_1
X_0570_ _0590_/A _0570_/B vssd1 vssd1 vccd1 vccd1 _0987_/D sky130_fd_sc_hd__nor2_2
X_0837_ _0837_/A _0837_/B vssd1 vssd1 vccd1 vccd1 _0838_/C sky130_fd_sc_hd__and2_2
X_0906_ clkload2/A _0906_/D _0911_/SET_B vssd1 vssd1 vccd1 vccd1 _0906_/Q sky130_fd_sc_hd__dfstp_2
X_0768_ _0768_/A _0781_/B vssd1 vssd1 vccd1 vccd1 _0772_/A sky130_fd_sc_hd__xor2_2
X_0699_ _0676_/Y _0678_/X _0688_/Y _0937_/Q _0924_/Q vssd1 vssd1 vccd1 vccd1 _0700_/B
+ sky130_fd_sc_hd__o32ai_2
XANTENNA__0877__CLK clkload7/A vssd1 vssd1 vccd1 vccd1 sky130_fd_sc_hd__diode_2
XTAP_TAPCELL_ROW_17_159 vssd1 vccd1 sky130_fd_sc_hd__tapvpwrvgnd_1
XFILLER_30_178 vssd1 vssd1 vccd1 vccd1 sky130_fd_sc_hd__fill_4
XFILLER_30_167 vssd1 vssd1 vccd1 vccd1 sky130_fd_sc_hd__fill_2
X_0622_ _0465_/C _0621_/Y input9/X hold165/X vssd1 vssd1 vccd1 vccd1 _0952_/D sky130_fd_sc_hd__a2bb2o_2
X_0553_ _0638_/A _0989_/Q _0535_/Y _0537_/Y _0547_/Y vssd1 vssd1 vccd1 vccd1 _0555_/C
+ sky130_fd_sc_hd__o2111a_2
X_0484_ _0970_/Q _0638_/A _0976_/Q _0429_/Y _0473_/Y vssd1 vssd1 vccd1 vccd1 _0484_/X
+ sky130_fd_sc_hd__o221a_2
XFILLER_38_223 vssd1 vssd1 vccd1 vccd1 sky130_fd_sc_hd__fill_1
XFILLER_21_156 vssd1 vccd1 vssd1 vccd1 sky130_ef_sc_hd__decap_40_12
XFILLER_12_156 vssd1 vssd1 vccd1 vccd1 sky130_fd_sc_hd__fill_1
XTAP_TAPCELL_ROW_22_184 vssd1 vccd1 sky130_fd_sc_hd__tapvpwrvgnd_1
XFILLER_8_149 vssd1 vssd1 vccd1 vccd1 sky130_fd_sc_hd__fill_2
XFILLER_32_85 vssd1 vccd1 vssd1 vccd1 sky130_ef_sc_hd__decap_40_12
Xhold127 _0959_/Q vssd1 vssd1 vccd1 vccd1 _0963_/D sky130_fd_sc_hd__dlygate4sd3_1
Xhold138 _0948_/Q vssd1 vssd1 vccd1 vccd1 _0957_/D sky130_fd_sc_hd__dlygate4sd3_1
Xhold149 _0623_/X vssd1 vssd1 vccd1 vccd1 _0949_/D sky130_fd_sc_hd__dlygate4sd3_1
X_0605_ _0416_/Y _0927_/Q hold132/X vssd1 vssd1 vccd1 vccd1 _0605_/X sky130_fd_sc_hd__a21o_2
X_0536_ _0422_/A _0989_/Q vssd1 vssd1 vccd1 vccd1 _0536_/Y sky130_fd_sc_hd__nand2b_2
X_0467_ _0968_/Q _0467_/B vssd1 vssd1 vccd1 vccd1 _0467_/X sky130_fd_sc_hd__and2b_2
XTAP_TAPCELL_ROW_5_108 vssd1 vccd1 sky130_fd_sc_hd__tapvpwrvgnd_1
XANTENNA_fanout40_X fanout40/X vssd1 vssd1 vccd1 vccd1 sky130_fd_sc_hd__diode_2
XFILLER_4_141 vssd1 vssd1 vccd1 vccd1 sky130_fd_sc_hd__fill_4
X_0519_ _0972_/Q _0973_/Q _0974_/Q _0519_/D vssd1 vssd1 vccd1 vccd1 _0525_/C sky130_fd_sc_hd__and4_2
Xfanout22 _0998_/Q vssd1 vssd1 vccd1 vccd1 _0863_/S sky130_fd_sc_hd__clkdlybuf4s25_1
Xfanout33 fanout35/X vssd1 vssd1 vccd1 vccd1 fanout33/X sky130_fd_sc_hd__clkdlybuf4s25_1
XTAP_TAPCELL_ROW_0_79 vssd1 vccd1 sky130_fd_sc_hd__tapvpwrvgnd_1
XFILLER_38_73 vssd1 vssd1 vccd1 vccd1 sky130_fd_sc_hd__fill_2
X_0870_ _0903_/CLK _0870_/D fanout32/X vssd1 vssd1 vccd1 vccd1 _0870_/Q sky130_fd_sc_hd__dfstp_2
X_0999_ clkload3/A _0999_/D _1001_/SET_B vssd1 vssd1 vccd1 vccd1 _0999_/Q sky130_fd_sc_hd__dfstp_2
Xclkload8 clkload8/A vssd1 vssd1 vccd1 vccd1 clkload8/X sky130_fd_sc_hd__clkbuf_4
XFILLER_6_225 vssd1 vssd1 vccd1 vccd1 sky130_fd_sc_hd__fill_1
X_0853_ _0906_/Q _0915_/Q _0854_/S vssd1 vssd1 vccd1 vccd1 _0906_/D sky130_fd_sc_hd__mux2_1
X_0922_ _0939_/CLK _0922_/D fanout48/A vssd1 vssd1 vccd1 vccd1 _0922_/Q sky130_fd_sc_hd__dfrtp_2
X_0784_ _0742_/B _0782_/Y _0783_/X _0774_/X vssd1 vssd1 vccd1 vccd1 _0888_/D sky130_fd_sc_hd__o31a_2
Xinput1 en vssd1 vssd1 vccd1 vccd1 input1/X sky130_fd_sc_hd__clkdlybuf4s25_1
XFILLER_19_118 vssd1 vssd1 vccd1 vccd1 sky130_fd_sc_hd__fill_1
XFILLER_27_184 vssd1 vssd1 vccd1 vccd1 sky130_fd_sc_hd__fill_1
XFILLER_27_162 vssd1 vssd1 vccd1 vccd1 sky130_fd_sc_hd__fill_4
XPHY_EDGE_ROW_27_Left_66 vssd1 vssd1 vccd1 vccd1 sky130_fd_sc_hd__decap_3
XFILLER_32_7 vssd1 vssd1 vccd1 vccd1 sky130_fd_sc_hd__fill_2
XFILLER_18_5 vssd1 vssd1 vccd1 vccd1 sky130_fd_sc_hd__fill_2
XFILLER_33_187 vssd1 vssd1 vccd1 vccd1 sky130_fd_sc_hd__fill_2
XFILLER_33_154 vssd1 vssd1 vccd1 vccd1 sky130_fd_sc_hd__fill_1
XFILLER_33_132 vssd1 vssd1 vccd1 vccd1 sky130_fd_sc_hd__fill_4
X_0905_ clkload2/A _0905_/D _0911_/SET_B vssd1 vssd1 vccd1 vccd1 _0905_/Q sky130_fd_sc_hd__dfstp_2
X_0836_ _0877_/Q _0882_/Q _0878_/Q _0881_/Q vssd1 vssd1 vccd1 vccd1 _0837_/B sky130_fd_sc_hd__a22o_2
X_0767_ _0872_/Q _0870_/Q vssd1 vssd1 vccd1 vccd1 _0781_/B sky130_fd_sc_hd__nand2_2
XFILLER_0_209 vssd1 vccd1 vssd1 vccd1 sky130_ef_sc_hd__decap_40_12
X_0698_ _0676_/Y _0678_/X _0688_/Y vssd1 vssd1 vccd1 vccd1 _0700_/A sky130_fd_sc_hd__o21a_2
XFILLER_24_110 vssd1 vssd1 vccd1 vccd1 sky130_fd_sc_hd__fill_2
X_0621_ _0949_/Q _0955_/Q vssd1 vssd1 vccd1 vccd1 _0621_/Y sky130_fd_sc_hd__nor2_2
X_0552_ _0662_/A _0985_/Q _0990_/Q _0659_/A _0543_/Y vssd1 vssd1 vccd1 vccd1 _0555_/B
+ sky130_fd_sc_hd__o221a_2
X_0483_ _0971_/Q _0659_/A _0467_/X _0471_/X _0475_/X vssd1 vssd1 vccd1 vccd1 _0486_/B
+ sky130_fd_sc_hd__a2111o_2
XFILLER_23_3 vssd1 vssd1 vccd1 vccd1 sky130_fd_sc_hd__fill_4
XFILLER_21_113 vssd1 vssd1 vccd1 vccd1 sky130_fd_sc_hd__fill_2
X_0819_ _0811_/Y _0816_/B _0813_/B vssd1 vssd1 vccd1 vccd1 _0820_/B sky130_fd_sc_hd__a21o_2
XANTENNA_fanout30_A fanout35/X vssd1 vssd1 vccd1 vccd1 sky130_fd_sc_hd__diode_2
XTAP_TAPCELL_ROW_22_185 vssd1 vccd1 sky130_fd_sc_hd__tapvpwrvgnd_1
XFILLER_32_97 vssd1 vssd1 vccd1 vccd1 sky130_fd_sc_hd__fill_1
XTAP_TAPCELL_ROW_13_141 vssd1 vccd1 sky130_fd_sc_hd__tapvpwrvgnd_1
Xhold128 _0999_/Q vssd1 vssd1 vccd1 vccd1 _1001_/D sky130_fd_sc_hd__dlygate4sd3_1
Xhold139 _0934_/Q vssd1 vssd1 vccd1 vccd1 hold139/X sky130_fd_sc_hd__dlygate4sd3_1
X_0604_ _0927_/Q _0932_/Q vssd1 vssd1 vccd1 vccd1 _0707_/A sky130_fd_sc_hd__or2_2
XPHY_EDGE_ROW_9_Right_9 vssd1 vssd1 vccd1 vccd1 sky130_fd_sc_hd__decap_3
X_0535_ _0995_/Q input6/X vssd1 vssd1 vccd1 vccd1 _0535_/Y sky130_fd_sc_hd__nand2b_2
X_0466_ _0466_/A input1/X vssd1 vssd1 vccd1 vccd1 _0466_/X sky130_fd_sc_hd__and2_2
XTAP_TAPCELL_ROW_36_244 vssd1 vccd1 sky130_fd_sc_hd__tapvpwrvgnd_1
XPHY_EDGE_ROW_14_Left_53 vssd1 vssd1 vccd1 vccd1 sky130_fd_sc_hd__decap_3
XFILLER_27_97 vssd1 vccd1 vssd1 vccd1 sky130_ef_sc_hd__decap_40_12
X_0518_ _0974_/Q _0518_/B vssd1 vssd1 vccd1 vccd1 _0520_/C sky130_fd_sc_hd__or2_2
X_0449_ _0454_/A _0449_/B vssd1 vssd1 vccd1 vccd1 _0937_/D sky130_fd_sc_hd__and2_2
XFILLER_14_219 vssd1 vssd1 vccd1 vccd1 sky130_fd_sc_hd__fill_2
Xfanout23 _0964_/Q vssd1 vssd1 vccd1 vccd1 _0454_/A sky130_fd_sc_hd__clkdlybuf4s25_1
Xfanout34 fanout35/X vssd1 vssd1 vccd1 vccd1 fanout34/X sky130_fd_sc_hd__clkdlybuf4s25_1
Xfanout45 _0466_/X vssd1 vssd1 vccd1 vccd1 fanout45/X sky130_fd_sc_hd__clkdlybuf4s25_1
XFILLER_22_230 vssd1 vssd1 vccd1 vccd1 sky130_fd_sc_hd__fill_1
XFILLER_13_66 vssd1 vssd1 vccd1 vccd1 sky130_fd_sc_hd__fill_4
XFILLER_38_41 vssd1 vssd1 vccd1 vccd1 sky130_fd_sc_hd__fill_8
XFILLER_1_145 vssd1 vssd1 vccd1 vccd1 sky130_fd_sc_hd__fill_2
XANTENNA_input10_A gpio_in[2] vssd1 vssd1 vccd1 vccd1 sky130_fd_sc_hd__diode_2
XFILLER_38_85 vssd1 vssd1 vccd1 vccd1 sky130_fd_sc_hd__fill_1
XFILLER_13_252 vssd1 vssd1 vccd1 vccd1 sky130_fd_sc_hd__fill_2
XTAP_TAPCELL_ROW_30_217 vssd1 vccd1 sky130_fd_sc_hd__tapvpwrvgnd_1
X_0998_ clkload6/A _0998_/D fanout33/X vssd1 vssd1 vccd1 vccd1 _0998_/Q sky130_fd_sc_hd__dfrtp_2
Xclkload9 clkload9/A vssd1 vssd1 vccd1 vccd1 clkload9/X sky130_fd_sc_hd__clkbuf_4
XANTENNA_input2_A gpio_in[0] vssd1 vssd1 vccd1 vccd1 sky130_fd_sc_hd__diode_2
XFILLER_10_211 vssd1 vssd1 vccd1 vccd1 sky130_fd_sc_hd__fill_2
XFILLER_10_244 vssd1 vssd1 vccd1 vccd1 sky130_fd_sc_hd__fill_8
X_0921_ _0938_/CLK _0921_/D load_slew49/X vssd1 vssd1 vccd1 vccd1 _0921_/Q sky130_fd_sc_hd__dfrtp_2
X_0852_ _0905_/Q _0914_/Q _0854_/S vssd1 vssd1 vccd1 vccd1 _0905_/D sky130_fd_sc_hd__mux2_1
X_0783_ _0783_/A _0783_/B _0783_/C vssd1 vssd1 vccd1 vccd1 _0783_/X sky130_fd_sc_hd__and3_2
XTAP_TAPCELL_ROW_1_90 vssd1 vccd1 sky130_fd_sc_hd__tapvpwrvgnd_1
Xinput2 gpio_in[0] vssd1 vssd1 vccd1 vccd1 input2/X sky130_fd_sc_hd__clkdlybuf4s25_1
XFILLER_28_119 vssd1 vccd1 vssd1 vccd1 sky130_ef_sc_hd__decap_40_12
XFILLER_35_53 vssd1 vssd1 vccd1 vccd1 sky130_fd_sc_hd__fill_2
XFILLER_27_141 vssd1 vssd1 vccd1 vccd1 sky130_fd_sc_hd__fill_2
XPHY_EDGE_ROW_2_Left_41 vssd1 vssd1 vccd1 vccd1 sky130_fd_sc_hd__decap_3
XFILLER_33_111 vssd1 vssd1 vccd1 vccd1 sky130_fd_sc_hd__fill_1
X_0904_ clkload2/A _0904_/D _0911_/SET_B vssd1 vssd1 vccd1 vccd1 _0904_/Q sky130_fd_sc_hd__dfstp_2
X_0835_ _0881_/Q _0877_/Q _0835_/C vssd1 vssd1 vccd1 vccd1 _0837_/A sky130_fd_sc_hd__nand3_2
X_0766_ _0781_/A _0766_/B vssd1 vssd1 vccd1 vccd1 _0768_/A sky130_fd_sc_hd__nand2_2
X_0697_ _0674_/X _0689_/Y _0690_/Y _0934_/Q _0929_/Q vssd1 vssd1 vccd1 vccd1 _0697_/X
+ sky130_fd_sc_hd__o32a_2
XFILLER_21_11 vssd1 vssd1 vccd1 vccd1 sky130_fd_sc_hd__fill_1
Xmax_cap53 input5/X vssd1 vssd1 vccd1 vccd1 _0651_/A sky130_fd_sc_hd__buf_2
XFILLER_30_169 vssd1 vssd1 vccd1 vccd1 sky130_fd_sc_hd__fill_1
X_0620_ _0417_/Y _0465_/B _0465_/C _0619_/X _0434_/Y vssd1 vssd1 vccd1 vccd1 _0955_/D
+ sky130_fd_sc_hd__a32o_2
X_0551_ _0419_/A _0564_/A _0539_/Y _0542_/Y _0546_/Y vssd1 vssd1 vccd1 vccd1 _0555_/A
+ sky130_fd_sc_hd__o2111a_2
X_0482_ _0968_/Q _0656_/A _0470_/X _0472_/X _0474_/X vssd1 vssd1 vccd1 vccd1 _0486_/A
+ sky130_fd_sc_hd__a2111o_2
XANTENNA_clkbuf_4_8_0_clk_A clkbuf_0_clk/X vssd1 vssd1 vccd1 vccd1 sky130_fd_sc_hd__diode_2
X_0818_ _0880_/Q _0877_/Q _0808_/B _0806_/X vssd1 vssd1 vccd1 vccd1 _0820_/A sky130_fd_sc_hd__a31o_2
X_0749_ _0748_/B _0748_/C _0748_/A vssd1 vssd1 vccd1 vccd1 _0752_/A sky130_fd_sc_hd__a21oi_2
XTAP_TAPCELL_ROW_8_118 vssd1 vccd1 sky130_fd_sc_hd__tapvpwrvgnd_1
XTAP_TAPCELL_ROW_13_142 vssd1 vccd1 sky130_fd_sc_hd__tapvpwrvgnd_1
Xhold129 _0945_/Q vssd1 vssd1 vccd1 vccd1 _0941_/D sky130_fd_sc_hd__dlygate4sd3_1
X_0603_ _0416_/Y _0928_/Q hold141/X vssd1 vssd1 vccd1 vccd1 _0603_/X sky130_fd_sc_hd__a21o_2
X_0534_ _0467_/B _0987_/Q vssd1 vssd1 vccd1 vccd1 _0534_/Y sky130_fd_sc_hd__nand2b_2
X_0465_ _0900_/Q _0465_/B _0465_/C vssd1 vssd1 vccd1 vccd1 _0951_/D sky130_fd_sc_hd__and3_2
XTAP_TAPCELL_ROW_36_245 vssd1 vccd1 sky130_fd_sc_hd__tapvpwrvgnd_1
XFILLER_27_76 vssd1 vssd1 vccd1 vccd1 sky130_fd_sc_hd__fill_8
XFILLER_27_65 vssd1 vssd1 vccd1 vccd1 sky130_fd_sc_hd__fill_2
XFILLER_27_43 vssd1 vssd1 vccd1 vccd1 sky130_fd_sc_hd__fill_1
XANTENNA__0961__CLK clkload7/A vssd1 vssd1 vccd1 vccd1 sky130_fd_sc_hd__diode_2
XPHY_EDGE_ROW_31_Left_70 vssd1 vssd1 vccd1 vccd1 sky130_fd_sc_hd__decap_3
XFILLER_16_250 vssd1 vssd1 vccd1 vccd1 sky130_fd_sc_hd__fill_2
XFILLER_23_209 vssd1 vssd1 vccd1 vccd1 sky130_fd_sc_hd__fill_1
X_0517_ _0517_/A vssd1 vssd1 vccd1 vccd1 _0973_/D sky130_fd_sc_hd__inv_2
XFILLER_14_209 vssd1 vssd1 vccd1 vccd1 sky130_fd_sc_hd__fill_2
X_0448_ _0454_/A _0448_/B vssd1 vssd1 vccd1 vccd1 _0938_/D sky130_fd_sc_hd__and2_2
Xfanout24 _0944_/Q vssd1 vssd1 vccd1 vccd1 _0854_/S sky130_fd_sc_hd__clkdlybuf4s25_1
Xfanout35 fanout40/X vssd1 vssd1 vccd1 vccd1 fanout35/X sky130_fd_sc_hd__clkdlybuf4s25_1
Xfanout46 fanout52/X vssd1 vssd1 vccd1 vccd1 fanout46/X sky130_fd_sc_hd__clkdlybuf4s25_1
XFILLER_22_253 vssd1 vssd1 vccd1 vccd1 sky130_fd_sc_hd__fill_2
XFILLER_1_113 vssd1 vssd1 vccd1 vccd1 sky130_fd_sc_hd__fill_4
XTAP_TAPCELL_ROW_30_218 vssd1 vccd1 sky130_fd_sc_hd__tapvpwrvgnd_1
X_0997_ clkload6/A _0997_/D fanout40/X vssd1 vssd1 vccd1 vccd1 _0997_/Q sky130_fd_sc_hd__dfrtp_2
XFILLER_24_77 vssd1 vssd1 vccd1 vccd1 sky130_fd_sc_hd__fill_4
XFILLER_24_66 vssd1 vssd1 vccd1 vccd1 sky130_fd_sc_hd__fill_2
X_0920_ _0977_/CLK _0920_/D load_slew49/X vssd1 vssd1 vccd1 vccd1 _0920_/Q sky130_fd_sc_hd__dfrtp_2
X_0851_ _0904_/Q _0913_/Q _0854_/S vssd1 vssd1 vccd1 vccd1 _0904_/D sky130_fd_sc_hd__mux2_1
X_0782_ _0783_/B _0783_/C _0783_/A vssd1 vssd1 vccd1 vccd1 _0782_/Y sky130_fd_sc_hd__a21oi_2
XPHY_EDGE_ROW_18_Right_18 vssd1 vssd1 vccd1 vccd1 sky130_fd_sc_hd__decap_3
Xinput3 gpio_in[10] vssd1 vssd1 vccd1 vccd1 input3/X sky130_fd_sc_hd__clkdlybuf4s25_1
XPHY_EDGE_ROW_27_Right_27 vssd1 vssd1 vccd1 vccd1 sky130_fd_sc_hd__decap_3
XFILLER_36_197 vssd1 vssd1 vccd1 vccd1 sky130_fd_sc_hd__fill_1
XPHY_EDGE_ROW_36_Right_36 vssd1 vssd1 vccd1 vccd1 sky130_fd_sc_hd__decap_3
XFILLER_32_9 vssd1 vssd1 vccd1 vccd1 sky130_fd_sc_hd__fill_1
XFILLER_18_197 vssd1 vssd1 vccd1 vccd1 sky130_fd_sc_hd__fill_4
X_0903_ _0903_/CLK _0903_/D fanout32/X vssd1 vssd1 vccd1 vccd1 _0903_/Q sky130_fd_sc_hd__dfstp_2
X_0834_ _0882_/Q _0878_/Q vssd1 vssd1 vccd1 vccd1 _0835_/C sky130_fd_sc_hd__and2_2
X_0765_ _0873_/Q _0869_/Q _0874_/Q _0868_/Q vssd1 vssd1 vccd1 vccd1 _0766_/B sky130_fd_sc_hd__a22o_2
X_0696_ _0674_/X _0690_/Y _0689_/Y vssd1 vssd1 vccd1 vccd1 _0696_/Y sky130_fd_sc_hd__o21ai_2
XANTENNA_clkbuf_4_4_0_clk_A clkbuf_0_clk/X vssd1 vssd1 vccd1 vccd1 sky130_fd_sc_hd__diode_2
XTAP_TAPCELL_ROW_19_170 vssd1 vccd1 sky130_fd_sc_hd__tapvpwrvgnd_1
XFILLER_24_112 vssd1 vssd1 vccd1 vccd1 sky130_fd_sc_hd__fill_1
Xmax_cap54 _0541_/B vssd1 vssd1 vccd1 vccd1 _0658_/A sky130_fd_sc_hd__buf_2
XTAP_TAPCELL_ROW_25_195 vssd1 vccd1 sky130_fd_sc_hd__tapvpwrvgnd_1
XFILLER_30_104 vssd1 vssd1 vccd1 vccd1 sky130_fd_sc_hd__fill_2
X_0550_ _0633_/A _0992_/Q _0991_/Q _0652_/A vssd1 vssd1 vccd1 vccd1 _0558_/B sky130_fd_sc_hd__o2bb2a_2
X_0481_ _0481_/A _0481_/B _0481_/C _0481_/D vssd1 vssd1 vccd1 vccd1 _0481_/X sky130_fd_sc_hd__or4_2
X_0817_ _0894_/Q _0816_/Y _0961_/Q vssd1 vssd1 vccd1 vccd1 _0894_/D sky130_fd_sc_hd__mux2_1
X_0748_ _0748_/A _0748_/B _0748_/C vssd1 vssd1 vccd1 vccd1 _0748_/X sky130_fd_sc_hd__and3_2
X_0679_ _0892_/Q _0884_/Q vssd1 vssd1 vccd1 vccd1 _0683_/B sky130_fd_sc_hd__or2_2
XTAP_TAPCELL_ROW_8_119 vssd1 vccd1 sky130_fd_sc_hd__tapvpwrvgnd_1
XPHY_EDGE_ROW_0_Right_0 vssd1 vssd1 vccd1 vccd1 sky130_fd_sc_hd__decap_3
XTAP_TAPCELL_ROW_13_143 vssd1 vccd1 sky130_fd_sc_hd__tapvpwrvgnd_1
X_0602_ _0928_/Q _0933_/Q vssd1 vssd1 vccd1 vccd1 _0602_/Y sky130_fd_sc_hd__nor2_2
X_0533_ input4/X _0993_/Q vssd1 vssd1 vccd1 vccd1 _0533_/Y sky130_fd_sc_hd__nand2b_2
X_0464_ _0900_/Q _0464_/B _0465_/C vssd1 vssd1 vccd1 vccd1 _0958_/D sky130_fd_sc_hd__and3_2
XTAP_TAPCELL_ROW_36_246 vssd1 vccd1 sky130_fd_sc_hd__tapvpwrvgnd_1
XTAP_TAPCELL_ROW_4_100 vssd1 vccd1 sky130_fd_sc_hd__tapvpwrvgnd_1
XFILLER_17_218 vssd1 vssd1 vccd1 vccd1 sky130_fd_sc_hd__fill_1
XANTENNA_clkbuf_4_12_0_clk_A clkbuf_0_clk/X vssd1 vssd1 vccd1 vccd1 sky130_fd_sc_hd__diode_2
X_0516_ _0526_/A _0516_/B _0518_/B vssd1 vssd1 vccd1 vccd1 _0517_/A sky130_fd_sc_hd__or3_2
X_0447_ _0447_/A _0454_/A vssd1 vssd1 vccd1 vccd1 _0939_/D sky130_fd_sc_hd__and2_2
Xfanout25 fanout29/X vssd1 vssd1 vccd1 vccd1 fanout25/X sky130_fd_sc_hd__clkdlybuf4s25_1
Xfanout36 fanout40/X vssd1 vssd1 vccd1 vccd1 fanout36/X sky130_fd_sc_hd__clkdlybuf4s25_1
XFILLER_1_169 vssd1 vssd1 vccd1 vccd1 sky130_fd_sc_hd__fill_2
XFILLER_13_254 vssd1 vssd1 vccd1 vccd1 sky130_fd_sc_hd__fill_1
XFILLER_9_225 vssd1 vssd1 vccd1 vccd1 sky130_fd_sc_hd__fill_4
XTAP_TAPCELL_ROW_30_219 vssd1 vccd1 sky130_fd_sc_hd__tapvpwrvgnd_1
X_0996_ clkload4/A _0996_/D fanout40/X vssd1 vssd1 vccd1 vccd1 _0996_/Q sky130_fd_sc_hd__dfrtp_2
XFILLER_10_202 vssd1 vssd1 vccd1 vccd1 sky130_fd_sc_hd__fill_1
XFILLER_10_213 vssd1 vssd1 vccd1 vccd1 sky130_fd_sc_hd__fill_1
XFILLER_1_49 vssd1 vssd1 vccd1 vccd1 sky130_fd_sc_hd__fill_1
X_0850_ _0903_/Q _0912_/Q _0854_/S vssd1 vssd1 vccd1 vccd1 _0903_/D sky130_fd_sc_hd__mux2_1
X_0781_ _0781_/A _0781_/B _0772_/B vssd1 vssd1 vccd1 vccd1 _0783_/C sky130_fd_sc_hd__or3b_2
Xinput4 gpio_in[11] vssd1 vssd1 vccd1 vccd1 input4/X sky130_fd_sc_hd__clkdlybuf4s25_1
XANTENNA_clkbuf_4_0_0_clk_A clkbuf_0_clk/X vssd1 vssd1 vccd1 vccd1 sky130_fd_sc_hd__diode_2
X_0979_ clkload3/A _0979_/D fanout27/X vssd1 vssd1 vccd1 vccd1 _0979_/Q sky130_fd_sc_hd__dfrtp_2
XFILLER_35_55 vssd1 vssd1 vccd1 vccd1 sky130_fd_sc_hd__fill_1
XFILLER_2_253 vssd1 vssd1 vccd1 vccd1 sky130_fd_sc_hd__fill_2
XFILLER_33_113 vssd1 vssd1 vccd1 vccd1 sky130_fd_sc_hd__fill_1
X_0902_ _0903_/CLK _0902_/D fanout32/X vssd1 vssd1 vccd1 vccd1 _0902_/Q sky130_fd_sc_hd__dfstp_2
X_0833_ _0829_/X _0833_/B _0833_/C vssd1 vssd1 vccd1 vccd1 _0838_/B sky130_fd_sc_hd__nand3b_2
X_0764_ _0868_/Q _0873_/Q _0869_/Q _0874_/Q vssd1 vssd1 vccd1 vccd1 _0781_/A sky130_fd_sc_hd__nand4_2
X_0695_ _0672_/Y _0673_/X _0691_/X _0939_/Q _0920_/Q vssd1 vssd1 vccd1 vccd1 _0695_/X
+ sky130_fd_sc_hd__o32a_2
XTAP_TAPCELL_ROW_19_171 vssd1 vccd1 sky130_fd_sc_hd__tapvpwrvgnd_1
XFILLER_24_157 vssd1 vssd1 vccd1 vccd1 sky130_fd_sc_hd__fill_4
XTAP_TAPCELL_ROW_25_196 vssd1 vccd1 sky130_fd_sc_hd__tapvpwrvgnd_1
X_0480_ _0970_/Q _0638_/A _0978_/Q _0653_/A vssd1 vssd1 vccd1 vccd1 _0481_/D sky130_fd_sc_hd__a22o_2
X_0816_ _0816_/A _0816_/B vssd1 vssd1 vccd1 vccd1 _0816_/Y sky130_fd_sc_hd__xnor2_2
X_0747_ _0746_/B _0746_/C _0746_/A vssd1 vssd1 vccd1 vccd1 _0748_/C sky130_fd_sc_hd__o21ai_2
X_0678_ _0895_/Q _0887_/Q vssd1 vssd1 vccd1 vccd1 _0678_/X sky130_fd_sc_hd__and2_2
XFILLER_12_138 vssd1 vssd1 vccd1 vccd1 sky130_fd_sc_hd__fill_2
X_0601_ _0929_/Q _0416_/Y hold139/X vssd1 vssd1 vccd1 vccd1 _0601_/X sky130_fd_sc_hd__a21o_2
XTAP_TAPCELL_ROW_13_144 vssd1 vccd1 sky130_fd_sc_hd__tapvpwrvgnd_1
X_0532_ _0978_/Q _0530_/A _0531_/Y vssd1 vssd1 vccd1 vccd1 _0978_/D sky130_fd_sc_hd__o21a_2
X_0463_ _0909_/Q _0899_/Q vssd1 vssd1 vccd1 vccd1 _0465_/C sky130_fd_sc_hd__nor2_2
XTAP_TAPCELL_ROW_36_247 vssd1 vccd1 sky130_fd_sc_hd__tapvpwrvgnd_1
Xteam_07 vssd1 vssd1 vccd1 vccd1 team_07/HI gpio_oeb[16] sky130_fd_sc_hd__conb_1
XTAP_TAPCELL_ROW_4_101 vssd1 vccd1 sky130_fd_sc_hd__tapvpwrvgnd_1
XFILLER_27_23 vssd1 vccd1 vssd1 vccd1 sky130_ef_sc_hd__decap_40_12
XFILLER_4_145 vssd1 vssd1 vccd1 vccd1 sky130_fd_sc_hd__fill_2
XPHY_EDGE_ROW_18_Left_57 vssd1 vssd1 vccd1 vccd1 sky130_fd_sc_hd__decap_3
X_0515_ _0972_/Q _0973_/Q _0519_/D vssd1 vssd1 vccd1 vccd1 _0518_/B sky130_fd_sc_hd__and3_2
X_0446_ hold183/X _0863_/S _0445_/Y vssd1 vssd1 vccd1 vccd1 _0979_/D sky130_fd_sc_hd__o21a_2
Xfanout48 fanout48/A vssd1 vssd1 vccd1 vccd1 fanout48/X sky130_fd_sc_hd__clkdlybuf4s25_1
XFILLER_0_181 vssd1 vccd1 vssd1 vccd1 sky130_ef_sc_hd__decap_40_12
X_0995_ clkload6/A _0995_/D load_slew39/X vssd1 vssd1 vccd1 vccd1 _0995_/Q sky130_fd_sc_hd__dfrtp_2
X_0429_ input6/X vssd1 vssd1 vccd1 vccd1 _0429_/Y sky130_fd_sc_hd__inv_2
XFILLER_24_68 vssd1 vssd1 vccd1 vccd1 sky130_fd_sc_hd__fill_1
XFILLER_24_24 vssd1 vssd1 vccd1 vccd1 sky130_fd_sc_hd__fill_4
X_0780_ _0772_/A _0772_/B _0779_/Y _0766_/B vssd1 vssd1 vccd1 vccd1 _0783_/B sky130_fd_sc_hd__a22o_2
Xinput5 gpio_in[12] vssd1 vssd1 vccd1 vccd1 input5/X sky130_fd_sc_hd__buf_1
X_0978_ clkload6/A _0978_/D load_slew39/X vssd1 vssd1 vccd1 vccd1 _0978_/Q sky130_fd_sc_hd__dfrtp_2
XFILLER_27_166 vssd1 vssd1 vccd1 vccd1 sky130_fd_sc_hd__fill_2
XFILLER_27_133 vssd1 vssd1 vccd1 vccd1 sky130_fd_sc_hd__fill_8
XFILLER_27_111 vssd1 vssd1 vccd1 vccd1 sky130_fd_sc_hd__fill_1
XFILLER_19_57 vssd1 vssd1 vccd1 vccd1 sky130_fd_sc_hd__fill_1
XFILLER_33_169 vssd1 vssd1 vccd1 vccd1 sky130_fd_sc_hd__fill_1
XFILLER_33_136 vssd1 vssd1 vccd1 vccd1 sky130_fd_sc_hd__fill_2
XFILLER_33_103 vssd1 vssd1 vccd1 vccd1 sky130_fd_sc_hd__fill_8
X_0901_ _0903_/CLK _0901_/D _0911_/SET_B vssd1 vssd1 vccd1 vccd1 _0901_/Q sky130_fd_sc_hd__dfstp_2
X_0832_ _0833_/C _0833_/B _0829_/X vssd1 vssd1 vccd1 vccd1 _0838_/A sky130_fd_sc_hd__a21bo_2
X_0763_ _0761_/X _0762_/X _0886_/Q _0742_/B vssd1 vssd1 vccd1 vccd1 _0886_/D sky130_fd_sc_hd__a2bb2o_2
X_0694_ _0672_/Y _0673_/X _0691_/X vssd1 vssd1 vccd1 vccd1 _0694_/Y sky130_fd_sc_hd__o21ai_2
XPHY_EDGE_ROW_6_Left_45 vssd1 vssd1 vccd1 vccd1 sky130_fd_sc_hd__decap_3
XTAP_TAPCELL_ROW_25_197 vssd1 vccd1 sky130_fd_sc_hd__tapvpwrvgnd_1
Xclkbuf_4_9_0_clk clkbuf_0_clk/X vssd1 vssd1 vccd1 vccd1 clkload8/A sky130_fd_sc_hd__clkbuf_8
XFILLER_30_8 vssd1 vssd1 vccd1 vccd1 sky130_fd_sc_hd__fill_4
XFILLER_23_7 vssd1 vssd1 vccd1 vccd1 sky130_fd_sc_hd__fill_2
XFILLER_21_106 vssd1 vssd1 vccd1 vccd1 sky130_fd_sc_hd__fill_4
X_0815_ _0815_/A _0815_/B vssd1 vssd1 vccd1 vccd1 _0816_/B sky130_fd_sc_hd__xnor2_2
X_0746_ _0746_/A _0746_/B _0746_/C vssd1 vssd1 vccd1 vccd1 _0748_/B sky130_fd_sc_hd__or3_2
X_0677_ _0895_/Q _0887_/Q vssd1 vssd1 vccd1 vccd1 _0677_/X sky130_fd_sc_hd__or2_2
XFILLER_32_46 vssd1 vccd1 vssd1 vccd1 sky130_ef_sc_hd__decap_40_12
XFILLER_32_13 vssd1 vssd1 vccd1 vccd1 sky130_fd_sc_hd__fill_2
XFILLER_20_183 vssd1 vccd1 vssd1 vccd1 sky130_ef_sc_hd__decap_40_12
X_0600_ _0958_/Q _0951_/Q vssd1 vssd1 vccd1 vccd1 _1068_/A sky130_fd_sc_hd__or2_2
X_0531_ _0978_/Q _0530_/A _0526_/A vssd1 vssd1 vccd1 vccd1 _0531_/Y sky130_fd_sc_hd__a21oi_2
X_0462_ _0999_/Q _0940_/Q _1001_/Q vssd1 vssd1 vccd1 vccd1 _0943_/D sky130_fd_sc_hd__and3b_2
XTAP_TAPCELL_ROW_36_248 vssd1 vccd1 sky130_fd_sc_hd__tapvpwrvgnd_1
XFILLER_34_253 vssd1 vssd1 vccd1 vccd1 sky130_fd_sc_hd__fill_2
X_0729_ _0877_/Q _0903_/Q _0958_/Q vssd1 vssd1 vccd1 vccd1 _0877_/D sky130_fd_sc_hd__mux2_1
XTAP_TAPCELL_ROW_4_102 vssd1 vccd1 sky130_fd_sc_hd__tapvpwrvgnd_1
XTAP_TAPCELL_ROW_27_204 vssd1 vccd1 sky130_fd_sc_hd__tapvpwrvgnd_1
XFILLER_27_57 vssd1 vssd1 vccd1 vccd1 sky130_fd_sc_hd__fill_8
XFILLER_27_35 vssd1 vssd1 vccd1 vccd1 sky130_fd_sc_hd__fill_8
XFILLER_16_242 vssd1 vssd1 vccd1 vccd1 sky130_fd_sc_hd__fill_8
XFILLER_16_253 vssd1 vssd1 vccd1 vccd1 sky130_fd_sc_hd__fill_2
X_0514_ _0514_/A _0514_/B vssd1 vssd1 vccd1 vccd1 _0516_/B sky130_fd_sc_hd__and2_2
X_0445_ _0983_/Q _0445_/B vssd1 vssd1 vccd1 vccd1 _0445_/Y sky130_fd_sc_hd__nor2_2
Xfanout27 fanout29/X vssd1 vssd1 vccd1 vccd1 fanout27/X sky130_fd_sc_hd__clkdlybuf4s25_1
Xfanout38 fanout40/X vssd1 vssd1 vccd1 vccd1 fanout38/X sky130_fd_sc_hd__clkdlybuf4s25_1
XFILLER_13_223 vssd1 vssd1 vccd1 vccd1 sky130_fd_sc_hd__fill_1
XPHY_EDGE_ROW_35_Left_74 vssd1 vssd1 vccd1 vccd1 sky130_fd_sc_hd__decap_3
XFILLER_9_216 vssd1 vssd1 vccd1 vccd1 sky130_fd_sc_hd__fill_8
XFILLER_0_193 vssd1 vssd1 vccd1 vccd1 sky130_fd_sc_hd__fill_2
X_0994_ clkload4/A _0994_/D load_slew37/X vssd1 vssd1 vccd1 vccd1 _0994_/Q sky130_fd_sc_hd__dfrtp_2
X_0428_ _0976_/Q vssd1 vssd1 vccd1 vccd1 _0524_/A sky130_fd_sc_hd__inv_2
XFILLER_24_47 vssd1 vssd1 vccd1 vccd1 sky130_fd_sc_hd__fill_4
Xinput6 gpio_in[13] vssd1 vssd1 vccd1 vccd1 input6/X sky130_fd_sc_hd__clkdlybuf4s25_1
X_0977_ _0977_/CLK _0977_/D load_slew39/X vssd1 vssd1 vccd1 vccd1 _0977_/Q sky130_fd_sc_hd__dfrtp_2
XFILLER_35_57 vssd1 vssd1 vccd1 vccd1 sky130_fd_sc_hd__fill_4
XPHY_EDGE_ROW_14_Right_14 vssd1 vssd1 vccd1 vccd1 sky130_fd_sc_hd__decap_3
XPHY_EDGE_ROW_23_Right_23 vssd1 vssd1 vccd1 vccd1 sky130_fd_sc_hd__decap_3
XFILLER_2_211 vssd1 vssd1 vccd1 vccd1 sky130_fd_sc_hd__fill_1
X_0900_ clkload0/A _0900_/D _0913_/SET_B vssd1 vssd1 vccd1 vccd1 _0900_/Q sky130_fd_sc_hd__dfrtp_2
XPHY_EDGE_ROW_32_Right_32 vssd1 vssd1 vccd1 vccd1 sky130_fd_sc_hd__decap_3
XFILLER_25_90 vssd1 vccd1 vssd1 vccd1 sky130_ef_sc_hd__decap_40_12
X_0831_ _0833_/C _0831_/B _0831_/C vssd1 vssd1 vccd1 vccd1 _0831_/Y sky130_fd_sc_hd__nand3_2
X_0762_ _0752_/Y _0759_/Y _0742_/B vssd1 vssd1 vccd1 vccd1 _0762_/X sky130_fd_sc_hd__a21o_2
X_0693_ _0693_/A _0693_/B vssd1 vssd1 vccd1 vccd1 _0693_/Y sky130_fd_sc_hd__xnor2_2
XPHY_EDGE_ROW_22_Left_61 vssd1 vssd1 vccd1 vccd1 sky130_fd_sc_hd__decap_3
XFILLER_2_83 vssd1 vssd1 vccd1 vccd1 sky130_fd_sc_hd__fill_1
XFILLER_24_148 vssd1 vssd1 vccd1 vccd1 sky130_fd_sc_hd__fill_2
XFILLER_24_126 vssd1 vssd1 vccd1 vccd1 sky130_fd_sc_hd__fill_4
XFILLER_15_159 vssd1 vssd1 vccd1 vccd1 sky130_fd_sc_hd__fill_2
XTAP_TAPCELL_ROW_25_198 vssd1 vccd1 sky130_fd_sc_hd__tapvpwrvgnd_1
XFILLER_14_181 vssd1 vssd1 vccd1 vccd1 sky130_fd_sc_hd__fill_2
X_0814_ _0800_/A _0800_/B _0800_/C vssd1 vssd1 vccd1 vccd1 _0815_/B sky130_fd_sc_hd__o21ba_2
XTAP_TAPCELL_ROW_16_154 vssd1 vccd1 sky130_fd_sc_hd__tapvpwrvgnd_1
X_0745_ _0872_/Q _0868_/Q _0873_/Q _0867_/Q vssd1 vssd1 vccd1 vccd1 _0746_/C sky130_fd_sc_hd__a22oi_2
X_0676_ _0895_/Q _0887_/Q vssd1 vssd1 vccd1 vccd1 _0676_/Y sky130_fd_sc_hd__nor2_2
XFILLER_32_58 vssd1 vccd1 vssd1 vccd1 sky130_ef_sc_hd__decap_40_12
XFILLER_20_195 vssd1 vssd1 vccd1 vccd1 sky130_fd_sc_hd__fill_1
XFILLER_11_151 vssd1 vssd1 vccd1 vccd1 sky130_fd_sc_hd__fill_4
XFILLER_7_111 vssd1 vssd1 vccd1 vccd1 sky130_fd_sc_hd__fill_1
X_0530_ _0530_/A _0530_/B vssd1 vssd1 vccd1 vccd1 _0977_/D sky130_fd_sc_hd__nor2_2
XFILLER_22_80 vssd1 vssd1 vccd1 vccd1 sky130_fd_sc_hd__fill_1
X_0461_ _0999_/Q _1001_/Q vssd1 vssd1 vccd1 vccd1 _0461_/Y sky130_fd_sc_hd__nand2b_2
X_0728_ _0876_/Q _0902_/Q _0958_/Q vssd1 vssd1 vccd1 vccd1 _0876_/D sky130_fd_sc_hd__mux2_1
X_0659_ _0659_/A _0990_/D vssd1 vssd1 vccd1 vccd1 _0663_/B sky130_fd_sc_hd__nand2_2
XTAP_TAPCELL_ROW_4_103 vssd1 vccd1 sky130_fd_sc_hd__tapvpwrvgnd_1
XPHY_EDGE_ROW_4_Right_4 vssd1 vssd1 vccd1 vccd1 sky130_fd_sc_hd__decap_3
XTAP_TAPCELL_ROW_27_205 vssd1 vccd1 sky130_fd_sc_hd__tapvpwrvgnd_1
Xclkbuf_4_8_0_clk clkbuf_0_clk/X vssd1 vssd1 vccd1 vccd1 clkload7/A sky130_fd_sc_hd__clkbuf_8
XTAP_TAPCELL_ROW_10_127 vssd1 vccd1 sky130_fd_sc_hd__tapvpwrvgnd_1
XFILLER_4_18 vssd1 vssd1 vccd1 vccd1 sky130_fd_sc_hd__fill_1
XFILLER_4_169 vssd1 vccd1 vssd1 vccd1 sky130_ef_sc_hd__decap_40_12
XFILLER_4_147 vssd1 vssd1 vccd1 vccd1 sky130_fd_sc_hd__fill_1
XFILLER_16_221 vssd1 vssd1 vccd1 vccd1 sky130_fd_sc_hd__fill_2
X_0513_ _0972_/Q _0519_/D _0514_/B _0523_/A vssd1 vssd1 vccd1 vccd1 _0972_/D sky130_fd_sc_hd__o211a_2
X_0444_ _0415_/Y _0981_/Q _0980_/Q _0863_/S _0979_/Q vssd1 vssd1 vccd1 vccd1 _0445_/B
+ sky130_fd_sc_hd__o311a_2
XTAP_TAPCELL_ROW_32_230 vssd1 vccd1 sky130_fd_sc_hd__tapvpwrvgnd_1
XFILLER_38_57 vssd1 vccd1 vssd1 vccd1 sky130_ef_sc_hd__decap_40_12
XFILLER_1_117 vssd1 vssd1 vccd1 vccd1 sky130_fd_sc_hd__fill_1
XFILLER_0_150 vssd1 vssd1 vccd1 vccd1 sky130_fd_sc_hd__fill_4
X_0993_ clkload4/A _0993_/D load_slew37/X vssd1 vssd1 vccd1 vccd1 _0993_/Q sky130_fd_sc_hd__dfrtp_2
XFILLER_8_250 vssd1 vssd1 vccd1 vccd1 sky130_fd_sc_hd__fill_2
X_0427_ _0974_/Q vssd1 vssd1 vccd1 vccd1 _0427_/Y sky130_fd_sc_hd__inv_2
XFILLER_5_231 vssd1 vssd1 vccd1 vccd1 sky130_fd_sc_hd__fill_1
Xinput7 gpio_in[14] vssd1 vssd1 vccd1 vccd1 input7/X sky130_fd_sc_hd__clkdlybuf4s25_1
X_0976_ _0977_/CLK _0976_/D fanout52/X vssd1 vssd1 vccd1 vccd1 _0976_/Q sky130_fd_sc_hd__dfrtp_2
XFILLER_4_3 vssd1 vssd1 vccd1 vccd1 sky130_fd_sc_hd__fill_1
XFILLER_2_245 vssd1 vssd1 vccd1 vccd1 sky130_fd_sc_hd__fill_4
X_0830_ _0833_/C _0833_/B _0829_/X vssd1 vssd1 vccd1 vccd1 _0830_/X sky130_fd_sc_hd__a21o_2
X_0761_ _0752_/Y _0758_/Y _0771_/A vssd1 vssd1 vccd1 vccd1 _0761_/X sky130_fd_sc_hd__o21ba_2
X_0692_ _0672_/Y _0691_/X _0673_/X vssd1 vssd1 vccd1 vccd1 _0693_/B sky130_fd_sc_hd__o21ba_2
X_0959_ clkload7/A _0959_/D fanout33/X vssd1 vssd1 vccd1 vccd1 _0959_/Q sky130_fd_sc_hd__dfrtp_2
XFILLER_23_193 vssd1 vssd1 vccd1 vccd1 sky130_fd_sc_hd__fill_4
XFILLER_23_171 vssd1 vssd1 vccd1 vccd1 sky130_fd_sc_hd__fill_1
XANTENNA_clkload7_A clkload7/A vssd1 vssd1 vccd1 vccd1 sky130_fd_sc_hd__diode_2
XTAP_TAPCELL_ROW_16_155 vssd1 vccd1 sky130_fd_sc_hd__tapvpwrvgnd_1
Xinput10 gpio_in[2] vssd1 vssd1 vccd1 vccd1 _0547_/B sky130_fd_sc_hd__clkdlybuf4s25_1
X_0813_ _0813_/A _0813_/B vssd1 vssd1 vccd1 vccd1 _0816_/A sky130_fd_sc_hd__nor2_2
X_0744_ _0867_/Q _0872_/Q _0868_/Q _0873_/Q vssd1 vssd1 vccd1 vccd1 _0746_/B sky130_fd_sc_hd__and4_2
X_0675_ _0896_/Q _0888_/Q vssd1 vssd1 vccd1 vccd1 _0675_/Y sky130_fd_sc_hd__nand2_2
XFILLER_20_141 vssd1 vccd1 vssd1 vccd1 sky130_ef_sc_hd__decap_40_12
XFILLER_11_196 vssd1 vssd1 vccd1 vccd1 sky130_fd_sc_hd__fill_2
XTAP_TAPCELL_ROW_21_180 vssd1 vccd1 sky130_fd_sc_hd__tapvpwrvgnd_1
X_0460_ _0909_/Q _0460_/B vssd1 vssd1 vccd1 vccd1 _0944_/D sky130_fd_sc_hd__and2b_2
X_0727_ _0875_/Q _0901_/Q _0958_/Q vssd1 vssd1 vccd1 vccd1 _0875_/D sky130_fd_sc_hd__mux2_1
X_0658_ _0658_/A _0986_/D vssd1 vssd1 vccd1 vccd1 _0663_/A sky130_fd_sc_hd__xnor2_2
X_0589_ _0993_/Q _0994_/Q _0593_/D vssd1 vssd1 vccd1 vccd1 _0592_/B sky130_fd_sc_hd__and3_2
XTAP_TAPCELL_ROW_4_104 vssd1 vccd1 sky130_fd_sc_hd__tapvpwrvgnd_1
XTAP_TAPCELL_ROW_27_206 vssd1 vccd1 sky130_fd_sc_hd__tapvpwrvgnd_1
XFILLER_27_15 vssd1 vssd1 vccd1 vccd1 sky130_fd_sc_hd__fill_1
XTAP_TAPCELL_ROW_10_128 vssd1 vccd1 sky130_fd_sc_hd__tapvpwrvgnd_1
XFILLER_33_91 vssd1 vccd1 vssd1 vccd1 sky130_ef_sc_hd__decap_40_12
X_0512_ _0972_/Q _0519_/D vssd1 vssd1 vccd1 vccd1 _0514_/B sky130_fd_sc_hd__nand2_2
X_0443_ _0628_/A _0442_/X _0441_/Y _0414_/Y vssd1 vssd1 vccd1 vccd1 _0982_/D sky130_fd_sc_hd__o211a_2
Xfanout29 fanout35/X vssd1 vssd1 vccd1 vccd1 fanout29/X sky130_fd_sc_hd__clkdlybuf4s25_1
XFILLER_38_69 vssd1 vssd1 vccd1 vccd1 sky130_fd_sc_hd__fill_4
XFILLER_13_225 vssd1 vssd1 vccd1 vccd1 sky130_fd_sc_hd__fill_2
XANTENNA__0997__RESET_B fanout40/X vssd1 vssd1 vccd1 vccd1 sky130_fd_sc_hd__diode_2
XFILLER_9_229 vssd1 vssd1 vccd1 vccd1 sky130_fd_sc_hd__fill_2
XFILLER_0_195 vssd1 vssd1 vccd1 vccd1 sky130_fd_sc_hd__fill_1
X_0992_ clkload4/A _0992_/D load_slew37/X vssd1 vssd1 vccd1 vccd1 _0992_/Q sky130_fd_sc_hd__dfrtp_2
Xclkbuf_4_7_0_clk clkbuf_0_clk/X vssd1 vssd1 vccd1 vccd1 clkload6/A sky130_fd_sc_hd__clkbuf_8
X_0426_ input3/X vssd1 vssd1 vccd1 vccd1 _0633_/A sky130_fd_sc_hd__inv_2
XANTENNA__0967__CLK clkload7/A vssd1 vssd1 vccd1 vccd1 sky130_fd_sc_hd__diode_2
Xinput8 gpio_in[15] vssd1 vssd1 vccd1 vccd1 input8/X sky130_fd_sc_hd__clkdlybuf4s25_1
X_0975_ _0977_/CLK _0975_/D fanout52/X vssd1 vssd1 vccd1 vccd1 _0975_/Q sky130_fd_sc_hd__dfrtp_2
XFILLER_18_125 vssd1 vssd1 vccd1 vccd1 sky130_fd_sc_hd__fill_1
X_0760_ _0752_/Y _0758_/Y _0759_/Y vssd1 vssd1 vccd1 vccd1 _0771_/A sky130_fd_sc_hd__a21o_2
X_0691_ _0675_/Y _0689_/Y _0690_/Y vssd1 vssd1 vccd1 vccd1 _0691_/X sky130_fd_sc_hd__a21o_2
XFILLER_24_106 vssd1 vssd1 vccd1 vccd1 sky130_fd_sc_hd__fill_4
X_0889_ clkload8/A _0889_/D _0919_/SET_B vssd1 vssd1 vccd1 vccd1 _0889_/Q sky130_fd_sc_hd__dfstp_2
X_0958_ clkload0/A _0958_/D fanout29/X vssd1 vssd1 vccd1 vccd1 _0958_/Q sky130_fd_sc_hd__dfrtp_2
XTAP_TAPCELL_ROW_16_156 vssd1 vccd1 sky130_fd_sc_hd__tapvpwrvgnd_1
Xinput11 gpio_in[3] vssd1 vssd1 vccd1 vccd1 _0419_/A sky130_fd_sc_hd__clkdlybuf4s25_1
X_0812_ _0879_/Q _0878_/Q _0811_/C vssd1 vssd1 vccd1 vccd1 _0813_/B sky130_fd_sc_hd__a21oi_2
X_0743_ _0871_/Q _0869_/Q vssd1 vssd1 vccd1 vccd1 _0746_/A sky130_fd_sc_hd__and2_2
X_0674_ _0896_/Q _0888_/Q vssd1 vssd1 vccd1 vccd1 _0674_/X sky130_fd_sc_hd__and2_2
XFILLER_28_253 vssd1 vssd1 vccd1 vccd1 sky130_fd_sc_hd__fill_2
XFILLER_11_164 vssd1 vssd1 vccd1 vccd1 sky130_fd_sc_hd__fill_4
XFILLER_7_146 vssd1 vssd1 vccd1 vccd1 sky130_fd_sc_hd__fill_1
XFILLER_7_113 vssd1 vssd1 vccd1 vccd1 sky130_fd_sc_hd__fill_4
XFILLER_19_253 vssd1 vssd1 vccd1 vccd1 sky130_fd_sc_hd__fill_2
X_0726_ _0874_/Q _0908_/Q _0951_/Q vssd1 vssd1 vccd1 vccd1 _0874_/D sky130_fd_sc_hd__mux2_1
X_0657_ _0657_/A _0988_/D vssd1 vssd1 vccd1 vccd1 _0657_/Y sky130_fd_sc_hd__xnor2_2
X_0588_ _0993_/Q _0593_/D _0994_/Q vssd1 vssd1 vccd1 vccd1 _0590_/B sky130_fd_sc_hd__a21oi_2
XTAP_TAPCELL_ROW_35_240 vssd1 vccd1 sky130_fd_sc_hd__tapvpwrvgnd_1
XTAP_TAPCELL_ROW_27_207 vssd1 vccd1 sky130_fd_sc_hd__tapvpwrvgnd_1
XFILLER_25_245 vssd1 vssd1 vccd1 vccd1 sky130_fd_sc_hd__fill_2
XTAP_TAPCELL_ROW_10_129 vssd1 vccd1 sky130_fd_sc_hd__tapvpwrvgnd_1
XANTENNA_input17_A gpio_in[9] vssd1 vssd1 vccd1 vccd1 sky130_fd_sc_hd__diode_2
Xteam_07_90 vssd1 vssd1 vccd1 vccd1 gpio_oeb[1] team_07_90/LO sky130_fd_sc_hd__conb_1
X_0511_ _0481_/X _0486_/X _0510_/X _0458_/A vssd1 vssd1 vccd1 vccd1 _0971_/D sky130_fd_sc_hd__o211a_2
XFILLER_12_3 vssd1 vssd1 vccd1 vccd1 sky130_fd_sc_hd__fill_1
X_0442_ _0981_/Q _0980_/Q _0438_/Y _0982_/Q vssd1 vssd1 vccd1 vccd1 _0442_/X sky130_fd_sc_hd__o31a_2
XANTENNA__0873__CLK clkload7/A vssd1 vssd1 vccd1 vccd1 sky130_fd_sc_hd__diode_2
X_0709_ _0922_/Q _0935_/Q _0891_/Q _0883_/Q vssd1 vssd1 vccd1 vccd1 _0710_/B sky130_fd_sc_hd__o22ai_2
XANTENNA_input9_A gpio_in[1] vssd1 vssd1 vccd1 vccd1 sky130_fd_sc_hd__diode_2
XFILLER_38_26 vssd1 vssd1 vccd1 vccd1 sky130_fd_sc_hd__fill_2
XFILLER_13_215 vssd1 vssd1 vccd1 vccd1 sky130_fd_sc_hd__fill_8
XFILLER_13_248 vssd1 vssd1 vccd1 vccd1 sky130_fd_sc_hd__fill_4
XFILLER_0_163 vssd1 vssd1 vccd1 vccd1 sky130_fd_sc_hd__fill_4
X_0991_ clkload4/A _0991_/D load_slew37/X vssd1 vssd1 vccd1 vccd1 _0991_/Q sky130_fd_sc_hd__dfrtp_2
X_0425_ _0973_/Q vssd1 vssd1 vccd1 vccd1 _0514_/A sky130_fd_sc_hd__inv_2
Xinput9 gpio_in[1] vssd1 vssd1 vccd1 vccd1 input9/X sky130_fd_sc_hd__clkdlybuf4s25_1
XFILLER_36_115 vssd1 vssd1 vccd1 vccd1 sky130_fd_sc_hd__fill_1
X_0974_ _0990_/CLK _0974_/D _0919_/SET_B vssd1 vssd1 vccd1 vccd1 _0974_/Q sky130_fd_sc_hd__dfrtp_2
XFILLER_35_38 vssd1 vssd1 vccd1 vccd1 sky130_fd_sc_hd__fill_2
XFILLER_2_225 vssd1 vssd1 vccd1 vccd1 sky130_fd_sc_hd__fill_1
XFILLER_26_192 vssd1 vssd1 vccd1 vccd1 sky130_fd_sc_hd__fill_4
XFILLER_26_181 vssd1 vssd1 vccd1 vccd1 sky130_fd_sc_hd__fill_4
Xclkbuf_4_6_0_clk clkbuf_0_clk/X vssd1 vssd1 vccd1 vccd1 clkload5/A sky130_fd_sc_hd__clkbuf_8
X_0690_ _0896_/Q _0888_/Q vssd1 vssd1 vccd1 vccd1 _0690_/Y sky130_fd_sc_hd__nor2_2
XPHY_EDGE_ROW_10_Right_10 vssd1 vssd1 vccd1 vccd1 sky130_fd_sc_hd__decap_3
XFILLER_32_195 vssd1 vssd1 vccd1 vccd1 sky130_fd_sc_hd__fill_1
X_0888_ clkload9/A _0888_/D fanout43/X vssd1 vssd1 vccd1 vccd1 _0888_/Q sky130_fd_sc_hd__dfstp_2
X_0957_ clkload6/A _0957_/D fanout33/X vssd1 vssd1 vccd1 vccd1 _0957_/Q sky130_fd_sc_hd__dfrtp_2
XTAP_TAPCELL_ROW_16_157 vssd1 vccd1 sky130_fd_sc_hd__tapvpwrvgnd_1
XPHY_EDGE_ROW_26_Left_65 vssd1 vssd1 vccd1 vccd1 sky130_fd_sc_hd__decap_3
Xinput12 gpio_in[4] vssd1 vssd1 vccd1 vccd1 _0541_/B sky130_fd_sc_hd__buf_1
X_0811_ _0879_/Q _0878_/Q _0811_/C vssd1 vssd1 vccd1 vccd1 _0811_/Y sky130_fd_sc_hd__nand3_2
X_0742_ _0742_/A _0742_/B vssd1 vssd1 vccd1 vccd1 _0742_/Y sky130_fd_sc_hd__nand2_2
X_0673_ _0897_/Q _0889_/Q vssd1 vssd1 vccd1 vccd1 _0673_/X sky130_fd_sc_hd__and2_2
XTAP_TAPCELL_ROW_24_190 vssd1 vccd1 sky130_fd_sc_hd__tapvpwrvgnd_1
XPHY_EDGE_ROW_10_Left_49 vssd1 vssd1 vccd1 vccd1 sky130_fd_sc_hd__decap_3
XFILLER_37_254 vssd1 vssd1 vccd1 vccd1 sky130_fd_sc_hd__fill_1
XTAP_TAPCELL_ROW_7_114 vssd1 vccd1 sky130_fd_sc_hd__tapvpwrvgnd_1
XFILLER_11_132 vssd1 vssd1 vccd1 vccd1 sky130_fd_sc_hd__fill_1
XTAP_TAPCELL_ROW_38_260 vssd1 vccd1 sky130_fd_sc_hd__tapvpwrvgnd_1
XFILLER_11_198 vssd1 vssd1 vccd1 vccd1 sky130_fd_sc_hd__fill_1
XFILLER_7_169 vssd1 vccd1 vssd1 vccd1 sky130_ef_sc_hd__decap_40_12
X_0725_ _0873_/Q _0907_/Q _0951_/Q vssd1 vssd1 vccd1 vccd1 _0873_/D sky130_fd_sc_hd__mux2_1
X_0656_ _0656_/A _0987_/D vssd1 vssd1 vccd1 vccd1 _0656_/Y sky130_fd_sc_hd__xnor2_2
X_0587_ _0993_/Q _0593_/D _0586_/Y vssd1 vssd1 vccd1 vccd1 _0993_/D sky130_fd_sc_hd__o21a_2
XTAP_TAPCELL_ROW_35_241 vssd1 vccd1 sky130_fd_sc_hd__tapvpwrvgnd_1
Xteam_07_91 vssd1 vssd1 vccd1 vccd1 gpio_oeb[2] team_07_91/LO sky130_fd_sc_hd__conb_1
Xteam_07_80 vssd1 vssd1 vccd1 vccd1 team_07_80/HI gpio_out[25] sky130_fd_sc_hd__conb_1
XFILLER_16_213 vssd1 vssd1 vccd1 vccd1 sky130_fd_sc_hd__fill_8
X_0510_ _0971_/Q _0510_/B vssd1 vssd1 vccd1 vccd1 _0510_/X sky130_fd_sc_hd__xor2_2
X_0441_ _0982_/Q _0628_/A vssd1 vssd1 vccd1 vccd1 _0441_/Y sky130_fd_sc_hd__nand2_2
XPHY_EDGE_ROW_8_Right_8 vssd1 vssd1 vccd1 vccd1 sky130_fd_sc_hd__decap_3
XFILLER_22_216 vssd1 vccd1 vssd1 vccd1 sky130_ef_sc_hd__decap_40_12
X_0708_ _0921_/Q _0708_/B _0938_/Q _0602_/Y vssd1 vssd1 vccd1 vccd1 _0708_/X sky130_fd_sc_hd__or4b_2
X_0639_ _0662_/A _0966_/D _0636_/Y _0637_/Y _0638_/Y vssd1 vssd1 vccd1 vccd1 _0645_/A
+ sky130_fd_sc_hd__o2111ai_2
XPHY_EDGE_ROW_13_Left_52 vssd1 vssd1 vccd1 vccd1 sky130_fd_sc_hd__decap_3
XFILLER_38_49 vssd1 vssd1 vccd1 vccd1 sky130_fd_sc_hd__fill_1
XFILLER_13_227 vssd1 vssd1 vccd1 vccd1 sky130_fd_sc_hd__fill_1
XFILLER_28_82 vssd1 vssd1 vccd1 vccd1 sky130_fd_sc_hd__fill_2
X_0990_ _0990_/CLK _0990_/D load_slew39/X vssd1 vssd1 vccd1 vccd1 _0990_/Q sky130_fd_sc_hd__dfrtp_2
XFILLER_8_253 vssd1 vssd1 vccd1 vccd1 sky130_fd_sc_hd__fill_2
X_0424_ _0476_/B vssd1 vssd1 vccd1 vccd1 _0652_/A sky130_fd_sc_hd__inv_2
XTAP_TAPCELL_ROW_1_87 vssd1 vccd1 sky130_fd_sc_hd__tapvpwrvgnd_1
X_0973_ _0977_/CLK _0973_/D _0919_/SET_B vssd1 vssd1 vccd1 vccd1 _0973_/Q sky130_fd_sc_hd__dfrtp_2
XANTENNA__0886__CLK clkload7/A vssd1 vssd1 vccd1 vccd1 sky130_fd_sc_hd__diode_2
X_0956_ clkload8/A _0956_/D fanout38/X vssd1 vssd1 vccd1 vccd1 _0956_/Q sky130_fd_sc_hd__dfrtp_2
X_0887_ _0939_/CLK _0887_/D fanout43/X vssd1 vssd1 vccd1 vccd1 _0887_/Q sky130_fd_sc_hd__dfstp_2
XPHY_EDGE_ROW_1_Left_40 vssd1 vssd1 vccd1 vccd1 sky130_fd_sc_hd__decap_3
XFILLER_14_141 vssd1 vssd1 vccd1 vccd1 sky130_fd_sc_hd__fill_2
Xinput13 gpio_in[5] vssd1 vssd1 vccd1 vccd1 _0467_/B sky130_fd_sc_hd__clkdlybuf4s25_1
X_0810_ _0879_/Q _0878_/Q _0811_/C vssd1 vssd1 vccd1 vccd1 _0813_/A sky130_fd_sc_hd__and3_2
XTAP_TAPCELL_ROW_24_191 vssd1 vccd1 sky130_fd_sc_hd__tapvpwrvgnd_1
XTAP_TAPCELL_ROW_16_158 vssd1 vccd1 sky130_fd_sc_hd__tapvpwrvgnd_1
X_0741_ _0884_/Q _0742_/B _0737_/X _0740_/Y vssd1 vssd1 vccd1 vccd1 _0884_/D sky130_fd_sc_hd__a22o_2
X_0672_ _0897_/Q _0889_/Q vssd1 vssd1 vccd1 vccd1 _0672_/Y sky130_fd_sc_hd__nor2_2
XFILLER_37_211 vssd1 vssd1 vccd1 vccd1 sky130_fd_sc_hd__fill_2
X_0939_ _0939_/CLK _0939_/D fanout48/A vssd1 vssd1 vccd1 vccd1 _0939_/Q sky130_fd_sc_hd__dfrtp_2
XFILLER_32_29 vssd1 vssd1 vccd1 vccd1 sky130_fd_sc_hd__fill_8
XFILLER_20_100 vssd1 vssd1 vccd1 vccd1 sky130_fd_sc_hd__fill_4
XTAP_TAPCELL_ROW_7_115 vssd1 vccd1 sky130_fd_sc_hd__tapvpwrvgnd_1
Xclkbuf_4_5_0_clk clkbuf_0_clk/X vssd1 vssd1 vccd1 vccd1 clkload4/A sky130_fd_sc_hd__clkbuf_8
XTAP_TAPCELL_ROW_38_261 vssd1 vccd1 sky130_fd_sc_hd__tapvpwrvgnd_1
XFILLER_11_155 vssd1 vssd1 vccd1 vccd1 sky130_fd_sc_hd__fill_1
XFILLER_7_126 vssd1 vssd1 vccd1 vccd1 sky130_fd_sc_hd__fill_2
XANTENNA__0947__CLK clkload7/A vssd1 vssd1 vccd1 vccd1 sky130_fd_sc_hd__diode_2
X_0724_ _0872_/Q _0906_/Q _0951_/Q vssd1 vssd1 vccd1 vccd1 _0872_/D sky130_fd_sc_hd__mux2_1
X_0655_ input4/X _0993_/D vssd1 vssd1 vccd1 vccd1 _0655_/Y sky130_fd_sc_hd__xnor2_2
X_0586_ _0993_/Q _0593_/D _0590_/A vssd1 vssd1 vccd1 vccd1 _0586_/Y sky130_fd_sc_hd__a21oi_2
X_1069_ _1069_/A vssd1 vssd1 vccd1 vccd1 _1069_/X sky130_fd_sc_hd__buf_2
XTAP_TAPCELL_ROW_35_242 vssd1 vccd1 sky130_fd_sc_hd__tapvpwrvgnd_1
XFILLER_25_225 vssd1 vssd1 vccd1 vccd1 sky130_fd_sc_hd__fill_2
Xteam_07_92 vssd1 vssd1 vccd1 vccd1 gpio_oeb[3] team_07_92/LO sky130_fd_sc_hd__conb_1
Xteam_07_81 vssd1 vssd1 vccd1 vccd1 team_07_81/HI gpio_out[26] sky130_fd_sc_hd__conb_1
Xteam_07_70 vssd1 vssd1 vccd1 vccd1 team_07_70/HI gpio_out[13] sky130_fd_sc_hd__conb_1
X_0440_ _0981_/Q _0625_/B vssd1 vssd1 vccd1 vccd1 _0628_/A sky130_fd_sc_hd__and2_2
XFILLER_22_228 vssd1 vssd1 vccd1 vccd1 sky130_fd_sc_hd__fill_2
X_0707_ _0707_/A _0707_/B _0707_/C _0707_/D vssd1 vssd1 vccd1 vccd1 _0708_/B sky130_fd_sc_hd__or4_2
XFILLER_30_250 vssd1 vssd1 vccd1 vccd1 sky130_fd_sc_hd__fill_2
X_0638_ _0638_/A _0970_/D vssd1 vssd1 vccd1 vccd1 _0638_/Y sky130_fd_sc_hd__nand2_2
X_0569_ _0987_/Q _0575_/D vssd1 vssd1 vccd1 vccd1 _0570_/B sky130_fd_sc_hd__xnor2_2
XFILLER_0_132 vssd1 vssd1 vccd1 vccd1 sky130_fd_sc_hd__fill_8
XFILLER_12_250 vssd1 vssd1 vccd1 vccd1 sky130_fd_sc_hd__fill_2
X_0423_ _0637_/A vssd1 vssd1 vccd1 vccd1 _0659_/A sky130_fd_sc_hd__inv_2
XFILLER_14_85 vssd1 vssd1 vccd1 vccd1 sky130_fd_sc_hd__fill_4
XFILLER_5_213 vssd1 vssd1 vccd1 vccd1 sky130_fd_sc_hd__fill_2
XTAP_TAPCELL_ROW_1_88 vssd1 vccd1 sky130_fd_sc_hd__tapvpwrvgnd_1
X_0972_ _0977_/CLK _0972_/D _0919_/SET_B vssd1 vssd1 vccd1 vccd1 _0972_/Q sky130_fd_sc_hd__dfrtp_2
XFILLER_2_205 vssd1 vssd1 vccd1 vccd1 sky130_fd_sc_hd__fill_4
XFILLER_18_139 vssd1 vssd1 vccd1 vccd1 sky130_fd_sc_hd__fill_1
XFILLER_25_40 vssd1 vssd1 vccd1 vccd1 sky130_fd_sc_hd__fill_2
XFILLER_2_11 vssd1 vssd1 vccd1 vccd1 sky130_fd_sc_hd__fill_1
XFILLER_17_183 vssd1 vssd1 vccd1 vccd1 sky130_fd_sc_hd__fill_4
X_0886_ clkload7/A _0886_/D fanout45/X vssd1 vssd1 vccd1 vccd1 _0886_/Q sky130_fd_sc_hd__dfstp_2
X_0955_ clkload1/A _0955_/D _0913_/SET_B vssd1 vssd1 vccd1 vccd1 _0955_/Q sky130_fd_sc_hd__dfrtp_2
XFILLER_23_197 vssd1 vssd1 vccd1 vccd1 sky130_fd_sc_hd__fill_1
XFILLER_14_120 vssd1 vssd1 vccd1 vccd1 sky130_fd_sc_hd__fill_2
XFILLER_36_83 vssd1 vssd1 vccd1 vccd1 sky130_fd_sc_hd__fill_1
XFILLER_14_197 vssd1 vssd1 vccd1 vccd1 sky130_fd_sc_hd__fill_4
Xinput14 gpio_in[6] vssd1 vssd1 vccd1 vccd1 _0421_/A sky130_fd_sc_hd__clkdlybuf4s25_1
X_0740_ _0742_/B _0740_/B vssd1 vssd1 vccd1 vccd1 _0740_/Y sky130_fd_sc_hd__nor2_2
XTAP_TAPCELL_ROW_24_192 vssd1 vccd1 sky130_fd_sc_hd__tapvpwrvgnd_1
X_0671_ _0898_/Q _0890_/Q vssd1 vssd1 vccd1 vccd1 _0693_/A sky130_fd_sc_hd__xor2_2
X_0869_ _0903_/CLK _0869_/D _0882_/SET_B vssd1 vssd1 vccd1 vccd1 _0869_/Q sky130_fd_sc_hd__dfstp_2
X_0938_ _0938_/CLK _0938_/D fanout48/A vssd1 vssd1 vccd1 vccd1 _0938_/Q sky130_fd_sc_hd__dfrtp_2
XTAP_TAPCELL_ROW_7_116 vssd1 vccd1 sky130_fd_sc_hd__tapvpwrvgnd_1
XANTENNA_fanout35_A fanout40/X vssd1 vssd1 vccd1 vccd1 sky130_fd_sc_hd__diode_2
XFILLER_22_85 vssd1 vccd1 vssd1 vccd1 sky130_ef_sc_hd__decap_40_12
XFILLER_19_245 vssd1 vssd1 vccd1 vccd1 sky130_fd_sc_hd__fill_8
XFILLER_19_223 vssd1 vssd1 vccd1 vccd1 sky130_fd_sc_hd__fill_1
X_0723_ _0871_/Q _0905_/Q _0951_/Q vssd1 vssd1 vccd1 vccd1 _0871_/D sky130_fd_sc_hd__mux2_1
XTAP_TAPCELL_ROW_12_140 vssd1 vccd1 sky130_fd_sc_hd__tapvpwrvgnd_1
X_0654_ input6/X _0654_/B vssd1 vssd1 vccd1 vccd1 _0665_/B sky130_fd_sc_hd__or2_2
X_0585_ _0585_/A vssd1 vssd1 vccd1 vccd1 _0992_/D sky130_fd_sc_hd__inv_2
XANTENNA_clkbuf_4_7_0_clk_A clkbuf_0_clk/X vssd1 vssd1 vccd1 vccd1 sky130_fd_sc_hd__diode_2
X_1068_ _1068_/A vssd1 vssd1 vccd1 vccd1 _1068_/X sky130_fd_sc_hd__buf_2
XTAP_TAPCELL_ROW_35_243 vssd1 vccd1 sky130_fd_sc_hd__tapvpwrvgnd_1
Xteam_07_93 vssd1 vssd1 vccd1 vccd1 gpio_oeb[4] team_07_93/LO sky130_fd_sc_hd__conb_1
Xteam_07_82 vssd1 vssd1 vccd1 vccd1 team_07_82/HI gpio_out[27] sky130_fd_sc_hd__conb_1
Xteam_07_71 vssd1 vssd1 vccd1 vccd1 team_07_71/HI gpio_out[14] sky130_fd_sc_hd__conb_1
Xteam_07_60 vssd1 vssd1 vccd1 vccd1 team_07_60/HI gpio_out[3] sky130_fd_sc_hd__conb_1
XFILLER_3_141 vssd1 vssd1 vccd1 vccd1 sky130_fd_sc_hd__fill_4
Xclkbuf_4_4_0_clk clkbuf_0_clk/X vssd1 vssd1 vccd1 vccd1 clkload3/A sky130_fd_sc_hd__clkbuf_8
X_0706_ _0924_/Q _0922_/Q _0937_/Q _0935_/Q vssd1 vssd1 vccd1 vccd1 _0707_/D sky130_fd_sc_hd__or4_2
X_0637_ _0637_/A _0971_/D vssd1 vssd1 vccd1 vccd1 _0637_/Y sky130_fd_sc_hd__xnor2_2
X_0568_ _0590_/A _0575_/D _0568_/C vssd1 vssd1 vccd1 vccd1 _0986_/D sky130_fd_sc_hd__nor3_2
X_0499_ _0509_/D _0499_/B vssd1 vssd1 vccd1 vccd1 _0499_/X sky130_fd_sc_hd__and2b_2
XFILLER_38_29 vssd1 vccd1 vssd1 vccd1 sky130_ef_sc_hd__decap_40_12
XFILLER_38_18 vssd1 vssd1 vccd1 vccd1 sky130_fd_sc_hd__fill_8
XANTENNA_input15_A gpio_in[7] vssd1 vssd1 vccd1 vccd1 sky130_fd_sc_hd__diode_2
XFILLER_28_95 vssd1 vssd1 vccd1 vccd1 sky130_fd_sc_hd__fill_2
XFILLER_28_73 vssd1 vssd1 vccd1 vccd1 sky130_fd_sc_hd__fill_1
X_0422_ _0422_/A vssd1 vssd1 vccd1 vccd1 _0638_/A sky130_fd_sc_hd__inv_2
XFILLER_5_77 vssd1 vssd1 vccd1 vccd1 sky130_fd_sc_hd__fill_1
XANTENNA_input7_A gpio_in[14] vssd1 vssd1 vccd1 vccd1 sky130_fd_sc_hd__diode_2
XFILLER_5_225 vssd1 vssd1 vccd1 vccd1 sky130_fd_sc_hd__fill_4
XANTENNA_clkbuf_4_15_0_clk_A clkbuf_0_clk/X vssd1 vssd1 vccd1 vccd1 sky130_fd_sc_hd__diode_2
XTAP_TAPCELL_ROW_1_89 vssd1 vccd1 sky130_fd_sc_hd__tapvpwrvgnd_1
XFILLER_30_85 vssd1 vccd1 vssd1 vccd1 sky130_ef_sc_hd__decap_40_12
X_0971_ _0990_/CLK _0971_/D _0919_/SET_B vssd1 vssd1 vccd1 vccd1 _0971_/Q sky130_fd_sc_hd__dfrtp_2
XFILLER_17_173 vssd1 vssd1 vccd1 vccd1 sky130_fd_sc_hd__fill_2
XFILLER_17_195 vssd1 vssd1 vccd1 vccd1 sky130_fd_sc_hd__fill_2
XTAP_TAPCELL_ROW_19_168 vssd1 vccd1 sky130_fd_sc_hd__tapvpwrvgnd_1
X_0885_ clkload9/A _0885_/D _0895_/SET_B vssd1 vssd1 vccd1 vccd1 _0885_/Q sky130_fd_sc_hd__dfstp_2
X_0954_ clkload5/A _0954_/D fanout33/X vssd1 vssd1 vccd1 vccd1 _0954_/Q sky130_fd_sc_hd__dfrtp_2
XFILLER_14_143 vssd1 vssd1 vccd1 vccd1 sky130_fd_sc_hd__fill_1
Xinput15 gpio_in[7] vssd1 vssd1 vccd1 vccd1 _0422_/A sky130_fd_sc_hd__clkdlybuf4s25_1
X_0670_ _0670_/A _0670_/B _0670_/C vssd1 vssd1 vccd1 vccd1 _0998_/D sky130_fd_sc_hd__and3_2
XTAP_TAPCELL_ROW_24_193 vssd1 vccd1 sky130_fd_sc_hd__tapvpwrvgnd_1
XANTENNA_clkbuf_4_3_0_clk_A clkbuf_0_clk/X vssd1 vssd1 vccd1 vccd1 sky130_fd_sc_hd__diode_2
X_0868_ _0903_/CLK _0868_/D _0911_/SET_B vssd1 vssd1 vccd1 vccd1 _0868_/Q sky130_fd_sc_hd__dfstp_2
X_0937_ _0938_/CLK _0937_/D fanout48/A vssd1 vssd1 vccd1 vccd1 _0937_/Q sky130_fd_sc_hd__dfrtp_2
X_0799_ _0880_/Q _0876_/Q _0881_/Q _0875_/Q vssd1 vssd1 vccd1 vccd1 _0800_/C sky130_fd_sc_hd__a22oi_2
XTAP_TAPCELL_ROW_7_117 vssd1 vccd1 sky130_fd_sc_hd__tapvpwrvgnd_1
XFILLER_8_33 vssd1 vssd1 vccd1 vccd1 sky130_fd_sc_hd__fill_1
X_0722_ _0870_/Q _0904_/Q _0951_/Q vssd1 vssd1 vccd1 vccd1 _0870_/D sky130_fd_sc_hd__mux2_1
X_0653_ _0653_/A _0997_/D vssd1 vssd1 vccd1 vccd1 _0665_/A sky130_fd_sc_hd__nand2_2
XFILLER_6_194 vssd1 vssd1 vccd1 vccd1 sky130_fd_sc_hd__fill_2
X_0584_ _0590_/A _0584_/B _0593_/D vssd1 vssd1 vccd1 vccd1 _0585_/A sky130_fd_sc_hd__or3_2
Xteam_07_94 vssd1 vssd1 vccd1 vccd1 gpio_oeb[5] team_07_94/LO sky130_fd_sc_hd__conb_1
Xteam_07_83 vssd1 vssd1 vccd1 vccd1 team_07_83/HI gpio_out[28] sky130_fd_sc_hd__conb_1
Xteam_07_72 vssd1 vssd1 vccd1 vccd1 team_07_72/HI gpio_out[15] sky130_fd_sc_hd__conb_1
Xteam_07_61 vssd1 vssd1 vccd1 vccd1 team_07_61/HI gpio_out[4] sky130_fd_sc_hd__conb_1
XTAP_TAPCELL_ROW_26_200 vssd1 vccd1 sky130_fd_sc_hd__tapvpwrvgnd_1
XFILLER_33_41 vssd1 vssd1 vccd1 vccd1 sky130_fd_sc_hd__fill_2
XFILLER_3_186 vssd1 vssd1 vccd1 vccd1 sky130_fd_sc_hd__fill_2
X_0705_ _0929_/Q _0925_/Q _0934_/Q _0930_/Q vssd1 vssd1 vccd1 vccd1 _0707_/C sky130_fd_sc_hd__or4_2
X_0636_ _0658_/A _0967_/D vssd1 vssd1 vccd1 vccd1 _0636_/Y sky130_fd_sc_hd__xnor2_2
X_0567_ _0986_/Q _0567_/B vssd1 vssd1 vccd1 vccd1 _0568_/C sky130_fd_sc_hd__nor2_2
X_0498_ _0965_/Q _0966_/Q _0967_/Q _0968_/Q vssd1 vssd1 vccd1 vccd1 _0499_/B sky130_fd_sc_hd__a31o_2
XPHY_EDGE_ROW_17_Right_17 vssd1 vssd1 vccd1 vccd1 sky130_fd_sc_hd__decap_3
XFILLER_0_101 vssd1 vssd1 vccd1 vccd1 sky130_fd_sc_hd__fill_2
XFILLER_0_167 vssd1 vssd1 vccd1 vccd1 sky130_fd_sc_hd__fill_1
XPHY_EDGE_ROW_26_Right_26 vssd1 vssd1 vccd1 vccd1 sky130_fd_sc_hd__decap_3
XFILLER_28_85 vssd1 vssd1 vccd1 vccd1 sky130_fd_sc_hd__fill_2
XANTENNA_clkbuf_4_11_0_clk_A clkbuf_0_clk/X vssd1 vssd1 vccd1 vccd1 sky130_fd_sc_hd__diode_2
XPHY_EDGE_ROW_35_Right_35 vssd1 vssd1 vccd1 vccd1 sky130_fd_sc_hd__decap_3
XFILLER_8_223 vssd1 vssd1 vccd1 vccd1 sky130_fd_sc_hd__fill_2
X_0421_ _0421_/A vssd1 vssd1 vccd1 vccd1 _0657_/A sky130_fd_sc_hd__inv_2
XPHY_EDGE_ROW_17_Left_56 vssd1 vssd1 vccd1 vccd1 sky130_fd_sc_hd__decap_3
X_0619_ _0946_/Q _0952_/Q vssd1 vssd1 vccd1 vccd1 _0619_/X sky130_fd_sc_hd__or2_2
XFILLER_14_65 vssd1 vssd1 vccd1 vccd1 sky130_fd_sc_hd__fill_2
XFILLER_5_215 vssd1 vssd1 vccd1 vccd1 sky130_fd_sc_hd__fill_1
Xclkbuf_4_3_0_clk clkbuf_0_clk/X vssd1 vssd1 vccd1 vccd1 clkload2/A sky130_fd_sc_hd__clkbuf_8
X_0970_ _0990_/CLK _0970_/D _0919_/SET_B vssd1 vssd1 vccd1 vccd1 _0970_/Q sky130_fd_sc_hd__dfrtp_2
XFILLER_26_185 vssd1 vssd1 vccd1 vccd1 sky130_fd_sc_hd__fill_1
XTAP_TAPCELL_ROW_19_169 vssd1 vccd1 sky130_fd_sc_hd__tapvpwrvgnd_1
X_0884_ clkload9/A _0884_/D _0895_/SET_B vssd1 vssd1 vccd1 vccd1 _0884_/Q sky130_fd_sc_hd__dfstp_2
X_0953_ clkload5/A _0953_/D fanout33/X vssd1 vssd1 vccd1 vccd1 _0953_/Q sky130_fd_sc_hd__dfrtp_2
XFILLER_23_166 vssd1 vssd1 vccd1 vccd1 sky130_fd_sc_hd__fill_2
XFILLER_14_177 vssd1 vssd1 vccd1 vccd1 sky130_fd_sc_hd__fill_4
XFILLER_36_85 vssd1 vssd1 vccd1 vccd1 sky130_fd_sc_hd__fill_2
Xinput16 gpio_in[8] vssd1 vssd1 vccd1 vccd1 _0637_/A sky130_fd_sc_hd__clkdlybuf4s25_1
XTAP_TAPCELL_ROW_24_194 vssd1 vccd1 sky130_fd_sc_hd__tapvpwrvgnd_1
XFILLER_35_6 vssd1 vssd1 vccd1 vccd1 sky130_fd_sc_hd__fill_4
X_0936_ _0938_/CLK _0936_/D load_slew49/X vssd1 vssd1 vccd1 vccd1 _0936_/Q sky130_fd_sc_hd__dfrtp_2
XTAP_TAPCELL_ROW_15_150 vssd1 vccd1 sky130_fd_sc_hd__tapvpwrvgnd_1
X_0867_ _0903_/CLK _0867_/D _0911_/SET_B vssd1 vssd1 vccd1 vccd1 _0867_/Q sky130_fd_sc_hd__dfstp_2
X_0798_ _0875_/Q _0880_/Q _0876_/Q _0881_/Q vssd1 vssd1 vccd1 vccd1 _0800_/B sky130_fd_sc_hd__and4_2
XTAP_TAPCELL_ROW_38_253 vssd1 vccd1 sky130_fd_sc_hd__tapvpwrvgnd_1
XFILLER_11_169 vssd1 vssd1 vccd1 vccd1 sky130_fd_sc_hd__fill_1
XPHY_EDGE_ROW_5_Left_44 vssd1 vssd1 vccd1 vccd1 sky130_fd_sc_hd__decap_3
XFILLER_22_43 vssd1 vssd1 vccd1 vccd1 sky130_fd_sc_hd__fill_2
XFILLER_19_225 vssd1 vssd1 vccd1 vccd1 sky130_fd_sc_hd__fill_2
XFILLER_19_203 vssd1 vssd1 vccd1 vccd1 sky130_fd_sc_hd__fill_2
X_0721_ _0869_/Q _0903_/Q _0951_/Q vssd1 vssd1 vccd1 vccd1 _0869_/D sky130_fd_sc_hd__mux2_1
X_0652_ _0652_/A _0991_/D vssd1 vssd1 vccd1 vccd1 _0652_/Y sky130_fd_sc_hd__xnor2_2
X_0583_ _0990_/Q _0991_/Q _0992_/Q _0583_/D vssd1 vssd1 vccd1 vccd1 _0593_/D sky130_fd_sc_hd__and4_2
XFILLER_33_3 vssd1 vccd1 vssd1 vccd1 sky130_ef_sc_hd__decap_40_12
X_0919_ _0990_/CLK _0919_/D _0919_/SET_B vssd1 vssd1 vccd1 vccd1 _0919_/Q sky130_fd_sc_hd__dfstp_2
Xteam_07_84 vssd1 vssd1 vccd1 vccd1 team_07_84/HI gpio_out[29] sky130_fd_sc_hd__conb_1
Xteam_07_73 vssd1 vssd1 vccd1 vccd1 team_07_73/HI gpio_out[18] sky130_fd_sc_hd__conb_1
Xteam_07_62 vssd1 vssd1 vccd1 vccd1 team_07_62/HI gpio_out[5] sky130_fd_sc_hd__conb_1
Xteam_07_95 vssd1 vssd1 vccd1 vccd1 gpio_oeb[6] team_07_95/LO sky130_fd_sc_hd__conb_1
XTAP_TAPCELL_ROW_26_201 vssd1 vccd1 sky130_fd_sc_hd__tapvpwrvgnd_1
XANTENNA_fanout40_A _0466_/X vssd1 vssd1 vccd1 vccd1 sky130_fd_sc_hd__diode_2
XFILLER_33_75 vssd1 vssd1 vccd1 vccd1 sky130_fd_sc_hd__fill_2
XFILLER_33_53 vssd1 vssd1 vccd1 vccd1 sky130_fd_sc_hd__fill_2
XTAP_TAPCELL_ROW_32_226 vssd1 vccd1 sky130_fd_sc_hd__tapvpwrvgnd_1
XFILLER_30_253 vssd1 vssd1 vccd1 vccd1 sky130_fd_sc_hd__fill_2
X_0704_ _0920_/Q _0939_/Q _0704_/C vssd1 vssd1 vccd1 vccd1 _0707_/B sky130_fd_sc_hd__or3_2
X_0635_ _0633_/A _0973_/D _0634_/Y vssd1 vssd1 vccd1 vccd1 _0635_/X sky130_fd_sc_hd__a21o_2
X_0566_ _0942_/Q _0984_/Q _0985_/Q _0986_/Q vssd1 vssd1 vccd1 vccd1 _0575_/D sky130_fd_sc_hd__and4_2
X_0497_ _0965_/Q _0966_/Q _0967_/Q _0968_/Q vssd1 vssd1 vccd1 vccd1 _0509_/D sky130_fd_sc_hd__and4_2
XFILLER_21_253 vssd1 vssd1 vccd1 vccd1 sky130_fd_sc_hd__fill_2
XFILLER_0_113 vssd1 vssd1 vccd1 vccd1 sky130_fd_sc_hd__fill_1
XFILLER_28_97 vssd1 vssd1 vccd1 vccd1 sky130_fd_sc_hd__fill_1
XFILLER_12_253 vssd1 vssd1 vccd1 vccd1 sky130_fd_sc_hd__fill_2
XFILLER_8_246 vssd1 vssd1 vccd1 vccd1 sky130_fd_sc_hd__fill_4
X_0420_ _0467_/B vssd1 vssd1 vccd1 vccd1 _0656_/A sky130_fd_sc_hd__inv_2
X_0618_ _0956_/Q _0435_/Y hold173/X vssd1 vssd1 vccd1 vccd1 _0956_/D sky130_fd_sc_hd__a21o_2
X_0549_ _0656_/A _0987_/Q _0538_/Y _0540_/Y _0545_/Y vssd1 vssd1 vccd1 vccd1 _0558_/A
+ sky130_fd_sc_hd__o2111a_2
XFILLER_30_65 vssd1 vssd1 vccd1 vccd1 sky130_fd_sc_hd__fill_4
XPHY_EDGE_ROW_34_Left_73 vssd1 vssd1 vccd1 vccd1 sky130_fd_sc_hd__decap_3
XFILLER_29_161 vssd1 vssd1 vccd1 vccd1 sky130_fd_sc_hd__fill_4
XFILLER_27_109 vssd1 vssd1 vccd1 vccd1 sky130_fd_sc_hd__fill_2
Xteam_07_110 vssd1 vssd1 vccd1 vccd1 gpio_oeb[24] team_07_110/LO sky130_fd_sc_hd__conb_1
X_0952_ clkload1/A _0952_/D _0913_/SET_B vssd1 vssd1 vccd1 vccd1 _0952_/Q sky130_fd_sc_hd__dfrtp_2
XFILLER_32_101 vssd1 vssd1 vccd1 vccd1 sky130_fd_sc_hd__fill_1
X_0883_ clkload9/A _0883_/D fanout43/X vssd1 vssd1 vccd1 vccd1 _0883_/Q sky130_fd_sc_hd__dfstp_2
Xclkbuf_4_2_0_clk clkbuf_0_clk/X vssd1 vssd1 vccd1 vccd1 _0903_/CLK sky130_fd_sc_hd__clkbuf_8
Xinput17 gpio_in[9] vssd1 vssd1 vccd1 vccd1 _0476_/B sky130_fd_sc_hd__clkdlybuf4s25_1
X_0866_ _0918_/Q input9/X _0998_/Q vssd1 vssd1 vccd1 vccd1 _0918_/D sky130_fd_sc_hd__mux2_1
X_0935_ _0939_/CLK _0935_/D fanout48/A vssd1 vssd1 vccd1 vccd1 _0935_/Q sky130_fd_sc_hd__dfrtp_2
XTAP_TAPCELL_ROW_15_151 vssd1 vccd1 sky130_fd_sc_hd__tapvpwrvgnd_1
XPHY_EDGE_ROW_21_Left_60 vssd1 vssd1 vccd1 vccd1 sky130_fd_sc_hd__decap_3
XFILLER_20_104 vssd1 vssd1 vccd1 vccd1 sky130_fd_sc_hd__fill_2
X_0797_ _0879_/Q _0877_/Q vssd1 vssd1 vccd1 vccd1 _0800_/A sky130_fd_sc_hd__and2_2
XTAP_TAPCELL_ROW_38_254 vssd1 vccd1 sky130_fd_sc_hd__tapvpwrvgnd_1
X_0720_ _0868_/Q _0902_/Q _0951_/Q vssd1 vssd1 vccd1 vccd1 _0868_/D sky130_fd_sc_hd__mux2_1
XFILLER_10_192 vssd1 vssd1 vccd1 vccd1 sky130_fd_sc_hd__fill_4
X_0651_ _0651_/A _0651_/B vssd1 vssd1 vccd1 vccd1 _0651_/X sky130_fd_sc_hd__or2_2
X_0582_ _0992_/Q _0582_/B vssd1 vssd1 vccd1 vccd1 _0584_/B sky130_fd_sc_hd__nor2_2
XFILLER_6_141 vssd1 vssd1 vccd1 vccd1 sky130_fd_sc_hd__fill_4
XFILLER_26_3 vssd1 vccd1 vssd1 vccd1 sky130_ef_sc_hd__decap_40_12
X_0849_ _0902_/Q _0911_/Q _0854_/S vssd1 vssd1 vccd1 vccd1 _0902_/D sky130_fd_sc_hd__mux2_1
X_0918_ clkload5/A _0918_/D _1001_/SET_B vssd1 vssd1 vccd1 vccd1 _0918_/Q sky130_fd_sc_hd__dfstp_2
Xteam_07_96 vssd1 vssd1 vccd1 vccd1 gpio_oeb[7] team_07_96/LO sky130_fd_sc_hd__conb_1
Xteam_07_85 vssd1 vssd1 vccd1 vccd1 team_07_85/HI gpio_out[30] sky130_fd_sc_hd__conb_1
Xteam_07_74 vssd1 vssd1 vccd1 vccd1 team_07_74/HI gpio_out[19] sky130_fd_sc_hd__conb_1
Xteam_07_63 vssd1 vssd1 vccd1 vccd1 team_07_63/HI gpio_out[6] sky130_fd_sc_hd__conb_1
XFILLER_16_207 vssd1 vssd1 vccd1 vccd1 sky130_fd_sc_hd__fill_2
XTAP_TAPCELL_ROW_26_202 vssd1 vccd1 sky130_fd_sc_hd__tapvpwrvgnd_1
XANTENNA_fanout33_A fanout35/X vssd1 vssd1 vccd1 vccd1 sky130_fd_sc_hd__diode_2
XFILLER_33_65 vssd1 vssd1 vccd1 vccd1 sky130_fd_sc_hd__fill_2
XFILLER_33_43 vssd1 vssd1 vccd1 vccd1 sky130_fd_sc_hd__fill_1
XFILLER_3_177 vssd1 vssd1 vccd1 vccd1 sky130_fd_sc_hd__fill_2
XFILLER_3_111 vssd1 vssd1 vccd1 vccd1 sky130_fd_sc_hd__fill_1
XFILLER_3_188 vssd1 vssd1 vccd1 vccd1 sky130_fd_sc_hd__fill_1
XTAP_TAPCELL_ROW_32_227 vssd1 vccd1 sky130_fd_sc_hd__tapvpwrvgnd_1
X_0703_ _0921_/Q _0938_/Q _0702_/Y vssd1 vssd1 vccd1 vccd1 _0716_/B sky130_fd_sc_hd__o21ba_2
X_0634_ _0652_/A _0972_/D vssd1 vssd1 vccd1 vccd1 _0634_/Y sky130_fd_sc_hd__xnor2_2
X_0565_ _0590_/A _0567_/B _0565_/C vssd1 vssd1 vccd1 vccd1 _0985_/D sky130_fd_sc_hd__nor3_2
X_0496_ _0481_/X _0486_/X _0495_/Y _0458_/A vssd1 vssd1 vccd1 vccd1 _0967_/D sky130_fd_sc_hd__o211a_2
XFILLER_0_91 vssd1 vssd1 vccd1 vccd1 sky130_fd_sc_hd__fill_1
XPHY_EDGE_ROW_3_Right_3 vssd1 vssd1 vccd1 vccd1 sky130_fd_sc_hd__decap_3
XFILLER_0_169 vssd1 vccd1 vssd1 vccd1 sky130_ef_sc_hd__decap_40_12
XFILLER_28_43 vssd1 vssd1 vccd1 vccd1 sky130_fd_sc_hd__fill_1
XFILLER_28_87 vssd1 vssd1 vccd1 vccd1 sky130_fd_sc_hd__fill_1
XFILLER_8_225 vssd1 vssd1 vccd1 vccd1 sky130_fd_sc_hd__fill_1
XFILLER_10_6 vssd1 vssd1 vccd1 vccd1 sky130_fd_sc_hd__fill_1
X_0617_ hold148/X input9/X _0951_/Q vssd1 vssd1 vccd1 vccd1 _0960_/D sky130_fd_sc_hd__a21o_2
X_0548_ _0476_/B _0991_/Q vssd1 vssd1 vccd1 vccd1 _0548_/Y sky130_fd_sc_hd__nand2b_2
X_0479_ _0969_/Q _0657_/A _0976_/Q _0429_/Y _0478_/X vssd1 vssd1 vccd1 vccd1 _0481_/C
+ sky130_fd_sc_hd__a221o_2
XFILLER_30_33 vssd1 vssd1 vccd1 vccd1 sky130_fd_sc_hd__fill_2
XANTENNA__0466__X _0466_/X vssd1 vssd1 vccd1 vccd1 sky130_fd_sc_hd__diode_2
XANTENNA_input13_A gpio_in[5] vssd1 vssd1 vccd1 vccd1 sky130_fd_sc_hd__diode_2
XFILLER_29_184 vssd1 vssd1 vccd1 vccd1 sky130_fd_sc_hd__fill_2
XFILLER_35_198 vssd1 vssd1 vccd1 vccd1 sky130_fd_sc_hd__fill_1
XFILLER_2_209 vssd1 vssd1 vccd1 vccd1 sky130_fd_sc_hd__fill_2
XANTENNA_input5_A gpio_in[12] vssd1 vssd1 vccd1 vccd1 sky130_fd_sc_hd__diode_2
XFILLER_25_55 vssd1 vssd1 vccd1 vccd1 sky130_fd_sc_hd__fill_1
Xteam_07_111 vssd1 vssd1 vccd1 vccd1 gpio_oeb[25] team_07_111/LO sky130_fd_sc_hd__conb_1
Xteam_07_100 vssd1 vssd1 vccd1 vccd1 gpio_oeb[11] team_07_100/LO sky130_fd_sc_hd__conb_1
XFILLER_17_187 vssd1 vssd1 vccd1 vccd1 sky130_fd_sc_hd__fill_2
X_0882_ _0898_/CLK _0882_/D _0882_/SET_B vssd1 vssd1 vccd1 vccd1 _0882_/Q sky130_fd_sc_hd__dfstp_2
X_0951_ clkload0/A _0951_/D _0913_/SET_B vssd1 vssd1 vccd1 vccd1 _0951_/Q sky130_fd_sc_hd__dfrtp_2
XTAP_TAPCELL_ROW_2_91 vssd1 vccd1 sky130_fd_sc_hd__tapvpwrvgnd_1
XFILLER_23_113 vssd1 vssd1 vccd1 vccd1 sky130_fd_sc_hd__fill_1
Xinput18 nrst vssd1 vssd1 vccd1 vccd1 _0466_/A sky130_fd_sc_hd__clkdlybuf4s25_1
XTAP_TAPCELL_ROW_15_152 vssd1 vccd1 sky130_fd_sc_hd__tapvpwrvgnd_1
X_0865_ _0917_/Q _0918_/Q _0998_/Q vssd1 vssd1 vccd1 vccd1 _0917_/D sky130_fd_sc_hd__mux2_1
X_0934_ _0939_/CLK _0934_/D fanout48/A vssd1 vssd1 vccd1 vccd1 _0934_/Q sky130_fd_sc_hd__dfrtp_2
X_0796_ _0796_/A _0796_/B vssd1 vssd1 vccd1 vccd1 _0796_/Y sky130_fd_sc_hd__nand2_2
XTAP_TAPCELL_ROW_38_255 vssd1 vccd1 sky130_fd_sc_hd__tapvpwrvgnd_1
XFILLER_11_105 vssd1 vssd1 vccd1 vccd1 sky130_fd_sc_hd__fill_2
XTAP_TAPCELL_ROW_21_177 vssd1 vccd1 sky130_fd_sc_hd__tapvpwrvgnd_1
XFILLER_22_45 vssd1 vssd1 vccd1 vccd1 sky130_fd_sc_hd__fill_1
XFILLER_19_205 vssd1 vssd1 vccd1 vccd1 sky130_fd_sc_hd__fill_1
X_0650_ _0650_/A _0996_/D vssd1 vssd1 vccd1 vccd1 _0668_/B sky130_fd_sc_hd__nand2_2
X_0581_ _0590_/A _0581_/B _0582_/B vssd1 vssd1 vccd1 vccd1 _0991_/D sky130_fd_sc_hd__nor3_2
XFILLER_6_197 vssd1 vssd1 vccd1 vccd1 sky130_fd_sc_hd__fill_2
Xclkbuf_4_1_0_clk clkbuf_0_clk/X vssd1 vssd1 vccd1 vccd1 clkload1/A sky130_fd_sc_hd__clkbuf_8
X_0848_ _0901_/Q _0910_/Q _0854_/S vssd1 vssd1 vccd1 vccd1 _0901_/D sky130_fd_sc_hd__mux2_1
X_0917_ clkload5/A _0917_/D fanout33/X vssd1 vssd1 vccd1 vccd1 _0917_/Q sky130_fd_sc_hd__dfstp_2
X_0779_ _0781_/A _0781_/B vssd1 vssd1 vccd1 vccd1 _0779_/Y sky130_fd_sc_hd__nand2_2
Xteam_07_97 vssd1 vssd1 vccd1 vccd1 gpio_oeb[8] team_07_97/LO sky130_fd_sc_hd__conb_1
Xteam_07_86 vssd1 vssd1 vccd1 vccd1 team_07_86/HI gpio_out[31] sky130_fd_sc_hd__conb_1
Xteam_07_75 vssd1 vssd1 vccd1 vccd1 team_07_75/HI gpio_out[20] sky130_fd_sc_hd__conb_1
Xteam_07_64 vssd1 vssd1 vccd1 vccd1 team_07_64/HI gpio_out[7] sky130_fd_sc_hd__conb_1
XTAP_TAPCELL_ROW_26_203 vssd1 vccd1 sky130_fd_sc_hd__tapvpwrvgnd_1
XFILLER_33_55 vssd1 vssd1 vccd1 vccd1 sky130_fd_sc_hd__fill_1
XFILLER_3_145 vssd1 vssd1 vccd1 vccd1 sky130_fd_sc_hd__fill_2
XTAP_TAPCELL_ROW_32_228 vssd1 vccd1 sky130_fd_sc_hd__tapvpwrvgnd_1
X_0702_ _0893_/Q _0702_/B vssd1 vssd1 vccd1 vccd1 _0702_/Y sky130_fd_sc_hd__xnor2_2
X_0633_ _0633_/A _0973_/D vssd1 vssd1 vccd1 vccd1 _0633_/Y sky130_fd_sc_hd__nor2_2
X_0564_ _0564_/A _0564_/B vssd1 vssd1 vccd1 vccd1 _0565_/C sky130_fd_sc_hd__and2_2
X_0495_ _0967_/Q _0495_/B vssd1 vssd1 vccd1 vccd1 _0495_/Y sky130_fd_sc_hd__xnor2_2
XPHY_EDGE_ROW_13_Right_13 vssd1 vssd1 vccd1 vccd1 sky130_fd_sc_hd__decap_3
XPHY_EDGE_ROW_22_Right_22 vssd1 vssd1 vccd1 vccd1 sky130_fd_sc_hd__decap_3
X_0616_ _0460_/B hold168/X _0940_/Q _0461_/Y _0854_/S vssd1 vssd1 vccd1 vccd1 _0940_/D
+ sky130_fd_sc_hd__a221o_2
X_0547_ _0984_/Q _0547_/B vssd1 vssd1 vccd1 vccd1 _0547_/Y sky130_fd_sc_hd__nand2b_2
X_0478_ _0975_/Q _0651_/A vssd1 vssd1 vccd1 vccd1 _0478_/X sky130_fd_sc_hd__xor2_2
XPHY_EDGE_ROW_31_Right_31 vssd1 vssd1 vccd1 vccd1 sky130_fd_sc_hd__decap_3
XFILLER_5_229 vssd1 vssd1 vccd1 vccd1 sky130_fd_sc_hd__fill_2
XFILLER_30_12 vssd1 vssd1 vccd1 vccd1 sky130_fd_sc_hd__fill_1
XFILLER_29_152 vssd1 vssd1 vccd1 vccd1 sky130_fd_sc_hd__fill_2
XFILLER_35_155 vssd1 vssd1 vccd1 vccd1 sky130_fd_sc_hd__fill_2
XANTENNA_clkbuf_0_clk_X clkbuf_0_clk/X vssd1 vssd1 vccd1 vccd1 sky130_fd_sc_hd__diode_2
Xteam_07_112 vssd1 vssd1 vccd1 vccd1 gpio_oeb[26] team_07_112/LO sky130_fd_sc_hd__conb_1
Xteam_07_101 vssd1 vssd1 vccd1 vccd1 gpio_oeb[12] team_07_101/LO sky130_fd_sc_hd__conb_1
XFILLER_2_27 vssd1 vssd1 vccd1 vccd1 sky130_fd_sc_hd__fill_1
XFILLER_17_155 vssd1 vssd1 vccd1 vccd1 sky130_fd_sc_hd__fill_1
X_0881_ _0898_/CLK _0881_/D _0882_/SET_B vssd1 vssd1 vccd1 vccd1 _0881_/Q sky130_fd_sc_hd__dfstp_2
X_0950_ clkload6/A _0950_/D fanout33/X vssd1 vssd1 vccd1 vccd1 _0950_/Q sky130_fd_sc_hd__dfrtp_2
XTAP_TAPCELL_ROW_2_92 vssd1 vccd1 sky130_fd_sc_hd__tapvpwrvgnd_1
XFILLER_23_169 vssd1 vssd1 vccd1 vccd1 sky130_fd_sc_hd__fill_2
XFILLER_23_158 vssd1 vssd1 vccd1 vccd1 sky130_fd_sc_hd__fill_8
XFILLER_36_55 vssd1 vssd1 vccd1 vccd1 sky130_fd_sc_hd__fill_2
XFILLER_14_158 vssd1 vssd1 vccd1 vccd1 sky130_fd_sc_hd__fill_2
XTAP_TAPCELL_ROW_15_153 vssd1 vccd1 sky130_fd_sc_hd__tapvpwrvgnd_1
XFILLER_20_117 vssd1 vssd1 vccd1 vccd1 sky130_fd_sc_hd__fill_1
XANTENNA__0963__CLK clkload7/A vssd1 vssd1 vccd1 vccd1 sky130_fd_sc_hd__diode_2
X_0864_ _0916_/Q _0917_/Q _0998_/Q vssd1 vssd1 vccd1 vccd1 _0916_/D sky130_fd_sc_hd__mux2_1
X_0933_ _0939_/CLK _0933_/D fanout52/X vssd1 vssd1 vccd1 vccd1 _0933_/Q sky130_fd_sc_hd__dfrtp_2
X_0795_ _0892_/Q _0796_/B _0791_/X _0794_/Y vssd1 vssd1 vccd1 vccd1 _0892_/D sky130_fd_sc_hd__a22o_2
XTAP_TAPCELL_ROW_38_256 vssd1 vccd1 sky130_fd_sc_hd__tapvpwrvgnd_1
XTAP_TAPCELL_ROW_21_178 vssd1 vccd1 sky130_fd_sc_hd__tapvpwrvgnd_1
XTAP_TAPCELL_ROW_6_110 vssd1 vccd1 sky130_fd_sc_hd__tapvpwrvgnd_1
X_0580_ _0990_/Q _0991_/Q _0583_/D vssd1 vssd1 vccd1 vccd1 _0582_/B sky130_fd_sc_hd__and3_2
X_0916_ clkload5/A _0916_/D fanout33/X vssd1 vssd1 vccd1 vccd1 _0916_/Q sky130_fd_sc_hd__dfstp_2
XFILLER_33_253 vssd1 vssd1 vccd1 vccd1 sky130_fd_sc_hd__fill_2
X_0847_ _0417_/Y _1068_/A _0854_/S vssd1 vssd1 vccd1 vccd1 _0900_/D sky130_fd_sc_hd__o21bai_2
X_0778_ _0778_/A _0778_/B vssd1 vssd1 vccd1 vccd1 _0783_/A sky130_fd_sc_hd__nand2_2
Xteam_07_98 vssd1 vssd1 vccd1 vccd1 gpio_oeb[9] team_07_98/LO sky130_fd_sc_hd__conb_1
Xteam_07_87 vssd1 vssd1 vccd1 vccd1 team_07_87/HI gpio_out[32] sky130_fd_sc_hd__conb_1
Xteam_07_76 vssd1 vssd1 vccd1 vccd1 team_07_76/HI gpio_out[21] sky130_fd_sc_hd__conb_1
Xteam_07_65 vssd1 vssd1 vccd1 vccd1 team_07_65/HI gpio_out[8] sky130_fd_sc_hd__conb_1
XPHY_EDGE_ROW_9_Left_48 vssd1 vssd1 vccd1 vccd1 sky130_fd_sc_hd__decap_3
XFILLER_24_253 vssd1 vssd1 vccd1 vccd1 sky130_fd_sc_hd__fill_2
XFILLER_3_113 vssd1 vssd1 vccd1 vccd1 sky130_fd_sc_hd__fill_4
XFILLER_15_253 vssd1 vssd1 vccd1 vccd1 sky130_fd_sc_hd__fill_2
XTAP_TAPCELL_ROW_32_229 vssd1 vccd1 sky130_fd_sc_hd__tapvpwrvgnd_1
X_0701_ _0683_/X _0714_/C vssd1 vssd1 vccd1 vccd1 _0702_/B sky130_fd_sc_hd__and2b_2
X_0632_ input6/X _0527_/A _0631_/Y vssd1 vssd1 vccd1 vccd1 _0632_/Y sky130_fd_sc_hd__a21oi_2
X_0563_ _0564_/A _0564_/B vssd1 vssd1 vccd1 vccd1 _0567_/B sky130_fd_sc_hd__nor2_2
X_0494_ _0526_/A _0494_/B vssd1 vssd1 vccd1 vccd1 _0966_/D sky130_fd_sc_hd__nor2_2
XFILLER_21_223 vssd1 vssd1 vccd1 vccd1 sky130_fd_sc_hd__fill_1
Xclkbuf_4_0_0_clk clkbuf_0_clk/X vssd1 vssd1 vccd1 vccd1 clkload0/A sky130_fd_sc_hd__clkbuf_8
X_0615_ _0414_/Y _0942_/Q hold143/X vssd1 vssd1 vccd1 vccd1 _0615_/X sky130_fd_sc_hd__a21o_2
X_0546_ input8/X _0997_/Q vssd1 vssd1 vccd1 vccd1 _0546_/Y sky130_fd_sc_hd__nand2b_2
X_0477_ _0973_/Q _0633_/A _0427_/Y input4/X _0469_/X vssd1 vssd1 vccd1 vccd1 _0481_/B
+ sky130_fd_sc_hd__a221o_2
XFILLER_38_197 vssd1 vssd1 vccd1 vccd1 sky130_fd_sc_hd__fill_2
XFILLER_30_35 vssd1 vssd1 vccd1 vccd1 sky130_fd_sc_hd__fill_1
XFILLER_30_24 vssd1 vssd1 vccd1 vccd1 sky130_fd_sc_hd__fill_4
X_0529_ _0977_/Q _0528_/B _0523_/A vssd1 vssd1 vccd1 vccd1 _0530_/B sky130_fd_sc_hd__o21ai_2
XFILLER_6_81 vssd1 vssd1 vccd1 vccd1 sky130_fd_sc_hd__fill_2
XFILLER_25_24 vssd1 vssd1 vccd1 vccd1 sky130_fd_sc_hd__fill_2
XPHY_EDGE_ROW_38_Left_77 vssd1 vssd1 vccd1 vccd1 sky130_fd_sc_hd__decap_3
XFILLER_25_57 vssd1 vssd1 vccd1 vccd1 sky130_fd_sc_hd__fill_4
Xteam_07_113 vssd1 vssd1 vccd1 vccd1 gpio_oeb[27] team_07_113/LO sky130_fd_sc_hd__conb_1
Xteam_07_102 vssd1 vssd1 vccd1 vccd1 gpio_oeb[13] team_07_102/LO sky130_fd_sc_hd__conb_1
XFILLER_1_211 vssd1 vssd1 vccd1 vccd1 sky130_fd_sc_hd__fill_2
XFILLER_17_189 vssd1 vssd1 vccd1 vccd1 sky130_fd_sc_hd__fill_1
XFILLER_32_159 vssd1 vssd1 vccd1 vccd1 sky130_fd_sc_hd__fill_1
XFILLER_32_115 vssd1 vssd1 vccd1 vccd1 sky130_fd_sc_hd__fill_4
X_0880_ _0898_/CLK _0880_/D _0882_/SET_B vssd1 vssd1 vccd1 vccd1 _0880_/Q sky130_fd_sc_hd__dfstp_2
XTAP_TAPCELL_ROW_2_93 vssd1 vccd1 sky130_fd_sc_hd__tapvpwrvgnd_1
XFILLER_11_59 vssd1 vssd1 vccd1 vccd1 sky130_fd_sc_hd__fill_4
XFILLER_22_170 vssd1 vccd1 vssd1 vccd1 sky130_ef_sc_hd__decap_40_12
X_0932_ _0938_/CLK _0932_/D fanout52/X vssd1 vssd1 vccd1 vccd1 _0932_/Q sky130_fd_sc_hd__dfrtp_2
X_0863_ _0915_/Q _0916_/Q _0863_/S vssd1 vssd1 vccd1 vccd1 _0915_/D sky130_fd_sc_hd__mux2_1
X_0794_ _0796_/B _0794_/B vssd1 vssd1 vccd1 vccd1 _0794_/Y sky130_fd_sc_hd__nor2_2
XTAP_TAPCELL_ROW_38_257 vssd1 vccd1 sky130_fd_sc_hd__tapvpwrvgnd_1
XTAP_TAPCELL_ROW_21_179 vssd1 vccd1 sky130_fd_sc_hd__tapvpwrvgnd_1
XTAP_TAPCELL_ROW_6_111 vssd1 vccd1 sky130_fd_sc_hd__tapvpwrvgnd_1
XTAP_TAPCELL_ROW_29_213 vssd1 vccd1 sky130_fd_sc_hd__tapvpwrvgnd_1
XFILLER_27_251 vssd1 vssd1 vccd1 vccd1 sky130_fd_sc_hd__fill_1
XFILLER_8_27 vssd1 vssd1 vccd1 vccd1 sky130_fd_sc_hd__fill_1
XFILLER_6_199 vssd1 vssd1 vccd1 vccd1 sky130_fd_sc_hd__fill_1
XPHY_EDGE_ROW_25_Left_64 vssd1 vssd1 vccd1 vccd1 sky130_fd_sc_hd__decap_3
XFILLER_18_251 vssd1 vssd1 vccd1 vccd1 sky130_fd_sc_hd__fill_1
X_0915_ clkload1/A _0915_/D fanout30/X vssd1 vssd1 vccd1 vccd1 _0915_/Q sky130_fd_sc_hd__dfstp_2
X_0846_ _1068_/A _0846_/B vssd1 vssd1 vccd1 vccd1 _0899_/D sky130_fd_sc_hd__nor2_2
Xteam_07_66 vssd1 vssd1 vccd1 vccd1 team_07_66/HI gpio_out[9] sky130_fd_sc_hd__conb_1
Xteam_07_55 vssd1 vssd1 vccd1 vccd1 team_07_55/HI gpio_oeb[17] sky130_fd_sc_hd__conb_1
X_0777_ _0869_/Q _0874_/Q _0870_/Q _0873_/Q vssd1 vssd1 vccd1 vccd1 _0778_/B sky130_fd_sc_hd__a22o_2
Xteam_07_99 vssd1 vssd1 vccd1 vccd1 gpio_oeb[10] team_07_99/LO sky130_fd_sc_hd__conb_1
Xteam_07_88 vssd1 vssd1 vccd1 vccd1 team_07_88/HI gpio_out[33] sky130_fd_sc_hd__conb_1
Xteam_07_77 vssd1 vssd1 vccd1 vccd1 team_07_77/HI gpio_out[22] sky130_fd_sc_hd__conb_1
XFILLER_33_57 vssd1 vssd1 vccd1 vccd1 sky130_fd_sc_hd__fill_8
XFILLER_3_169 vssd1 vssd1 vccd1 vccd1 sky130_fd_sc_hd__fill_8
XFILLER_15_221 vssd1 vssd1 vccd1 vccd1 sky130_fd_sc_hd__fill_2
X_0700_ _0700_/A _0700_/B vssd1 vssd1 vccd1 vccd1 _0716_/A sky130_fd_sc_hd__nor2_2
X_0631_ input6/X _0527_/A _0630_/Y vssd1 vssd1 vccd1 vccd1 _0631_/Y sky130_fd_sc_hd__o21ai_2
X_0562_ _0942_/Q _0555_/X _0558_/X _0983_/Q vssd1 vssd1 vccd1 vccd1 _0594_/A sky130_fd_sc_hd__a31o_2
X_0493_ _0493_/A _0495_/B vssd1 vssd1 vccd1 vccd1 _0494_/B sky130_fd_sc_hd__nand2_2
XFILLER_24_3 vssd1 vssd1 vccd1 vccd1 sky130_fd_sc_hd__fill_8
X_0829_ _0823_/B _0831_/C _0831_/B vssd1 vssd1 vccd1 vccd1 _0829_/X sky130_fd_sc_hd__a21o_2
XFILLER_28_57 vssd1 vccd1 vssd1 vccd1 sky130_ef_sc_hd__decap_40_12
XFILLER_12_246 vssd1 vssd1 vccd1 vccd1 sky130_fd_sc_hd__fill_4
X_0614_ _0454_/A hold163/X _0456_/Y _0919_/Q vssd1 vssd1 vccd1 vccd1 _0614_/X sky130_fd_sc_hd__a22o_2
X_0545_ _0547_/B _0984_/Q vssd1 vssd1 vccd1 vccd1 _0545_/Y sky130_fd_sc_hd__nand2b_2
X_0476_ _0972_/Q _0476_/B vssd1 vssd1 vccd1 vccd1 _0476_/Y sky130_fd_sc_hd__xnor2_2
XPHY_EDGE_ROW_7_Right_7 vssd1 vssd1 vccd1 vccd1 sky130_fd_sc_hd__decap_3
XPHY_EDGE_ROW_12_Left_51 vssd1 vssd1 vccd1 vccd1 sky130_fd_sc_hd__decap_3
XFILLER_5_209 vssd1 vssd1 vccd1 vccd1 sky130_fd_sc_hd__fill_4
XFILLER_30_69 vssd1 vssd1 vccd1 vccd1 sky130_fd_sc_hd__fill_1
XFILLER_29_143 vssd1 vssd1 vccd1 vccd1 sky130_fd_sc_hd__fill_2
XFILLER_29_165 vssd1 vssd1 vccd1 vccd1 sky130_fd_sc_hd__fill_2
XFILLER_4_253 vssd1 vssd1 vccd1 vccd1 sky130_fd_sc_hd__fill_2
XFILLER_4_220 vssd1 vssd1 vccd1 vccd1 sky130_fd_sc_hd__fill_1
X_0528_ _0977_/Q _0528_/B vssd1 vssd1 vccd1 vccd1 _0530_/A sky130_fd_sc_hd__and2_2
X_0459_ _0983_/Q _0942_/Q vssd1 vssd1 vccd1 vccd1 _0945_/D sky130_fd_sc_hd__and2_2
XFILLER_26_146 vssd1 vssd1 vccd1 vccd1 sky130_fd_sc_hd__fill_1
Xteam_07_114 vssd1 vssd1 vccd1 vccd1 gpio_oeb[28] team_07_114/LO sky130_fd_sc_hd__conb_1
Xteam_07_103 vssd1 vssd1 vccd1 vccd1 gpio_oeb[14] team_07_103/LO sky130_fd_sc_hd__conb_1
XFILLER_1_234 vssd1 vccd1 vssd1 vccd1 sky130_ef_sc_hd__decap_40_12
XANTENNA_input11_A gpio_in[3] vssd1 vssd1 vccd1 vccd1 sky130_fd_sc_hd__diode_2
XTAP_TAPCELL_ROW_2_94 vssd1 vccd1 sky130_fd_sc_hd__tapvpwrvgnd_1
XTAP_TAPCELL_ROW_18_163 vssd1 vccd1 sky130_fd_sc_hd__tapvpwrvgnd_1
XANTENNA_input3_A gpio_in[10] vssd1 vssd1 vccd1 vccd1 sky130_fd_sc_hd__diode_2
XFILLER_36_57 vssd1 vssd1 vccd1 vccd1 sky130_fd_sc_hd__fill_1
XFILLER_22_182 vssd1 vccd1 vssd1 vccd1 sky130_ef_sc_hd__decap_40_12
X_0862_ _0914_/Q _0915_/Q _0863_/S vssd1 vssd1 vccd1 vccd1 _0914_/D sky130_fd_sc_hd__mux2_1
X_0931_ _0977_/CLK _0931_/D load_slew49/X vssd1 vssd1 vccd1 vccd1 _0931_/Q sky130_fd_sc_hd__dfrtp_2
XFILLER_20_108 vssd1 vssd1 vccd1 vccd1 sky130_fd_sc_hd__fill_1
X_0793_ _0794_/B vssd1 vssd1 vccd1 vccd1 _0802_/A sky130_fd_sc_hd__inv_2
XTAP_TAPCELL_ROW_38_258 vssd1 vccd1 sky130_fd_sc_hd__tapvpwrvgnd_1
XFILLER_22_26 vssd1 vssd1 vccd1 vccd1 sky130_fd_sc_hd__fill_2
XTAP_TAPCELL_ROW_6_112 vssd1 vccd1 sky130_fd_sc_hd__tapvpwrvgnd_1
XTAP_TAPCELL_ROW_29_214 vssd1 vccd1 sky130_fd_sc_hd__tapvpwrvgnd_1
XFILLER_19_219 vssd1 vssd1 vccd1 vccd1 sky130_fd_sc_hd__fill_4
XTAP_TAPCELL_ROW_12_136 vssd1 vccd1 sky130_fd_sc_hd__tapvpwrvgnd_1
XFILLER_6_145 vssd1 vssd1 vccd1 vccd1 sky130_fd_sc_hd__fill_2
XANTENNA__0996__RESET_B fanout40/X vssd1 vssd1 vccd1 vccd1 sky130_fd_sc_hd__diode_2
XFILLER_18_241 vssd1 vssd1 vccd1 vccd1 sky130_fd_sc_hd__fill_8
X_0845_ _0900_/Q _0854_/S hold161/X vssd1 vssd1 vccd1 vccd1 _0845_/Y sky130_fd_sc_hd__a21oi_2
X_0914_ clkload0/A _0914_/D fanout30/X vssd1 vssd1 vccd1 vccd1 _0914_/Q sky130_fd_sc_hd__dfstp_2
Xteam_07_89 vssd1 vssd1 vccd1 vccd1 gpio_oeb[0] team_07_89/LO sky130_fd_sc_hd__conb_1
Xteam_07_78 vssd1 vssd1 vccd1 vccd1 team_07_78/HI gpio_out[23] sky130_fd_sc_hd__conb_1
Xteam_07_67 vssd1 vssd1 vccd1 vccd1 team_07_67/HI gpio_out[10] sky130_fd_sc_hd__conb_1
Xteam_07_56 vssd1 vssd1 vccd1 vccd1 team_07_56/HI gpio_oeb[18] sky130_fd_sc_hd__conb_1
X_0776_ _0873_/Q _0869_/Q _0776_/C vssd1 vssd1 vccd1 vccd1 _0778_/A sky130_fd_sc_hd__nand3_2
XFILLER_24_211 vssd1 vssd1 vccd1 vccd1 sky130_fd_sc_hd__fill_1
XFILLER_24_233 vssd1 vssd1 vccd1 vccd1 sky130_fd_sc_hd__fill_1
X_0630_ input5/X _0975_/D vssd1 vssd1 vccd1 vccd1 _0630_/Y sky130_fd_sc_hd__xnor2_2
X_0561_ _0942_/Q _0984_/Q _0560_/X _0414_/Y vssd1 vssd1 vccd1 vccd1 _0984_/D sky130_fd_sc_hd__o211a_2
X_0492_ _0965_/Q _0966_/Q vssd1 vssd1 vccd1 vccd1 _0495_/B sky130_fd_sc_hd__nand2_2
XFILLER_21_225 vssd1 vssd1 vccd1 vccd1 sky130_fd_sc_hd__fill_2
X_0828_ _0896_/Q _0961_/Q vssd1 vssd1 vccd1 vccd1 _0828_/X sky130_fd_sc_hd__or2_2
X_0759_ _0871_/Q _0870_/Q _0758_/C vssd1 vssd1 vccd1 vccd1 _0759_/Y sky130_fd_sc_hd__a21oi_2
XFILLER_28_69 vssd1 vssd1 vccd1 vccd1 sky130_fd_sc_hd__fill_4
XFILLER_8_229 vssd1 vssd1 vccd1 vccd1 sky130_fd_sc_hd__fill_2
X_0613_ _0416_/Y _0920_/Q hold150/X vssd1 vssd1 vccd1 vccd1 _0613_/X sky130_fd_sc_hd__a21o_2
X_0544_ input6/X _0995_/Q vssd1 vssd1 vccd1 vccd1 _0544_/Y sky130_fd_sc_hd__nand2b_2
X_0475_ _0419_/A _0966_/Q vssd1 vssd1 vccd1 vccd1 _0475_/X sky130_fd_sc_hd__and2b_2
XFILLER_29_122 vssd1 vssd1 vccd1 vccd1 sky130_fd_sc_hd__fill_2
XFILLER_29_111 vssd1 vssd1 vccd1 vccd1 sky130_fd_sc_hd__fill_1
XFILLER_4_210 vssd1 vssd1 vccd1 vccd1 sky130_fd_sc_hd__fill_8
XFILLER_35_125 vssd1 vssd1 vccd1 vccd1 sky130_fd_sc_hd__fill_1
XFILLER_6_83 vssd1 vssd1 vccd1 vccd1 sky130_fd_sc_hd__fill_1
X_0527_ _0527_/A vssd1 vssd1 vccd1 vccd1 _0976_/D sky130_fd_sc_hd__inv_2
X_0458_ _0458_/A vssd1 vssd1 vccd1 vccd1 _0930_/D sky130_fd_sc_hd__inv_2
XFILLER_26_158 vssd1 vssd1 vccd1 vccd1 sky130_fd_sc_hd__fill_2
Xteam_07_115 vssd1 vssd1 vccd1 vccd1 gpio_oeb[29] team_07_115/LO sky130_fd_sc_hd__conb_1
Xteam_07_104 vssd1 vssd1 vccd1 vccd1 gpio_oeb[15] team_07_104/LO sky130_fd_sc_hd__conb_1
XFILLER_1_213 vssd1 vssd1 vccd1 vccd1 sky130_fd_sc_hd__fill_1
XFILLER_17_169 vssd1 vssd1 vccd1 vccd1 sky130_fd_sc_hd__fill_4
XTAP_TAPCELL_ROW_2_95 vssd1 vccd1 sky130_fd_sc_hd__tapvpwrvgnd_1
XTAP_TAPCELL_ROW_18_164 vssd1 vccd1 sky130_fd_sc_hd__tapvpwrvgnd_1
XFILLER_22_194 vssd1 vssd1 vccd1 vccd1 sky130_fd_sc_hd__fill_2
X_0861_ _0913_/Q _0914_/Q _0863_/S vssd1 vssd1 vccd1 vccd1 _0913_/D sky130_fd_sc_hd__mux2_1
X_0930_ _0990_/CLK _0930_/D fanout50/X vssd1 vssd1 vccd1 vccd1 _0930_/Q sky130_fd_sc_hd__dfrtp_2
X_0792_ _0875_/Q _0880_/Q _0876_/Q _0879_/Q vssd1 vssd1 vccd1 vccd1 _0794_/B sky130_fd_sc_hd__and4_2
XFILLER_9_110 vssd1 vssd1 vccd1 vccd1 sky130_fd_sc_hd__fill_2
XTAP_TAPCELL_ROW_38_259 vssd1 vccd1 sky130_fd_sc_hd__tapvpwrvgnd_1
XFILLER_36_253 vssd1 vssd1 vccd1 vccd1 sky130_fd_sc_hd__fill_2
XTAP_TAPCELL_ROW_6_113 vssd1 vccd1 sky130_fd_sc_hd__tapvpwrvgnd_1
XTAP_TAPCELL_ROW_29_215 vssd1 vccd1 sky130_fd_sc_hd__tapvpwrvgnd_1
XPHY_EDGE_ROW_29_Right_29 vssd1 vssd1 vccd1 vccd1 sky130_fd_sc_hd__decap_3
XTAP_TAPCELL_ROW_12_137 vssd1 vccd1 sky130_fd_sc_hd__tapvpwrvgnd_1
XPHY_EDGE_ROW_38_Right_38 vssd1 vssd1 vccd1 vccd1 sky130_fd_sc_hd__decap_3
XFILLER_8_29 vssd1 vssd1 vccd1 vccd1 sky130_fd_sc_hd__fill_1
XFILLER_6_135 vssd1 vssd1 vccd1 vccd1 sky130_fd_sc_hd__fill_4
XFILLER_18_253 vssd1 vssd1 vccd1 vccd1 sky130_fd_sc_hd__fill_2
X_0844_ _0837_/A _0842_/Y _0898_/Q _0961_/Q vssd1 vssd1 vccd1 vccd1 _0898_/D sky130_fd_sc_hd__o2bb2a_2
X_0913_ clkload0/A _0913_/D _0913_/SET_B vssd1 vssd1 vccd1 vccd1 _0913_/Q sky130_fd_sc_hd__dfstp_2
X_0775_ _0874_/Q _0870_/Q vssd1 vssd1 vccd1 vccd1 _0776_/C sky130_fd_sc_hd__and2_2
Xteam_07_79 vssd1 vssd1 vccd1 vccd1 team_07_79/HI gpio_out[24] sky130_fd_sc_hd__conb_1
Xteam_07_68 vssd1 vssd1 vccd1 vccd1 team_07_68/HI gpio_out[11] sky130_fd_sc_hd__conb_1
Xteam_07_57 vssd1 vssd1 vccd1 vccd1 team_07_57/HI gpio_out[0] sky130_fd_sc_hd__conb_1
XFILLER_17_16 vssd1 vssd1 vccd1 vccd1 sky130_fd_sc_hd__fill_2
XFILLER_33_15 vssd1 vccd1 vssd1 vccd1 sky130_ef_sc_hd__decap_40_12
XFILLER_15_223 vssd1 vssd1 vccd1 vccd1 sky130_fd_sc_hd__fill_1
XFILLER_15_245 vssd1 vssd1 vccd1 vccd1 sky130_fd_sc_hd__fill_8
X_0560_ _0555_/X _0558_/X _0564_/B vssd1 vssd1 vccd1 vccd1 _0560_/X sky130_fd_sc_hd__a21o_2
X_0491_ _0965_/Q _0966_/Q vssd1 vssd1 vccd1 vccd1 _0493_/A sky130_fd_sc_hd__or2_2
XFILLER_9_83 vssd1 vssd1 vccd1 vccd1 sky130_fd_sc_hd__fill_2
X_0827_ _0895_/Q _0826_/X _0961_/Q vssd1 vssd1 vccd1 vccd1 _0895_/D sky130_fd_sc_hd__mux2_1
X_0758_ _0871_/Q _0870_/Q _0758_/C vssd1 vssd1 vccd1 vccd1 _0758_/Y sky130_fd_sc_hd__nand3_2
X_0689_ _0677_/X _0688_/A _0688_/B _0678_/X vssd1 vssd1 vccd1 vccd1 _0689_/Y sky130_fd_sc_hd__a31oi_2
XFILLER_28_37 vssd1 vssd1 vccd1 vccd1 sky130_fd_sc_hd__fill_2
XFILLER_28_26 vssd1 vssd1 vccd1 vccd1 sky130_fd_sc_hd__fill_2
X_0612_ _0416_/Y _0921_/Q hold145/X vssd1 vssd1 vccd1 vccd1 _0612_/X sky130_fd_sc_hd__a21o_2
X_0543_ _0651_/A _0994_/Q vssd1 vssd1 vccd1 vccd1 _0543_/Y sky130_fd_sc_hd__xnor2_2
X_0474_ input7/X _0977_/Q vssd1 vssd1 vccd1 vccd1 _0474_/X sky130_fd_sc_hd__and2b_2
XFILLER_29_167 vssd1 vssd1 vccd1 vccd1 sky130_fd_sc_hd__fill_1
X_0526_ _0526_/A _0526_/B _0528_/B vssd1 vssd1 vccd1 vccd1 _0527_/A sky130_fd_sc_hd__or3_2
X_0457_ _0947_/Q _0956_/Q _0919_/Q vssd1 vssd1 vccd1 vccd1 _0458_/A sky130_fd_sc_hd__o21ai_2
XFILLER_26_137 vssd1 vssd1 vccd1 vccd1 sky130_fd_sc_hd__fill_2
Xteam_07_116 vssd1 vssd1 vccd1 vccd1 gpio_oeb[30] team_07_116/LO sky130_fd_sc_hd__conb_1
Xteam_07_105 vssd1 vssd1 vccd1 vccd1 gpio_oeb[19] team_07_105/LO sky130_fd_sc_hd__conb_1
XFILLER_1_225 vssd1 vssd1 vccd1 vccd1 sky130_fd_sc_hd__fill_1
XFILLER_32_129 vssd1 vssd1 vccd1 vccd1 sky130_fd_sc_hd__fill_8
XFILLER_16_181 vssd1 vccd1 vssd1 vccd1 sky130_ef_sc_hd__decap_40_12
XTAP_TAPCELL_ROW_18_165 vssd1 vccd1 sky130_fd_sc_hd__tapvpwrvgnd_1
X_0509_ _0969_/Q _0970_/Q _0971_/Q _0509_/D vssd1 vssd1 vccd1 vccd1 _0519_/D sky130_fd_sc_hd__and4_2
XFILLER_22_151 vssd1 vssd1 vccd1 vccd1 sky130_fd_sc_hd__fill_4
XFILLER_13_140 vssd1 vssd1 vccd1 vccd1 sky130_fd_sc_hd__fill_2
XFILLER_13_151 vssd1 vssd1 vccd1 vccd1 sky130_fd_sc_hd__fill_8
X_0860_ _0912_/Q _0913_/Q _0863_/S vssd1 vssd1 vccd1 vccd1 _0912_/D sky130_fd_sc_hd__mux2_1
X_0791_ _0875_/Q _0880_/Q _0876_/Q _0879_/Q vssd1 vssd1 vccd1 vccd1 _0791_/X sky130_fd_sc_hd__a22o_2
XFILLER_9_199 vssd1 vssd1 vccd1 vccd1 sky130_fd_sc_hd__fill_4
XFILLER_9_155 vssd1 vccd1 vssd1 vccd1 sky130_ef_sc_hd__decap_40_12
X_0989_ clkload4/A _0989_/D load_slew37/X vssd1 vssd1 vccd1 vccd1 _0989_/Q sky130_fd_sc_hd__dfrtp_2
XTAP_TAPCELL_ROW_29_216 vssd1 vccd1 sky130_fd_sc_hd__tapvpwrvgnd_1
XFILLER_10_165 vssd1 vssd1 vccd1 vccd1 sky130_fd_sc_hd__fill_4
XTAP_TAPCELL_ROW_12_138 vssd1 vccd1 sky130_fd_sc_hd__tapvpwrvgnd_1
XFILLER_6_147 vssd1 vssd1 vccd1 vccd1 sky130_fd_sc_hd__fill_1
XFILLER_6_169 vssd1 vssd1 vccd1 vccd1 sky130_fd_sc_hd__fill_4
X_0912_ clkload0/A _0912_/D _0913_/SET_B vssd1 vssd1 vccd1 vccd1 _0912_/Q sky130_fd_sc_hd__dfstp_2
X_0843_ _0837_/A _0841_/X _0842_/Y _0796_/B hold175/X vssd1 vssd1 vccd1 vccd1 _0897_/D
+ sky130_fd_sc_hd__a32o_2
X_0774_ _0888_/Q _0948_/Q vssd1 vssd1 vccd1 vccd1 _0774_/X sky130_fd_sc_hd__or2_2
Xteam_07_69 vssd1 vssd1 vccd1 vccd1 team_07_69/HI gpio_out[12] sky130_fd_sc_hd__conb_1
Xteam_07_58 vssd1 vssd1 vccd1 vccd1 team_07_58/HI gpio_out[1] sky130_fd_sc_hd__conb_1
XFILLER_3_117 vssd1 vssd1 vccd1 vccd1 sky130_fd_sc_hd__fill_2
XFILLER_30_205 vssd1 vssd1 vccd1 vccd1 sky130_fd_sc_hd__fill_1
XPHY_EDGE_ROW_29_Left_68 vssd1 vssd1 vccd1 vccd1 sky130_fd_sc_hd__decap_3
XFILLER_17_5 vssd1 vssd1 vccd1 vccd1 sky130_fd_sc_hd__fill_1
X_0490_ _0481_/X _0486_/X _0458_/A vssd1 vssd1 vccd1 vccd1 _0526_/A sky130_fd_sc_hd__o21ai_2
XFILLER_2_194 vssd1 vssd1 vccd1 vccd1 sky130_fd_sc_hd__fill_2
XTAP_TAPCELL_ROW_31_222 vssd1 vccd1 sky130_fd_sc_hd__tapvpwrvgnd_1
XANTENNA_clkbuf_4_6_0_clk_A clkbuf_0_clk/X vssd1 vssd1 vccd1 vccd1 sky130_fd_sc_hd__diode_2
X_0826_ _0833_/C _0833_/B vssd1 vssd1 vccd1 vccd1 _0826_/X sky130_fd_sc_hd__xor2_2
X_0757_ _0769_/A _0757_/B vssd1 vssd1 vccd1 vccd1 _0758_/C sky130_fd_sc_hd__xnor2_2
X_0688_ _0688_/A _0688_/B vssd1 vssd1 vccd1 vccd1 _0688_/Y sky130_fd_sc_hd__nand2_2
Xclkbuf_4_15_0_clk clkbuf_0_clk/X vssd1 vssd1 vccd1 vccd1 _0938_/CLK sky130_fd_sc_hd__clkbuf_8
XFILLER_7_231 vssd1 vssd1 vccd1 vccd1 sky130_fd_sc_hd__fill_2
X_0611_ _0416_/Y _0922_/Q hold152/X vssd1 vssd1 vccd1 vccd1 _0611_/X sky130_fd_sc_hd__a21o_2
X_0542_ _0421_/A _0988_/Q vssd1 vssd1 vccd1 vccd1 _0542_/Y sky130_fd_sc_hd__nand2b_2
X_0473_ _0547_/B _0965_/Q vssd1 vssd1 vccd1 vccd1 _0473_/Y sky130_fd_sc_hd__xnor2_2
XFILLER_38_113 vssd1 vssd1 vccd1 vccd1 sky130_fd_sc_hd__fill_1
X_0809_ _0809_/A _0809_/B vssd1 vssd1 vccd1 vccd1 _0811_/C sky130_fd_sc_hd__xnor2_2
XFILLER_29_135 vssd1 vssd1 vccd1 vccd1 sky130_fd_sc_hd__fill_8
XFILLER_29_124 vssd1 vssd1 vccd1 vccd1 sky130_fd_sc_hd__fill_1
X_0525_ _0975_/Q _0976_/Q _0525_/C vssd1 vssd1 vccd1 vccd1 _0528_/B sky130_fd_sc_hd__and3_2
X_0456_ _0947_/Q _0956_/Q vssd1 vssd1 vccd1 vccd1 _0456_/Y sky130_fd_sc_hd__nor2_2
XPHY_EDGE_ROW_16_Left_55 vssd1 vssd1 vccd1 vccd1 sky130_fd_sc_hd__decap_3
Xteam_07_117 vssd1 vssd1 vccd1 vccd1 gpio_oeb[31] team_07_117/LO sky130_fd_sc_hd__conb_1
Xteam_07_106 vssd1 vssd1 vccd1 vccd1 gpio_oeb[20] team_07_106/LO sky130_fd_sc_hd__conb_1
XFILLER_32_119 vssd1 vssd1 vccd1 vccd1 sky130_fd_sc_hd__fill_2
XANTENNA_clkbuf_4_14_0_clk_A clkbuf_0_clk/X vssd1 vssd1 vccd1 vccd1 sky130_fd_sc_hd__diode_2
XFILLER_31_60 vssd1 vssd1 vccd1 vccd1 sky130_fd_sc_hd__fill_8
XTAP_TAPCELL_ROW_18_166 vssd1 vccd1 sky130_fd_sc_hd__tapvpwrvgnd_1
X_0508_ _0481_/X _0486_/X _0507_/Y _0458_/A vssd1 vssd1 vccd1 vccd1 _0970_/D sky130_fd_sc_hd__o211a_2
X_0439_ _0979_/Q _0980_/Q _0863_/S vssd1 vssd1 vccd1 vccd1 _0625_/B sky130_fd_sc_hd__and3_2
XTAP_TAPCELL_ROW_9_123 vssd1 vccd1 sky130_fd_sc_hd__tapvpwrvgnd_1
XFILLER_26_82 vssd1 vssd1 vccd1 vccd1 sky130_fd_sc_hd__fill_2
X_0790_ _0891_/Q _0796_/B _0789_/X vssd1 vssd1 vccd1 vccd1 _0891_/D sky130_fd_sc_hd__a21o_2
XFILLER_9_167 vssd1 vssd1 vccd1 vccd1 sky130_fd_sc_hd__fill_1
X_0988_ clkload4/A _0988_/D load_slew37/X vssd1 vssd1 vccd1 vccd1 _0988_/Q sky130_fd_sc_hd__dfrtp_2
XFILLER_22_29 vssd1 vssd1 vccd1 vccd1 sky130_fd_sc_hd__fill_1
XANTENNA_input1_A en vssd1 vssd1 vccd1 vccd1 sky130_fd_sc_hd__diode_2
XFILLER_27_200 vssd1 vssd1 vccd1 vccd1 sky130_fd_sc_hd__fill_1
XTAP_TAPCELL_ROW_37_250 vssd1 vccd1 sky130_fd_sc_hd__tapvpwrvgnd_1
XTAP_TAPCELL_ROW_20_172 vssd1 vccd1 sky130_fd_sc_hd__tapvpwrvgnd_1
XTAP_TAPCELL_ROW_12_139 vssd1 vccd1 sky130_fd_sc_hd__tapvpwrvgnd_1
X_0842_ _0830_/X _0831_/Y _0835_/C _0837_/B _0796_/B vssd1 vssd1 vccd1 vccd1 _0842_/Y
+ sky130_fd_sc_hd__a41oi_2
X_0911_ clkload0/A _0911_/D _0911_/SET_B vssd1 vssd1 vccd1 vccd1 _0911_/Q sky130_fd_sc_hd__dfstp_2
X_0773_ _0887_/Q _0772_/X _0948_/Q vssd1 vssd1 vccd1 vccd1 _0887_/D sky130_fd_sc_hd__mux2_1
Xteam_07_59 vssd1 vssd1 vccd1 vccd1 team_07_59/HI gpio_out[2] sky130_fd_sc_hd__conb_1
XANTENNA_clkbuf_4_2_0_clk_A clkbuf_0_clk/X vssd1 vssd1 vccd1 vccd1 sky130_fd_sc_hd__diode_2
XFILLER_15_225 vssd1 vssd1 vccd1 vccd1 sky130_fd_sc_hd__fill_4
XPHY_EDGE_ROW_4_Left_43 vssd1 vssd1 vccd1 vccd1 sky130_fd_sc_hd__decap_3
X_0825_ _0825_/A _0831_/C vssd1 vssd1 vccd1 vccd1 _0833_/B sky130_fd_sc_hd__xnor2_2
XTAP_TAPCELL_ROW_31_223 vssd1 vccd1 sky130_fd_sc_hd__tapvpwrvgnd_1
X_0756_ _0770_/A _0769_/B vssd1 vssd1 vccd1 vccd1 _0757_/B sky130_fd_sc_hd__nor2_2
X_0687_ _0886_/Q _0714_/C _0714_/D _0894_/Q vssd1 vssd1 vccd1 vccd1 _0688_/B sky130_fd_sc_hd__a31o_2
XFILLER_28_39 vssd1 vssd1 vccd1 vccd1 sky130_fd_sc_hd__fill_1
XPHY_EDGE_ROW_30_Left_69 vssd1 vssd1 vccd1 vccd1 sky130_fd_sc_hd__decap_3
XFILLER_7_254 vssd1 vssd1 vccd1 vccd1 sky130_fd_sc_hd__fill_1
XFILLER_34_82 vssd1 vssd1 vccd1 vccd1 sky130_fd_sc_hd__fill_2
X_0610_ _0416_/Y _0923_/Q hold130/X vssd1 vssd1 vccd1 vccd1 _0610_/X sky130_fd_sc_hd__a21o_2
X_0541_ _0986_/Q _0541_/B vssd1 vssd1 vccd1 vccd1 _0541_/Y sky130_fd_sc_hd__nand2b_2
X_0472_ input4/X _0974_/Q vssd1 vssd1 vccd1 vccd1 _0472_/X sky130_fd_sc_hd__and2b_2
X_0808_ _0806_/X _0808_/B vssd1 vssd1 vccd1 vccd1 _0809_/B sky130_fd_sc_hd__and2b_2
XFILLER_30_29 vssd1 vssd1 vccd1 vccd1 sky130_fd_sc_hd__fill_4
X_0739_ _0740_/B vssd1 vssd1 vccd1 vccd1 _0748_/A sky130_fd_sc_hd__inv_2
XFILLER_29_169 vssd1 vssd1 vccd1 vccd1 sky130_fd_sc_hd__fill_1
XFILLER_20_62 vssd1 vssd1 vccd1 vccd1 sky130_fd_sc_hd__fill_1
XANTENNA_clkbuf_4_10_0_clk_A clkbuf_0_clk/X vssd1 vssd1 vccd1 vccd1 sky130_fd_sc_hd__diode_2
XFILLER_35_139 vssd1 vssd1 vccd1 vccd1 sky130_fd_sc_hd__fill_1
Xclkbuf_4_14_0_clk clkbuf_0_clk/X vssd1 vssd1 vccd1 vccd1 _0939_/CLK sky130_fd_sc_hd__clkbuf_8
X_0524_ _0524_/A _0524_/B vssd1 vssd1 vccd1 vccd1 _0526_/B sky130_fd_sc_hd__and2_2
X_0455_ _0455_/A _0920_/Q vssd1 vssd1 vccd1 vccd1 _0455_/X sky130_fd_sc_hd__and2_2
XFILLER_26_139 vssd1 vssd1 vccd1 vccd1 sky130_fd_sc_hd__fill_1
Xteam_07_118 vssd1 vssd1 vccd1 vccd1 gpio_oeb[32] team_07_118/LO sky130_fd_sc_hd__conb_1
Xteam_07_107 vssd1 vssd1 vccd1 vccd1 gpio_oeb[21] team_07_107/LO sky130_fd_sc_hd__conb_1
XFILLER_25_150 vssd1 vssd1 vccd1 vccd1 sky130_fd_sc_hd__fill_4
XPHY_EDGE_ROW_33_Left_72 vssd1 vssd1 vccd1 vccd1 sky130_fd_sc_hd__decap_3
XTAP_TAPCELL_ROW_18_167 vssd1 vccd1 sky130_fd_sc_hd__tapvpwrvgnd_1
XFILLER_31_153 vssd1 vssd1 vccd1 vccd1 sky130_fd_sc_hd__fill_4
XFILLER_31_131 vssd1 vssd1 vccd1 vccd1 sky130_fd_sc_hd__fill_2
XFILLER_31_120 vssd1 vssd1 vccd1 vccd1 sky130_fd_sc_hd__fill_2
X_0507_ _0510_/B _0507_/B vssd1 vssd1 vccd1 vccd1 _0507_/Y sky130_fd_sc_hd__nor2_2
X_0438_ _0979_/Q _0863_/S vssd1 vssd1 vccd1 vccd1 _0438_/Y sky130_fd_sc_hd__nand2_2
XFILLER_22_197 vssd1 vssd1 vccd1 vccd1 sky130_fd_sc_hd__fill_2
XTAP_TAPCELL_ROW_9_124 vssd1 vccd1 sky130_fd_sc_hd__tapvpwrvgnd_1
XFILLER_13_142 vssd1 vssd1 vccd1 vccd1 sky130_fd_sc_hd__fill_1
XFILLER_9_113 vssd1 vssd1 vccd1 vccd1 sky130_fd_sc_hd__fill_2
XFILLER_26_94 vssd1 vssd1 vccd1 vccd1 sky130_fd_sc_hd__fill_4
X_0987_ clkload4/A _0987_/D load_slew37/X vssd1 vssd1 vccd1 vccd1 _0987_/Q sky130_fd_sc_hd__dfrtp_2
XFILLER_27_223 vssd1 vssd1 vccd1 vccd1 sky130_fd_sc_hd__fill_1
XTAP_TAPCELL_ROW_37_251 vssd1 vccd1 sky130_fd_sc_hd__tapvpwrvgnd_1
XFILLER_12_85 vssd1 vssd1 vccd1 vccd1 sky130_fd_sc_hd__fill_4
XTAP_TAPCELL_ROW_20_173 vssd1 vccd1 sky130_fd_sc_hd__tapvpwrvgnd_1
XFILLER_18_201 vssd1 vssd1 vccd1 vccd1 sky130_fd_sc_hd__fill_2
XPHY_EDGE_ROW_16_Right_16 vssd1 vssd1 vccd1 vccd1 sky130_fd_sc_hd__decap_3
X_0841_ _0830_/X _0831_/Y _0837_/B _0835_/C vssd1 vssd1 vccd1 vccd1 _0841_/X sky130_fd_sc_hd__a31o_2
X_0910_ clkload0/A _0910_/D _0911_/SET_B vssd1 vssd1 vccd1 vccd1 _0910_/Q sky130_fd_sc_hd__dfstp_2
X_0772_ _0772_/A _0772_/B vssd1 vssd1 vccd1 vccd1 _0772_/X sky130_fd_sc_hd__xor2_2
XPHY_EDGE_ROW_25_Right_25 vssd1 vssd1 vccd1 vccd1 sky130_fd_sc_hd__decap_3
XFILLER_5_160 vssd1 vssd1 vccd1 vccd1 sky130_fd_sc_hd__fill_8
XPHY_EDGE_ROW_34_Right_34 vssd1 vssd1 vccd1 vccd1 sky130_fd_sc_hd__decap_3
XFILLER_3_119 vssd1 vssd1 vccd1 vccd1 sky130_fd_sc_hd__fill_1
XANTENNA_fanout52_A _0466_/X vssd1 vssd1 vccd1 vccd1 sky130_fd_sc_hd__diode_2
XFILLER_23_73 vssd1 vssd1 vccd1 vccd1 sky130_fd_sc_hd__fill_1
XTAP_TAPCELL_ROW_31_224 vssd1 vccd1 sky130_fd_sc_hd__tapvpwrvgnd_1
XFILLER_21_207 vssd1 vssd1 vccd1 vccd1 sky130_fd_sc_hd__fill_2
X_0824_ _0880_/Q _0878_/Q vssd1 vssd1 vccd1 vccd1 _0831_/C sky130_fd_sc_hd__and2_2
X_0755_ _0868_/Q _0873_/Q _0874_/Q _0867_/Q vssd1 vssd1 vccd1 vccd1 _0769_/B sky130_fd_sc_hd__a22oi_2
X_0686_ _0714_/C _0714_/D _0886_/Q vssd1 vssd1 vccd1 vccd1 _0688_/A sky130_fd_sc_hd__a21o_2
XFILLER_28_29 vssd1 vssd1 vccd1 vccd1 sky130_fd_sc_hd__fill_8
XFILLER_34_61 vssd1 vssd1 vccd1 vccd1 sky130_fd_sc_hd__fill_1
XFILLER_7_211 vssd1 vccd1 vssd1 vccd1 sky130_ef_sc_hd__decap_40_12
X_0540_ _0997_/Q input8/X vssd1 vssd1 vccd1 vccd1 _0540_/Y sky130_fd_sc_hd__nand2b_2
X_0471_ _0977_/Q input7/X vssd1 vssd1 vccd1 vccd1 _0471_/X sky130_fd_sc_hd__and2b_2
XFILLER_22_5 vssd1 vssd1 vccd1 vccd1 sky130_fd_sc_hd__fill_2
X_0807_ _0876_/Q _0881_/Q _0882_/Q _0875_/Q vssd1 vssd1 vccd1 vccd1 _0808_/B sky130_fd_sc_hd__a22o_2
X_0738_ _0867_/Q _0872_/Q _0868_/Q _0871_/Q vssd1 vssd1 vccd1 vccd1 _0740_/B sky130_fd_sc_hd__and4_2
X_0669_ _0429_/Y _0995_/D _0997_/D _0653_/A _0655_/Y vssd1 vssd1 vccd1 vccd1 _0670_/C
+ sky130_fd_sc_hd__o221a_2
XPHY_EDGE_ROW_2_Right_2 vssd1 vssd1 vccd1 vccd1 sky130_fd_sc_hd__decap_3
XFILLER_4_236 vssd1 vccd1 vssd1 vccd1 sky130_ef_sc_hd__decap_40_12
XANTENNA__0959__CLK clkload7/A vssd1 vssd1 vccd1 vccd1 sky130_fd_sc_hd__diode_2
XFILLER_29_72 vssd1 vssd1 vccd1 vccd1 sky130_fd_sc_hd__fill_2
X_0523_ _0523_/A _0523_/B _0524_/B vssd1 vssd1 vccd1 vccd1 _0975_/D sky130_fd_sc_hd__and3_2
X_0454_ _0454_/A _0454_/B vssd1 vssd1 vccd1 vccd1 _0932_/D sky130_fd_sc_hd__and2_2
XFILLER_34_184 vssd1 vssd1 vccd1 vccd1 sky130_fd_sc_hd__fill_1
XFILLER_26_129 vssd1 vssd1 vccd1 vccd1 sky130_fd_sc_hd__fill_8
Xteam_07_119 vssd1 vssd1 vccd1 vccd1 gpio_oeb[33] team_07_119/LO sky130_fd_sc_hd__conb_1
Xteam_07_108 vssd1 vssd1 vccd1 vccd1 gpio_oeb[22] team_07_108/LO sky130_fd_sc_hd__conb_1
XFILLER_15_63 vssd1 vssd1 vccd1 vccd1 sky130_fd_sc_hd__fill_1
X_0506_ _0969_/Q _0509_/D _0970_/Q vssd1 vssd1 vccd1 vccd1 _0507_/B sky130_fd_sc_hd__a21oi_2
X_0437_ _0961_/Q vssd1 vssd1 vccd1 vccd1 _0796_/B sky130_fd_sc_hd__inv_2
Xclkbuf_4_13_0_clk clkbuf_0_clk/X vssd1 vssd1 vccd1 vccd1 _0977_/CLK sky130_fd_sc_hd__clkbuf_8
XTAP_TAPCELL_ROW_9_125 vssd1 vccd1 sky130_fd_sc_hd__tapvpwrvgnd_1
XFILLER_26_51 vssd1 vssd1 vccd1 vccd1 sky130_fd_sc_hd__fill_4
XFILLER_9_169 vssd1 vssd1 vccd1 vccd1 sky130_fd_sc_hd__fill_1
X_0986_ clkload6/A _0986_/D load_slew37/X vssd1 vssd1 vccd1 vccd1 _0986_/Q sky130_fd_sc_hd__dfrtp_2
XTAP_TAPCELL_ROW_37_252 vssd1 vccd1 sky130_fd_sc_hd__tapvpwrvgnd_1
XFILLER_10_113 vssd1 vssd1 vccd1 vccd1 sky130_fd_sc_hd__fill_1
XFILLER_10_157 vssd1 vssd1 vccd1 vccd1 sky130_fd_sc_hd__fill_1
XFILLER_12_97 vssd1 vssd1 vccd1 vccd1 sky130_fd_sc_hd__fill_4
Xhold180 _0955_/Q vssd1 vssd1 vccd1 vccd1 _0465_/B sky130_fd_sc_hd__dlygate4sd3_1
XTAP_TAPCELL_ROW_20_174 vssd1 vccd1 sky130_fd_sc_hd__tapvpwrvgnd_1
XFILLER_6_139 vssd1 vssd1 vccd1 vccd1 sky130_fd_sc_hd__fill_1
XFILLER_5_3 vssd1 vssd1 vccd1 vccd1 sky130_fd_sc_hd__fill_1
XFILLER_18_213 vssd1 vccd1 vssd1 vccd1 sky130_ef_sc_hd__decap_40_12
X_0840_ _0796_/B _0838_/X _0839_/Y _0828_/X vssd1 vssd1 vccd1 vccd1 _0896_/D sky130_fd_sc_hd__o31a_2
X_0771_ _0771_/A _0771_/B vssd1 vssd1 vccd1 vccd1 _0772_/B sky130_fd_sc_hd__xnor2_2
X_0969_ _0990_/CLK _0969_/D _0919_/SET_B vssd1 vssd1 vccd1 vccd1 _0969_/Q sky130_fd_sc_hd__dfrtp_2
XFILLER_3_109 vssd1 vssd1 vccd1 vccd1 sky130_fd_sc_hd__fill_2
XANTENNA_fanout45_A _0466_/X vssd1 vssd1 vccd1 vccd1 sky130_fd_sc_hd__diode_2
XFILLER_23_30 vssd1 vssd1 vccd1 vccd1 sky130_fd_sc_hd__fill_4
XFILLER_2_197 vssd1 vssd1 vccd1 vccd1 sky130_fd_sc_hd__fill_1
XFILLER_2_186 vssd1 vssd1 vccd1 vccd1 sky130_fd_sc_hd__fill_8
XTAP_TAPCELL_ROW_31_225 vssd1 vccd1 sky130_fd_sc_hd__tapvpwrvgnd_1
XFILLER_21_219 vssd1 vssd1 vccd1 vccd1 sky130_fd_sc_hd__fill_4
X_0823_ _0831_/B _0823_/B vssd1 vssd1 vccd1 vccd1 _0825_/A sky130_fd_sc_hd__nand2b_2
X_0754_ _0867_/Q _0868_/Q _0873_/Q _0874_/Q vssd1 vssd1 vccd1 vccd1 _0770_/A sky130_fd_sc_hd__and4_2
X_0685_ _0885_/Q _0683_/B _0683_/C _0893_/Q vssd1 vssd1 vccd1 vccd1 _0714_/D sky130_fd_sc_hd__a31o_2
XFILLER_12_219 vssd1 vssd1 vccd1 vccd1 sky130_fd_sc_hd__fill_1
XFILLER_34_95 vssd1 vssd1 vccd1 vccd1 sky130_fd_sc_hd__fill_2
XFILLER_7_223 vssd1 vssd1 vccd1 vccd1 sky130_fd_sc_hd__fill_1
X_0470_ _0971_/Q _0637_/A vssd1 vssd1 vccd1 vccd1 _0470_/X sky130_fd_sc_hd__and2b_2
Xload_slew51 fanout50/X vssd1 vssd1 vccd1 vccd1 fanout48/A sky130_fd_sc_hd__clkbuf_4
X_0806_ _0875_/Q _0876_/Q _0881_/Q _0882_/Q vssd1 vssd1 vccd1 vccd1 _0806_/X sky130_fd_sc_hd__and4_2
X_0737_ _0867_/Q _0872_/Q _0868_/Q _0871_/Q vssd1 vssd1 vccd1 vccd1 _0737_/X sky130_fd_sc_hd__a22o_2
X_0668_ _0667_/X _0668_/B _0668_/C _0668_/D vssd1 vssd1 vccd1 vccd1 _0670_/B sky130_fd_sc_hd__and4b_2
X_0599_ _0996_/Q _0997_/Q _0594_/C _0598_/Y _0594_/A vssd1 vssd1 vccd1 vccd1 _0997_/D
+ sky130_fd_sc_hd__a311oi_2
XFILLER_4_248 vssd1 vssd1 vccd1 vccd1 sky130_fd_sc_hd__fill_1
X_0522_ _0975_/Q _0525_/C vssd1 vssd1 vccd1 vccd1 _0524_/B sky130_fd_sc_hd__nand2_2
X_0453_ _0454_/A _0453_/B vssd1 vssd1 vccd1 vccd1 _0933_/D sky130_fd_sc_hd__and2_2
XFILLER_34_141 vssd1 vssd1 vccd1 vccd1 sky130_fd_sc_hd__fill_1
Xteam_07_109 vssd1 vssd1 vccd1 vccd1 gpio_oeb[23] team_07_109/LO sky130_fd_sc_hd__conb_1
XFILLER_31_30 vssd1 vccd1 vssd1 vccd1 sky130_ef_sc_hd__decap_40_12
X_0505_ _0969_/Q _0970_/Q _0509_/D vssd1 vssd1 vccd1 vccd1 _0510_/B sky130_fd_sc_hd__and3_2
X_0436_ _0948_/Q vssd1 vssd1 vccd1 vccd1 _0742_/B sky130_fd_sc_hd__inv_2
.ends
