* NGSPICE file created from team_07.ext - technology: sky130A

* Black-box entry subcircuit for sky130_fd_sc_hd__fill_8 abstract view
.subckt sky130_fd_sc_hd__fill_8 VGND VNB VPB VPWR
.ends

* Black-box entry subcircuit for sky130_fd_sc_hd__tapvpwrvgnd_1 abstract view
.subckt sky130_fd_sc_hd__tapvpwrvgnd_1 VGND VPWR
.ends

* Black-box entry subcircuit for sky130_fd_sc_hd__fill_1 abstract view
.subckt sky130_fd_sc_hd__fill_1 VGND VNB VPB VPWR
.ends

* Black-box entry subcircuit for sky130_fd_sc_hd__diode_2 abstract view
.subckt sky130_fd_sc_hd__diode_2 DIODE VGND VNB VPB VPWR
.ends

* Black-box entry subcircuit for sky130_ef_sc_hd__decap_40_12 abstract view
.subckt sky130_ef_sc_hd__decap_40_12 VPWR VGND VPB VNB
.ends

* Black-box entry subcircuit for sky130_fd_sc_hd__dfstp_2 abstract view
.subckt sky130_fd_sc_hd__dfstp_2 CLK D SET_B VGND VNB VPB VPWR Q
.ends

* Black-box entry subcircuit for sky130_fd_sc_hd__or4_1 abstract view
.subckt sky130_fd_sc_hd__or4_1 A B C D VGND VNB VPB VPWR X
.ends

* Black-box entry subcircuit for sky130_fd_sc_hd__dfstp_1 abstract view
.subckt sky130_fd_sc_hd__dfstp_1 CLK D SET_B VGND VNB VPB VPWR Q
.ends

* Black-box entry subcircuit for sky130_fd_sc_hd__xnor2_1 abstract view
.subckt sky130_fd_sc_hd__xnor2_1 A B VGND VNB VPB VPWR Y
.ends

* Black-box entry subcircuit for sky130_fd_sc_hd__fill_2 abstract view
.subckt sky130_fd_sc_hd__fill_2 VGND VNB VPB VPWR
.ends

* Black-box entry subcircuit for sky130_fd_sc_hd__nor2_1 abstract view
.subckt sky130_fd_sc_hd__nor2_1 A B VGND VNB VPB VPWR Y
.ends

* Black-box entry subcircuit for sky130_fd_sc_hd__a21bo_1 abstract view
.subckt sky130_fd_sc_hd__a21bo_1 A1 A2 B1_N VGND VNB VPB VPWR X
.ends

* Black-box entry subcircuit for sky130_fd_sc_hd__a21o_1 abstract view
.subckt sky130_fd_sc_hd__a21o_1 A1 A2 B1 VGND VNB VPB VPWR X
.ends

* Black-box entry subcircuit for sky130_fd_sc_hd__fill_4 abstract view
.subckt sky130_fd_sc_hd__fill_4 VGND VNB VPB VPWR
.ends

* Black-box entry subcircuit for sky130_fd_sc_hd__decap_3 abstract view
.subckt sky130_fd_sc_hd__decap_3 VGND VNB VPB VPWR
.ends

* Black-box entry subcircuit for sky130_fd_sc_hd__o211ai_1 abstract view
.subckt sky130_fd_sc_hd__o211ai_1 A1 A2 B1 C1 VGND VNB VPB VPWR Y
.ends

* Black-box entry subcircuit for sky130_fd_sc_hd__a32o_1 abstract view
.subckt sky130_fd_sc_hd__a32o_1 A1 A2 A3 B1 B2 VGND VNB VPB VPWR X
.ends

* Black-box entry subcircuit for sky130_fd_sc_hd__o2111a_1 abstract view
.subckt sky130_fd_sc_hd__o2111a_1 A1 A2 B1 C1 D1 VGND VNB VPB VPWR X
.ends

* Black-box entry subcircuit for sky130_fd_sc_hd__inv_2 abstract view
.subckt sky130_fd_sc_hd__inv_2 A VGND VNB VPB VPWR Y
.ends

* Black-box entry subcircuit for sky130_fd_sc_hd__a21boi_2 abstract view
.subckt sky130_fd_sc_hd__a21boi_2 A1 A2 B1_N VGND VNB VPB VPWR Y
.ends

* Black-box entry subcircuit for sky130_fd_sc_hd__dfrtp_1 abstract view
.subckt sky130_fd_sc_hd__dfrtp_1 CLK D RESET_B VGND VNB VPB VPWR Q
.ends

* Black-box entry subcircuit for sky130_fd_sc_hd__o221a_1 abstract view
.subckt sky130_fd_sc_hd__o221a_1 A1 A2 B1 B2 C1 VGND VNB VPB VPWR X
.ends

* Black-box entry subcircuit for sky130_fd_sc_hd__buf_2 abstract view
.subckt sky130_fd_sc_hd__buf_2 A VGND VNB VPB VPWR X
.ends

* Black-box entry subcircuit for sky130_fd_sc_hd__nand2b_1 abstract view
.subckt sky130_fd_sc_hd__nand2b_1 A_N B VGND VNB VPB VPWR Y
.ends

* Black-box entry subcircuit for sky130_fd_sc_hd__clkbuf_16 abstract view
.subckt sky130_fd_sc_hd__clkbuf_16 A VGND VNB VPB VPWR X
.ends

* Black-box entry subcircuit for sky130_fd_sc_hd__o21ba_1 abstract view
.subckt sky130_fd_sc_hd__o21ba_1 A1 A2 B1_N VGND VNB VPB VPWR X
.ends

* Black-box entry subcircuit for sky130_fd_sc_hd__and4bb_1 abstract view
.subckt sky130_fd_sc_hd__and4bb_1 A_N B_N C D VGND VNB VPB VPWR X
.ends

* Black-box entry subcircuit for sky130_fd_sc_hd__nand4_1 abstract view
.subckt sky130_fd_sc_hd__nand4_1 A B C D VGND VNB VPB VPWR Y
.ends

* Black-box entry subcircuit for sky130_fd_sc_hd__a211o_1 abstract view
.subckt sky130_fd_sc_hd__a211o_1 A1 A2 B1 C1 VGND VNB VPB VPWR X
.ends

* Black-box entry subcircuit for sky130_fd_sc_hd__or2_1 abstract view
.subckt sky130_fd_sc_hd__or2_1 A B VGND VNB VPB VPWR X
.ends

* Black-box entry subcircuit for sky130_fd_sc_hd__nand2_1 abstract view
.subckt sky130_fd_sc_hd__nand2_1 A B VGND VNB VPB VPWR Y
.ends

* Black-box entry subcircuit for sky130_fd_sc_hd__dlygate4sd3_1 abstract view
.subckt sky130_fd_sc_hd__dlygate4sd3_1 A VGND VNB VPB VPWR X
.ends

* Black-box entry subcircuit for sky130_fd_sc_hd__a21boi_1 abstract view
.subckt sky130_fd_sc_hd__a21boi_1 A1 A2 B1_N VGND VNB VPB VPWR Y
.ends

* Black-box entry subcircuit for sky130_fd_sc_hd__and3_1 abstract view
.subckt sky130_fd_sc_hd__and3_1 A B C VGND VNB VPB VPWR X
.ends

* Black-box entry subcircuit for sky130_fd_sc_hd__o21ai_1 abstract view
.subckt sky130_fd_sc_hd__o21ai_1 A1 A2 B1 VGND VNB VPB VPWR Y
.ends

* Black-box entry subcircuit for sky130_fd_sc_hd__a22o_1 abstract view
.subckt sky130_fd_sc_hd__a22o_1 A1 A2 B1 B2 VGND VNB VPB VPWR X
.ends

* Black-box entry subcircuit for sky130_fd_sc_hd__or3b_1 abstract view
.subckt sky130_fd_sc_hd__or3b_1 A B C_N VGND VNB VPB VPWR X
.ends

* Black-box entry subcircuit for sky130_fd_sc_hd__and2b_1 abstract view
.subckt sky130_fd_sc_hd__and2b_1 A_N B VGND VNB VPB VPWR X
.ends

* Black-box entry subcircuit for sky130_fd_sc_hd__and2_1 abstract view
.subckt sky130_fd_sc_hd__and2_1 A B VGND VNB VPB VPWR X
.ends

* Black-box entry subcircuit for sky130_fd_sc_hd__a2bb2o_1 abstract view
.subckt sky130_fd_sc_hd__a2bb2o_1 A1_N A2_N B1 B2 VGND VNB VPB VPWR X
.ends

* Black-box entry subcircuit for sky130_fd_sc_hd__mux2_1 abstract view
.subckt sky130_fd_sc_hd__mux2_1 A0 A1 S VGND VNB VPB VPWR X
.ends

* Black-box entry subcircuit for sky130_fd_sc_hd__dfrtp_4 abstract view
.subckt sky130_fd_sc_hd__dfrtp_4 CLK D RESET_B VGND VNB VPB VPWR Q
.ends

* Black-box entry subcircuit for sky130_fd_sc_hd__a21oi_1 abstract view
.subckt sky130_fd_sc_hd__a21oi_1 A1 A2 B1 VGND VNB VPB VPWR Y
.ends

* Black-box entry subcircuit for sky130_fd_sc_hd__o21bai_1 abstract view
.subckt sky130_fd_sc_hd__o21bai_1 A1 A2 B1_N VGND VNB VPB VPWR Y
.ends

* Black-box entry subcircuit for sky130_fd_sc_hd__inv_6 abstract view
.subckt sky130_fd_sc_hd__inv_6 A VGND VNB VPB VPWR Y
.ends

* Black-box entry subcircuit for sky130_fd_sc_hd__and4_1 abstract view
.subckt sky130_fd_sc_hd__and4_1 A B C D VGND VNB VPB VPWR X
.ends

* Black-box entry subcircuit for sky130_fd_sc_hd__xor2_1 abstract view
.subckt sky130_fd_sc_hd__xor2_1 A B VGND VNB VPB VPWR X
.ends

* Black-box entry subcircuit for sky130_fd_sc_hd__nand3_1 abstract view
.subckt sky130_fd_sc_hd__nand3_1 A B C VGND VNB VPB VPWR Y
.ends

* Black-box entry subcircuit for sky130_fd_sc_hd__clkinv_2 abstract view
.subckt sky130_fd_sc_hd__clkinv_2 A VGND VNB VPB VPWR Y
.ends

* Black-box entry subcircuit for sky130_fd_sc_hd__and3b_1 abstract view
.subckt sky130_fd_sc_hd__and3b_1 A_N B C VGND VNB VPB VPWR X
.ends

* Black-box entry subcircuit for sky130_fd_sc_hd__clkinv_4 abstract view
.subckt sky130_fd_sc_hd__clkinv_4 A VGND VNB VPB VPWR Y
.ends

* Black-box entry subcircuit for sky130_fd_sc_hd__o32a_1 abstract view
.subckt sky130_fd_sc_hd__o32a_1 A1 A2 A3 B1 B2 VGND VNB VPB VPWR X
.ends

* Black-box entry subcircuit for sky130_fd_sc_hd__o21a_1 abstract view
.subckt sky130_fd_sc_hd__o21a_1 A1 A2 B1 VGND VNB VPB VPWR X
.ends

* Black-box entry subcircuit for sky130_fd_sc_hd__and3_4 abstract view
.subckt sky130_fd_sc_hd__and3_4 A B C VGND VNB VPB VPWR X
.ends

* Black-box entry subcircuit for sky130_fd_sc_hd__a31o_1 abstract view
.subckt sky130_fd_sc_hd__a31o_1 A1 A2 A3 B1 VGND VNB VPB VPWR X
.ends

* Black-box entry subcircuit for sky130_fd_sc_hd__nand3b_1 abstract view
.subckt sky130_fd_sc_hd__nand3b_1 A_N B C VGND VNB VPB VPWR Y
.ends

* Black-box entry subcircuit for sky130_fd_sc_hd__clkbuf_1 abstract view
.subckt sky130_fd_sc_hd__clkbuf_1 A VGND VNB VPB VPWR X
.ends

* Black-box entry subcircuit for sky130_fd_sc_hd__dfrtp_2 abstract view
.subckt sky130_fd_sc_hd__dfrtp_2 CLK D RESET_B VGND VNB VPB VPWR Q
.ends

* Black-box entry subcircuit for sky130_fd_sc_hd__nand2_4 abstract view
.subckt sky130_fd_sc_hd__nand2_4 A B VGND VNB VPB VPWR Y
.ends

* Black-box entry subcircuit for sky130_fd_sc_hd__bufinv_16 abstract view
.subckt sky130_fd_sc_hd__bufinv_16 A VGND VNB VPB VPWR Y
.ends

* Black-box entry subcircuit for sky130_fd_sc_hd__o31a_1 abstract view
.subckt sky130_fd_sc_hd__o31a_1 A1 A2 A3 B1 VGND VNB VPB VPWR X
.ends

* Black-box entry subcircuit for sky130_fd_sc_hd__o211a_1 abstract view
.subckt sky130_fd_sc_hd__o211a_1 A1 A2 B1 C1 VGND VNB VPB VPWR X
.ends

* Black-box entry subcircuit for sky130_fd_sc_hd__clkbuf_4 abstract view
.subckt sky130_fd_sc_hd__clkbuf_4 A VGND VNB VPB VPWR X
.ends

* Black-box entry subcircuit for sky130_fd_sc_hd__inv_8 abstract view
.subckt sky130_fd_sc_hd__inv_8 A VGND VNB VPB VPWR Y
.ends

* Black-box entry subcircuit for sky130_fd_sc_hd__or3b_2 abstract view
.subckt sky130_fd_sc_hd__or3b_2 A B C_N VGND VNB VPB VPWR X
.ends

* Black-box entry subcircuit for sky130_fd_sc_hd__or4b_1 abstract view
.subckt sky130_fd_sc_hd__or4b_1 A B C D_N VGND VNB VPB VPWR X
.ends

* Black-box entry subcircuit for sky130_fd_sc_hd__or2_2 abstract view
.subckt sky130_fd_sc_hd__or2_2 A B VGND VNB VPB VPWR X
.ends

* Black-box entry subcircuit for sky130_fd_sc_hd__o41ai_1 abstract view
.subckt sky130_fd_sc_hd__o41ai_1 A1 A2 A3 A4 B1 VGND VNB VPB VPWR Y
.ends

* Black-box entry subcircuit for sky130_fd_sc_hd__and4b_1 abstract view
.subckt sky130_fd_sc_hd__and4b_1 A_N B C D VGND VNB VPB VPWR X
.ends

* Black-box entry subcircuit for sky130_fd_sc_hd__nor2_4 abstract view
.subckt sky130_fd_sc_hd__nor2_4 A B VGND VNB VPB VPWR Y
.ends

* Black-box entry subcircuit for sky130_fd_sc_hd__a2111oi_1 abstract view
.subckt sky130_fd_sc_hd__a2111oi_1 A1 A2 B1 C1 D1 VGND VNB VPB VPWR Y
.ends

* Black-box entry subcircuit for sky130_fd_sc_hd__clkbuf_2 abstract view
.subckt sky130_fd_sc_hd__clkbuf_2 A VGND VNB VPB VPWR X
.ends

* Black-box entry subcircuit for sky130_fd_sc_hd__nor3_1 abstract view
.subckt sky130_fd_sc_hd__nor3_1 A B C VGND VNB VPB VPWR Y
.ends

* Black-box entry subcircuit for sky130_fd_sc_hd__nor4_1 abstract view
.subckt sky130_fd_sc_hd__nor4_1 A B C D VGND VNB VPB VPWR Y
.ends

* Black-box entry subcircuit for sky130_fd_sc_hd__a22oi_1 abstract view
.subckt sky130_fd_sc_hd__a22oi_1 A1 A2 B1 B2 VGND VNB VPB VPWR Y
.ends

* Black-box entry subcircuit for sky130_fd_sc_hd__nand2_2 abstract view
.subckt sky130_fd_sc_hd__nand2_2 A B VGND VNB VPB VPWR Y
.ends

* Black-box entry subcircuit for sky130_fd_sc_hd__a2111o_1 abstract view
.subckt sky130_fd_sc_hd__a2111o_1 A1 A2 B1 C1 D1 VGND VNB VPB VPWR X
.ends

* Black-box entry subcircuit for sky130_fd_sc_hd__or3_1 abstract view
.subckt sky130_fd_sc_hd__or3_1 A B C VGND VNB VPB VPWR X
.ends

* Black-box entry subcircuit for sky130_fd_sc_hd__o311a_1 abstract view
.subckt sky130_fd_sc_hd__o311a_1 A1 A2 A3 B1 C1 VGND VNB VPB VPWR X
.ends

* Black-box entry subcircuit for sky130_fd_sc_hd__o2bb2a_1 abstract view
.subckt sky130_fd_sc_hd__o2bb2a_1 A1_N A2_N B1 B2 VGND VNB VPB VPWR X
.ends

* Black-box entry subcircuit for sky130_fd_sc_hd__o22a_1 abstract view
.subckt sky130_fd_sc_hd__o22a_1 A1 A2 B1 B2 VGND VNB VPB VPWR X
.ends

* Black-box entry subcircuit for sky130_fd_sc_hd__dlymetal6s2s_1 abstract view
.subckt sky130_fd_sc_hd__dlymetal6s2s_1 A VGND VNB VPB VPWR X
.ends

* Black-box entry subcircuit for sky130_fd_sc_hd__buf_1 abstract view
.subckt sky130_fd_sc_hd__buf_1 A VGND VNB VPB VPWR X
.ends

* Black-box entry subcircuit for sky130_fd_sc_hd__o31ai_1 abstract view
.subckt sky130_fd_sc_hd__o31ai_1 A1 A2 A3 B1 VGND VNB VPB VPWR Y
.ends

* Black-box entry subcircuit for sky130_fd_sc_hd__conb_1 abstract view
.subckt sky130_fd_sc_hd__conb_1 VGND VNB VPB VPWR HI LO
.ends

* Black-box entry subcircuit for sky130_fd_sc_hd__a211oi_1 abstract view
.subckt sky130_fd_sc_hd__a211oi_1 A1 A2 B1 C1 VGND VNB VPB VPWR Y
.ends

* Black-box entry subcircuit for sky130_fd_sc_hd__a221o_1 abstract view
.subckt sky130_fd_sc_hd__a221o_1 A1 A2 B1 B2 C1 VGND VNB VPB VPWR X
.ends

* Black-box entry subcircuit for sky130_fd_sc_hd__a31oi_2 abstract view
.subckt sky130_fd_sc_hd__a31oi_2 A1 A2 A3 B1 VGND VNB VPB VPWR Y
.ends

* Black-box entry subcircuit for sky130_fd_sc_hd__a211oi_2 abstract view
.subckt sky130_fd_sc_hd__a211oi_2 A1 A2 B1 C1 VGND VNB VPB VPWR Y
.ends

* Black-box entry subcircuit for sky130_fd_sc_hd__and4bb_2 abstract view
.subckt sky130_fd_sc_hd__and4bb_2 A_N B_N C D VGND VNB VPB VPWR X
.ends

* Black-box entry subcircuit for sky130_fd_sc_hd__or4bb_1 abstract view
.subckt sky130_fd_sc_hd__or4bb_1 A B C_N D_N VGND VNB VPB VPWR X
.ends

* Black-box entry subcircuit for sky130_fd_sc_hd__nor3_2 abstract view
.subckt sky130_fd_sc_hd__nor3_2 A B C VGND VNB VPB VPWR Y
.ends

.subckt team_07 clk en gpio_in[0] gpio_in[10] gpio_in[11] gpio_in[12] gpio_in[13]
+ gpio_in[14] gpio_in[15] gpio_in[16] gpio_in[17] gpio_in[18] gpio_in[19] gpio_in[1]
+ gpio_in[20] gpio_in[21] gpio_in[22] gpio_in[23] gpio_in[24] gpio_in[25] gpio_in[26]
+ gpio_in[27] gpio_in[28] gpio_in[29] gpio_in[2] gpio_in[30] gpio_in[31] gpio_in[32]
+ gpio_in[33] gpio_in[3] gpio_in[4] gpio_in[5] gpio_in[6] gpio_in[7] gpio_in[8] gpio_in[9]
+ gpio_oeb[0] gpio_oeb[10] gpio_oeb[11] gpio_oeb[12] gpio_oeb[13] gpio_oeb[14] gpio_oeb[15]
+ gpio_oeb[16] gpio_oeb[17] gpio_oeb[18] gpio_oeb[19] gpio_oeb[1] gpio_oeb[20] gpio_oeb[21]
+ gpio_oeb[22] gpio_oeb[23] gpio_oeb[24] gpio_oeb[25] gpio_oeb[26] gpio_oeb[27] gpio_oeb[28]
+ gpio_oeb[29] gpio_oeb[2] gpio_oeb[30] gpio_oeb[31] gpio_oeb[32] gpio_oeb[33] gpio_oeb[3]
+ gpio_oeb[4] gpio_oeb[5] gpio_oeb[6] gpio_oeb[7] gpio_oeb[8] gpio_oeb[9] gpio_out[0]
+ gpio_out[10] gpio_out[11] gpio_out[12] gpio_out[13] gpio_out[14] gpio_out[15] gpio_out[16]
+ gpio_out[17] gpio_out[18] gpio_out[19] gpio_out[1] gpio_out[20] gpio_out[21] gpio_out[22]
+ gpio_out[23] gpio_out[24] gpio_out[25] gpio_out[26] gpio_out[27] gpio_out[28] gpio_out[29]
+ gpio_out[2] gpio_out[30] gpio_out[31] gpio_out[32] gpio_out[33] gpio_out[3] gpio_out[4]
+ gpio_out[5] gpio_out[6] gpio_out[7] gpio_out[8] gpio_out[9] nrst vccd1 vssd1
XFILLER_22_177 vssd1 vssd1 vccd1 vccd1 sky130_fd_sc_hd__fill_8
XTAP_TAPCELL_ROW_9_126 vssd1 vccd1 sky130_fd_sc_hd__tapvpwrvgnd_1
XFILLER_13_111 vssd1 vssd1 vccd1 vccd1 sky130_fd_sc_hd__fill_1
XANTENNA_fanout30_X net30 vssd1 vssd1 vccd1 vccd1 sky130_fd_sc_hd__diode_2
XFILLER_9_126 vccd1 vssd1 vccd1 vssd1 sky130_ef_sc_hd__decap_40_12
XFILLER_13_155 vssd1 vssd1 vccd1 vccd1 sky130_fd_sc_hd__fill_1
XFILLER_13_188 vssd1 vssd1 vccd1 vccd1 sky130_fd_sc_hd__fill_1
X_0985_ clknet_3_1__leaf_clk _0031_ net26 vssd1 vssd1 vccd1 vccd1 MATMULT_INST.parallel_out1\[1\]
+ sky130_fd_sc_hd__dfstp_2
XTAP_TAPCELL_ROW_20_175 vssd1 vccd1 sky130_fd_sc_hd__tapvpwrvgnd_1
XFILLER_18_203 vssd1 vssd1 vccd1 vccd1 sky130_fd_sc_hd__fill_1
X_0770_ MATMULT_INST.cntrl.state\[4\] MATMULT_INST.cntrl.state\[0\] _0065_ MATMULT_INST.cntrl.state\[2\]
+ vssd1 vssd1 vccd1 vccd1 _0328_ sky130_fd_sc_hd__or4_1
X_0968_ clknet_3_4__leaf_clk _0014_ net31 vssd1 vssd1 vccd1 vccd1 MATMULT_INST.prod_adder.gen_for_loop\[0\].adder_n.a
+ sky130_fd_sc_hd__dfstp_1
XANTENNA__0952__RESET_B net37 vssd1 vssd1 vccd1 vccd1 sky130_fd_sc_hd__diode_2
X_0899_ _0413_ _0423_ vssd1 vssd1 vccd1 vccd1 _0424_ sky130_fd_sc_hd__xnor2_1
XFILLER_15_239 vssd1 vssd1 vccd1 vccd1 sky130_fd_sc_hd__fill_8
XFILLER_23_250 vssd1 vssd1 vccd1 vccd1 sky130_fd_sc_hd__fill_2
XFILLER_0_57 vssd1 vssd1 vccd1 vccd1 sky130_fd_sc_hd__fill_2
XFILLER_9_88 vccd1 vssd1 vccd1 vssd1 sky130_ef_sc_hd__decap_40_12
X_0822_ _0330_ _0366_ vssd1 vssd1 vccd1 vccd1 _0374_ sky130_fd_sc_hd__nor2_1
X_0684_ MATMULT_INST.uart_rcv.control.packet_done _0202_ _0259_ vssd1 vssd1 vccd1
+ vccd1 MATMULT_INST.uart_rcv.control.next_state\[0\] sky130_fd_sc_hd__a21bo_1
X_0753_ _0100_ _0103_ _0323_ vssd1 vssd1 vccd1 vccd1 _0324_ sky130_fd_sc_hd__a21o_1
XFILLER_12_209 vssd1 vssd1 vccd1 vccd1 sky130_fd_sc_hd__fill_4
XFILLER_20_253 vssd1 vssd1 vccd1 vccd1 sky130_fd_sc_hd__fill_2
XPHY_EDGE_ROW_8_Left_47 vssd1 vssd1 vccd1 vccd1 sky130_fd_sc_hd__decap_3
XFILLER_18_42 vccd1 vssd1 vccd1 vssd1 sky130_ef_sc_hd__decap_40_12
XFILLER_34_85 vssd1 vssd1 vccd1 vccd1 sky130_fd_sc_hd__fill_8
XFILLER_11_220 vssd1 vssd1 vccd1 vccd1 sky130_fd_sc_hd__fill_4
XFILLER_11_253 vssd1 vssd1 vccd1 vccd1 sky130_fd_sc_hd__fill_2
XFILLER_38_139 vssd1 vssd1 vccd1 vccd1 sky130_fd_sc_hd__fill_1
XFILLER_38_117 vssd1 vssd1 vccd1 vccd1 sky130_fd_sc_hd__fill_2
XANTENNA__0767__S net24 vssd1 vssd1 vccd1 vccd1 sky130_fd_sc_hd__diode_2
X_1021_ clknet_3_4__leaf_clk _0044_ net31 vssd1 vssd1 vccd1 vccd1 MATMULT_INST.prod_adder.gen_for_loop\[0\].adder_n.b
+ sky130_fd_sc_hd__dfstp_1
X_0805_ _0357_ _0358_ vssd1 vssd1 vccd1 vccd1 _0359_ sky130_fd_sc_hd__xnor2_1
X_0667_ _0069_ MATMULT_INST.uart_rcv.tim.clock_count.next_cnt_out\[1\] _0243_ _0244_
+ vssd1 vssd1 vccd1 vccd1 _0245_ sky130_fd_sc_hd__o211ai_1
X_0736_ _0271_ _0308_ _0309_ _0304_ _0306_ vssd1 vssd1 vccd1 vccd1 _0310_ sky130_fd_sc_hd__a32o_1
X_0598_ _0068_ MATMULT_INST.uart_rcv.tim.clk_cnt\[0\] _0180_ _0187_ _0189_ vssd1 vssd1
+ vccd1 vccd1 _0190_ sky130_fd_sc_hd__o2111a_1
XFILLER_4_238 vssd1 vssd1 vccd1 vccd1 sky130_fd_sc_hd__fill_8
XFILLER_29_30 vssd1 vssd1 vccd1 vccd1 sky130_fd_sc_hd__fill_2
XFILLER_29_52 vssd1 vssd1 vccd1 vccd1 sky130_fd_sc_hd__fill_4
XANTENNA_input18_A nrst vssd1 vssd1 vccd1 vccd1 sky130_fd_sc_hd__diode_2
XFILLER_6_45 vssd1 vssd1 vccd1 vccd1 sky130_fd_sc_hd__fill_2
X_0452_ MATMULT_INST.cntrl.state\[3\] vssd1 vssd1 vccd1 vccd1 _0065_ sky130_fd_sc_hd__inv_2
X_0521_ _0123_ net23 _0104_ vssd1 vssd1 vccd1 vccd1 _0128_ sky130_fd_sc_hd__a21boi_2
XFILLER_13_3 vccd1 vssd1 vccd1 vssd1 sky130_ef_sc_hd__decap_40_12
XFILLER_34_197 vssd1 vssd1 vccd1 vccd1 sky130_fd_sc_hd__fill_4
X_1004_ clknet_3_2__leaf_clk MATMULT_INST.uart_rcv.tim.clock_count.next_cnt_out\[2\]
+ net29 vssd1 vssd1 vccd1 vccd1 MATMULT_INST.uart_rcv.tim.clk_cnt\[2\] sky130_fd_sc_hd__dfrtp_1
X_0719_ _0284_ _0285_ _0291_ _0292_ _0289_ vssd1 vssd1 vccd1 vccd1 _0293_ sky130_fd_sc_hd__o221a_1
XFILLER_15_87 vssd1 vssd1 vccd1 vccd1 sky130_fd_sc_hd__fill_1
XFILLER_0_230 vssd1 vssd1 vccd1 vccd1 sky130_fd_sc_hd__fill_4
Xoutput20 net20 vssd1 vssd1 vccd1 vccd1 gpio_out[17] sky130_fd_sc_hd__buf_2
XFILLER_31_75 vssd1 vssd1 vccd1 vccd1 sky130_fd_sc_hd__fill_2
XFILLER_16_197 vssd1 vssd1 vccd1 vccd1 sky130_fd_sc_hd__fill_8
XFILLER_31_101 vssd1 vssd1 vccd1 vccd1 sky130_fd_sc_hd__fill_8
X_0504_ MATMULT_INST.uart_tx.clk_cnt\[11\] net6 vssd1 vssd1 vccd1 vccd1 _0112_ sky130_fd_sc_hd__nand2b_1
XFILLER_22_101 vssd1 vssd1 vccd1 vccd1 sky130_fd_sc_hd__fill_4
XPHY_EDGE_ROW_37_Left_76 vssd1 vssd1 vccd1 vccd1 sky130_fd_sc_hd__decap_3
XFILLER_13_101 vssd1 vssd1 vccd1 vccd1 sky130_fd_sc_hd__fill_1
XFILLER_13_123 vssd1 vssd1 vccd1 vccd1 sky130_fd_sc_hd__fill_1
XFILLER_13_167 vssd1 vssd1 vccd1 vccd1 sky130_fd_sc_hd__fill_1
XFILLER_26_64 vccd1 vssd1 vccd1 vssd1 sky130_ef_sc_hd__decap_40_12
Xclkbuf_3_6__f_clk clknet_0_clk vssd1 vssd1 vccd1 vccd1 clknet_3_6__leaf_clk sky130_fd_sc_hd__clkbuf_16
XFILLER_3_57 vccd1 vssd1 vccd1 vssd1 sky130_ef_sc_hd__decap_40_12
XFILLER_36_237 vssd1 vssd1 vccd1 vccd1 sky130_fd_sc_hd__fill_8
X_0984_ clknet_3_1__leaf_clk _0030_ net26 vssd1 vssd1 vccd1 vccd1 MATMULT_INST.parallel_out1\[0\]
+ sky130_fd_sc_hd__dfstp_1
XFILLER_10_137 vssd1 vssd1 vccd1 vccd1 sky130_fd_sc_hd__fill_2
XTAP_TAPCELL_ROW_20_176 vssd1 vccd1 sky130_fd_sc_hd__tapvpwrvgnd_1
XTAP_TAPCELL_ROW_28_210 vssd1 vccd1 sky130_fd_sc_hd__tapvpwrvgnd_1
XTAP_TAPCELL_ROW_11_132 vssd1 vccd1 sky130_fd_sc_hd__tapvpwrvgnd_1
XTAP_TAPCELL_ROW_34_235 vssd1 vccd1 sky130_fd_sc_hd__tapvpwrvgnd_1
X_0967_ clknet_3_7__leaf_clk _0013_ net34 vssd1 vssd1 vccd1 vccd1 MATMULT_INST.uart_rcv.sbc.stop_bit
+ sky130_fd_sc_hd__dfstp_1
X_0898_ _0408_ _0409_ _0410_ vssd1 vssd1 vccd1 vccd1 _0423_ sky130_fd_sc_hd__o21ba_1
XPHY_EDGE_ROW_12_Right_12 vssd1 vssd1 vccd1 vccd1 sky130_fd_sc_hd__decap_3
XPHY_EDGE_ROW_21_Right_21 vssd1 vssd1 vccd1 vccd1 sky130_fd_sc_hd__decap_3
XFILLER_2_111 vssd1 vssd1 vccd1 vccd1 sky130_fd_sc_hd__fill_2
XPHY_EDGE_ROW_30_Right_30 vssd1 vssd1 vccd1 vccd1 sky130_fd_sc_hd__decap_3
XFILLER_0_69 vssd1 vssd1 vccd1 vccd1 sky130_fd_sc_hd__fill_4
XFILLER_9_23 vssd1 vssd1 vccd1 vccd1 sky130_fd_sc_hd__fill_1
X_0752_ MATMULT_INST.uart_tx.count.roflag_ff MATMULT_INST.uart_tx.tx_ctrl.state\[0\]
+ _0102_ _0322_ vssd1 vssd1 vccd1 vccd1 _0323_ sky130_fd_sc_hd__and4bb_1
X_0821_ MATMULT_INST.parallel_out1\[7\] MATMULT_INST.parallel_out1\[3\] _0368_ _0369_
+ vssd1 vssd1 vccd1 vccd1 _0373_ sky130_fd_sc_hd__nand4_1
XPHY_EDGE_ROW_24_Left_63 vssd1 vssd1 vccd1 vccd1 sky130_fd_sc_hd__decap_3
X_0683_ _0257_ _0258_ MATMULT_INST.uart_rcv.control.state\[1\] MATMULT_INST.uart_rcv.control.state\[0\]
+ vssd1 vssd1 vccd1 vccd1 _0259_ sky130_fd_sc_hd__a211o_1
XFILLER_18_54 vssd1 vssd1 vccd1 vccd1 sky130_fd_sc_hd__fill_1
XFILLER_7_203 vccd1 vssd1 vccd1 vssd1 sky130_ef_sc_hd__decap_40_12
X_1020_ clknet_3_7__leaf_clk net114 net35 vssd1 vssd1 vccd1 vccd1 MATMULT_INST.uart_rcv.control.state\[2\]
+ sky130_fd_sc_hd__dfrtp_1
X_0735_ MATMULT_INST.prod_adder.gen_for_loop\[0\].adder_n.b MATMULT_INST.prod_adder.gen_for_loop\[0\].adder_n.a
+ vssd1 vssd1 vccd1 vccd1 _0309_ sky130_fd_sc_hd__or2_1
X_0804_ MATMULT_INST.parallel_out1\[5\] MATMULT_INST.parallel_out1\[3\] vssd1 vssd1
+ vccd1 vccd1 _0358_ sky130_fd_sc_hd__nand2_1
X_0666_ net13 MATMULT_INST.uart_rcv.tim.clock_count.next_cnt_out\[3\] vssd1 vssd1
+ vccd1 vccd1 _0244_ sky130_fd_sc_hd__xnor2_1
X_0597_ net12 MATMULT_INST.uart_rcv.tim.clk_cnt\[2\] vssd1 vssd1 vccd1 vccd1 _0189_
+ sky130_fd_sc_hd__nand2b_1
XFILLER_20_33 vssd1 vssd1 vccd1 vccd1 sky130_fd_sc_hd__fill_2
Xhold20 MATMULT_INST.prod_adder.gen_for_loop\[0\].adder_n.a vssd1 vssd1 vccd1 vccd1
+ net123 sky130_fd_sc_hd__dlygate4sd3_1
XFILLER_29_64 vssd1 vssd1 vccd1 vccd1 sky130_fd_sc_hd__fill_4
XFILLER_29_75 vccd1 vssd1 vccd1 vssd1 sky130_ef_sc_hd__decap_40_12
XFILLER_29_97 vssd1 vssd1 vccd1 vccd1 sky130_fd_sc_hd__fill_1
XFILLER_28_184 vssd1 vssd1 vccd1 vccd1 sky130_fd_sc_hd__fill_1
X_0451_ MATMULT_INST.cntrl.state\[1\] vssd1 vssd1 vccd1 vccd1 _0064_ sky130_fd_sc_hd__inv_2
X_0520_ MATMULT_INST.uart_tx.clk_cnt\[0\] _0127_ _0104_ vssd1 vssd1 vccd1 vccd1 MATMULT_INST.uart_tx.count.next_cnt_out\[0\]
+ sky130_fd_sc_hd__a21boi_1
XFILLER_19_140 vssd1 vssd1 vccd1 vccd1 sky130_fd_sc_hd__fill_1
XFILLER_19_195 vssd1 vssd1 vccd1 vccd1 sky130_fd_sc_hd__fill_4
X_1003_ clknet_3_2__leaf_clk MATMULT_INST.uart_rcv.tim.clock_count.next_cnt_out\[1\]
+ net29 vssd1 vssd1 vccd1 vccd1 MATMULT_INST.uart_rcv.tim.clk_cnt\[1\] sky130_fd_sc_hd__dfrtp_1
X_0718_ _0082_ _0290_ vssd1 vssd1 vccd1 vccd1 _0292_ sky130_fd_sc_hd__xnor2_1
XPHY_EDGE_ROW_6_Right_6 vssd1 vssd1 vccd1 vccd1 sky130_fd_sc_hd__decap_3
X_0649_ MATMULT_INST.uart_rcv.tim.clk_cnt\[11\] MATMULT_INST.uart_rcv.tim.clk_cnt\[12\]
+ _0226_ vssd1 vssd1 vccd1 vccd1 _0229_ sky130_fd_sc_hd__and3_1
XPHY_EDGE_ROW_11_Left_50 vssd1 vssd1 vccd1 vccd1 sky130_fd_sc_hd__decap_3
XFILLER_15_55 vssd1 vssd1 vccd1 vccd1 sky130_fd_sc_hd__fill_1
XFILLER_0_253 vssd1 vssd1 vccd1 vccd1 sky130_fd_sc_hd__fill_2
XFILLER_31_146 vssd1 vssd1 vccd1 vccd1 sky130_fd_sc_hd__fill_2
X_0503_ net8 MATMULT_INST.uart_tx.clk_cnt\[13\] vssd1 vssd1 vccd1 vccd1 _0111_ sky130_fd_sc_hd__nand2b_1
XTAP_TAPCELL_ROW_17_160 vssd1 vccd1 sky130_fd_sc_hd__tapvpwrvgnd_1
XFILLER_26_76 vssd1 vssd1 vccd1 vccd1 sky130_fd_sc_hd__fill_1
XFILLER_3_69 vssd1 vssd1 vccd1 vccd1 sky130_fd_sc_hd__fill_8
X_0983_ clknet_3_1__leaf_clk _0029_ net27 vssd1 vssd1 vccd1 vccd1 MATMULT_INST.parallel_out2\[7\]
+ sky130_fd_sc_hd__dfstp_1
XTAP_TAPCELL_ROW_6_109 vssd1 vccd1 sky130_fd_sc_hd__tapvpwrvgnd_1
XFILLER_5_6 vccd1 vssd1 vccd1 vssd1 sky130_ef_sc_hd__decap_40_12
XFILLER_37_97 vssd1 vssd1 vccd1 vccd1 sky130_fd_sc_hd__fill_1
XTAP_TAPCELL_ROW_28_211 vssd1 vccd1 sky130_fd_sc_hd__tapvpwrvgnd_1
XTAP_TAPCELL_ROW_11_133 vssd1 vccd1 sky130_fd_sc_hd__tapvpwrvgnd_1
XFILLER_5_164 vssd1 vssd1 vccd1 vccd1 sky130_fd_sc_hd__fill_4
XTAP_TAPCELL_ROW_34_236 vssd1 vccd1 sky130_fd_sc_hd__tapvpwrvgnd_1
X_0897_ _0420_ _0421_ vssd1 vssd1 vccd1 vccd1 _0422_ sky130_fd_sc_hd__nor2_1
X_0966_ clknet_3_7__leaf_clk _0012_ net34 vssd1 vssd1 vccd1 vccd1 MATMULT_INST.uart_rcv.data_buff.packet_data\[7\]
+ sky130_fd_sc_hd__dfstp_1
XFILLER_3_3 vccd1 vssd1 vccd1 vssd1 sky130_ef_sc_hd__decap_40_12
XFILLER_0_48 vssd1 vssd1 vccd1 vccd1 sky130_fd_sc_hd__fill_4
XFILLER_9_57 vssd1 vssd1 vccd1 vccd1 sky130_fd_sc_hd__fill_8
X_0751_ MATMULT_INST.uart_tx.tx_ctrl.state\[1\] MATMULT_INST.uart_tx.tx_ctrl.state\[3\]
+ _0321_ vssd1 vssd1 vccd1 vccd1 _0322_ sky130_fd_sc_hd__o21ai_1
X_0820_ MATMULT_INST.parallel_out1\[7\] MATMULT_INST.parallel_out1\[3\] _0368_ _0369_
+ vssd1 vssd1 vccd1 vccd1 _0372_ sky130_fd_sc_hd__a22o_1
XTAP_TAPCELL_ROW_0_80 vssd1 vccd1 sky130_fd_sc_hd__tapvpwrvgnd_1
X_0682_ MATMULT_INST.uart_rcv.control.state\[2\] MATMULT_INST.uart_rcv.sbd.new_sample
+ MATMULT_INST.uart_rcv.sbd.old_sample vssd1 vssd1 vccd1 vccd1 _0258_ sky130_fd_sc_hd__or3b_1
X_0949_ clknet_3_2__leaf_clk MATMULT_INST.uart_tx.count.next_cnt_out\[4\] net28 vssd1
+ vssd1 vccd1 vccd1 MATMULT_INST.uart_tx.clk_cnt\[4\] sky130_fd_sc_hd__dfrtp_1
XFILLER_18_33 vssd1 vssd1 vccd1 vccd1 sky130_fd_sc_hd__fill_2
XFILLER_7_248 vssd1 vssd1 vccd1 vccd1 sky130_fd_sc_hd__fill_4
XFILLER_38_119 vssd1 vssd1 vccd1 vccd1 sky130_fd_sc_hd__fill_1
X_0665_ net10 MATMULT_INST.uart_rcv.tim.clock_count.next_cnt_out\[0\] vssd1 vssd1
+ vccd1 vccd1 _0243_ sky130_fd_sc_hd__xnor2_1
X_0734_ _0307_ _0298_ vssd1 vssd1 vccd1 vccd1 _0308_ sky130_fd_sc_hd__and2b_1
X_0803_ _0355_ _0356_ vssd1 vssd1 vccd1 vccd1 _0357_ sky130_fd_sc_hd__and2b_1
X_0596_ net16 MATMULT_INST.uart_rcv.tim.clk_cnt\[6\] vssd1 vssd1 vccd1 vccd1 _0188_
+ sky130_fd_sc_hd__nand2b_1
XFILLER_20_78 vssd1 vssd1 vccd1 vccd1 sky130_fd_sc_hd__fill_2
Xhold21 MATMULT_INST.uart_rcv.tim.bit_cnt\[1\] vssd1 vssd1 vccd1 vccd1 net124 sky130_fd_sc_hd__dlygate4sd3_1
XFILLER_29_32 vssd1 vssd1 vccd1 vccd1 sky130_fd_sc_hd__fill_1
XFILLER_29_87 vssd1 vssd1 vccd1 vccd1 sky130_fd_sc_hd__fill_8
Xhold10 MATMULT_INST.uart_rcv.control.state\[0\] vssd1 vssd1 vccd1 vccd1 net113 sky130_fd_sc_hd__dlygate4sd3_1
XANTENNA__1011__RESET_B net30 vssd1 vssd1 vccd1 vccd1 sky130_fd_sc_hd__diode_2
XFILLER_6_58 vssd1 vssd1 vccd1 vccd1 sky130_fd_sc_hd__fill_2
X_0450_ MATMULT_INST.cntrl.state\[0\] vssd1 vssd1 vccd1 vccd1 _0063_ sky130_fd_sc_hd__inv_2
X_1002_ clknet_3_6__leaf_clk MATMULT_INST.uart_rcv.tim.clock_count.next_cnt_out\[0\]
+ net33 vssd1 vssd1 vccd1 vccd1 MATMULT_INST.uart_rcv.tim.clk_cnt\[0\] sky130_fd_sc_hd__dfrtp_1
X_0648_ _0227_ _0228_ vssd1 vssd1 vccd1 vccd1 MATMULT_INST.uart_rcv.tim.clock_count.next_cnt_out\[11\]
+ sky130_fd_sc_hd__nor2_1
X_0717_ MATMULT_INST.uart_tx.tx_ctrl.state\[3\] _0101_ vssd1 vssd1 vccd1 vccd1 _0291_
+ sky130_fd_sc_hd__nand2_1
X_0579_ net7 MATMULT_INST.uart_tx.count.next_cnt_out\[12\] vssd1 vssd1 vccd1 vccd1
+ _0173_ sky130_fd_sc_hd__xnor2_1
XFILLER_15_23 vssd1 vssd1 vccd1 vccd1 sky130_fd_sc_hd__fill_1
XFILLER_15_45 vssd1 vssd1 vccd1 vccd1 sky130_fd_sc_hd__fill_1
XFILLER_31_55 vssd1 vssd1 vccd1 vccd1 sky130_fd_sc_hd__fill_1
XFILLER_31_77 vssd1 vssd1 vccd1 vccd1 sky130_fd_sc_hd__fill_1
XANTENNA_clkbuf_3_1__f_clk_A clknet_0_clk vssd1 vssd1 vccd1 vccd1 sky130_fd_sc_hd__diode_2
XFILLER_31_136 vssd1 vssd1 vccd1 vccd1 sky130_fd_sc_hd__fill_2
X_0502_ MATMULT_INST.uart_tx.clk_cnt\[5\] net15 vssd1 vssd1 vccd1 vccd1 _0110_ sky130_fd_sc_hd__xnor2_1
XTAP_TAPCELL_ROW_17_161 vssd1 vccd1 sky130_fd_sc_hd__tapvpwrvgnd_1
XTAP_TAPCELL_ROW_23_186 vssd1 vccd1 sky130_fd_sc_hd__tapvpwrvgnd_1
XFILLER_3_15 vccd1 vssd1 vccd1 vssd1 sky130_ef_sc_hd__decap_40_12
X_0982_ clknet_3_1__leaf_clk _0028_ net26 vssd1 vssd1 vccd1 vccd1 MATMULT_INST.parallel_out2\[6\]
+ sky130_fd_sc_hd__dfstp_2
XFILLER_10_139 vssd1 vssd1 vccd1 vccd1 sky130_fd_sc_hd__fill_1
XTAP_TAPCELL_ROW_28_212 vssd1 vccd1 sky130_fd_sc_hd__tapvpwrvgnd_1
XFILLER_5_110 vssd1 vssd1 vccd1 vccd1 sky130_fd_sc_hd__fill_2
XTAP_TAPCELL_ROW_11_134 vssd1 vccd1 sky130_fd_sc_hd__tapvpwrvgnd_1
XFILLER_5_198 vssd1 vssd1 vccd1 vccd1 sky130_fd_sc_hd__fill_2
XTAP_TAPCELL_ROW_34_237 vssd1 vccd1 sky130_fd_sc_hd__tapvpwrvgnd_1
XFILLER_32_253 vssd1 vssd1 vccd1 vccd1 sky130_fd_sc_hd__fill_2
X_0896_ MATMULT_INST.parallel_out2\[4\] MATMULT_INST.parallel_out2\[3\] _0419_ vssd1
+ vssd1 vccd1 vccd1 _0421_ sky130_fd_sc_hd__and3_1
X_0965_ clknet_3_3__leaf_clk _0011_ net28 vssd1 vssd1 vccd1 vccd1 MATMULT_INST.uart_rcv.data_buff.packet_data\[6\]
+ sky130_fd_sc_hd__dfstp_1
XFILLER_23_78 vssd1 vssd1 vccd1 vccd1 sky130_fd_sc_hd__fill_1
XFILLER_0_16 vssd1 vssd1 vccd1 vccd1 sky130_fd_sc_hd__fill_1
XFILLER_0_27 vssd1 vssd1 vccd1 vccd1 sky130_fd_sc_hd__fill_1
XFILLER_14_253 vssd1 vssd1 vccd1 vccd1 sky130_fd_sc_hd__fill_2
X_0750_ MATMULT_INST.uart_tx.tx_ctrl.state\[4\] _0284_ _0294_ vssd1 vssd1 vccd1 vccd1
+ _0321_ sky130_fd_sc_hd__and3_1
X_0681_ MATMULT_INST.cntrl.framing_error MATMULT_INST.uart_rcv.control.state\[2\]
+ vssd1 vssd1 vccd1 vccd1 _0257_ sky130_fd_sc_hd__nand2b_1
XTAP_TAPCELL_ROW_0_81 vssd1 vccd1 sky130_fd_sc_hd__tapvpwrvgnd_1
XFILLER_1_190 vccd1 vssd1 vccd1 vssd1 sky130_ef_sc_hd__decap_40_12
X_0948_ clknet_3_3__leaf_clk MATMULT_INST.uart_tx.count.next_cnt_out\[3\] net28 vssd1
+ vssd1 vccd1 vccd1 MATMULT_INST.uart_tx.clk_cnt\[3\] sky130_fd_sc_hd__dfrtp_1
X_0879_ _0404_ _0405_ vssd1 vssd1 vccd1 vccd1 _0406_ sky130_fd_sc_hd__and2_1
XANTENNA_fanout36_A net37 vssd1 vssd1 vccd1 vccd1 sky130_fd_sc_hd__diode_2
X_0802_ MATMULT_INST.parallel_out1\[6\] MATMULT_INST.parallel_out1\[2\] MATMULT_INST.parallel_out1\[7\]
+ MATMULT_INST.parallel_out1\[1\] vssd1 vssd1 vccd1 vccd1 _0356_ sky130_fd_sc_hd__a22o_1
X_0664_ _0213_ net14 _0069_ MATMULT_INST.uart_rcv.tim.clock_count.next_cnt_out\[1\]
+ vssd1 vssd1 vccd1 vccd1 _0242_ sky130_fd_sc_hd__a2bb2o_1
X_0733_ _0261_ _0262_ MATMULT_INST.uart_tx.tx_ctrl.state\[2\] vssd1 vssd1 vccd1 vccd1
+ _0307_ sky130_fd_sc_hd__mux2_1
XFILLER_37_131 vssd1 vssd1 vccd1 vccd1 sky130_fd_sc_hd__fill_2
X_0595_ net3 MATMULT_INST.uart_rcv.tim.clk_cnt\[8\] vssd1 vssd1 vccd1 vccd1 _0187_
+ sky130_fd_sc_hd__nand2b_1
XFILLER_1_81 vccd1 vssd1 vccd1 vssd1 sky130_ef_sc_hd__decap_40_12
XFILLER_20_13 vccd1 vssd1 vccd1 vssd1 sky130_ef_sc_hd__decap_40_12
Xhold11 MATMULT_INST.uart_rcv.control.next_state\[2\] vssd1 vssd1 vccd1 vccd1 net114
+ sky130_fd_sc_hd__dlygate4sd3_1
XFILLER_20_35 vssd1 vssd1 vccd1 vccd1 sky130_fd_sc_hd__fill_1
Xhold22 MATMULT_INST.cntrl.state\[4\] vssd1 vssd1 vccd1 vccd1 net125 sky130_fd_sc_hd__dlygate4sd3_1
XFILLER_28_197 vssd1 vssd1 vccd1 vccd1 sky130_fd_sc_hd__fill_2
XFILLER_6_26 vssd1 vssd1 vccd1 vccd1 sky130_fd_sc_hd__fill_2
X_1001_ clknet_3_7__leaf_clk MATMULT_INST.uart_rcv.tim.bit_count.next_roflag net35
+ vssd1 vssd1 vccd1 vccd1 MATMULT_INST.uart_rcv.control.packet_done sky130_fd_sc_hd__dfrtp_4
X_0647_ MATMULT_INST.uart_rcv.tim.clk_cnt\[11\] _0226_ _0205_ vssd1 vssd1 vccd1 vccd1
+ _0228_ sky130_fd_sc_hd__o21ai_1
X_0716_ _0276_ _0277_ vssd1 vssd1 vccd1 vccd1 _0290_ sky130_fd_sc_hd__nand2_1
X_0578_ net8 _0155_ vssd1 vssd1 vccd1 vccd1 _0172_ sky130_fd_sc_hd__or2_1
XFILLER_25_167 vssd1 vssd1 vccd1 vccd1 sky130_fd_sc_hd__fill_1
XANTENNA_input16_A gpio_in[8] vssd1 vssd1 vccd1 vccd1 sky130_fd_sc_hd__diode_2
X_0501_ net16 MATMULT_INST.uart_tx.clk_cnt\[6\] vssd1 vssd1 vccd1 vccd1 _0109_ sky130_fd_sc_hd__and2b_1
XFILLER_11_3 vccd1 vssd1 vccd1 vssd1 sky130_ef_sc_hd__decap_40_12
XTAP_TAPCELL_ROW_17_162 vssd1 vccd1 sky130_fd_sc_hd__tapvpwrvgnd_1
XFILLER_22_137 vssd1 vssd1 vccd1 vccd1 sky130_fd_sc_hd__fill_2
XANTENNA_input8_A gpio_in[15] vssd1 vssd1 vccd1 vccd1 sky130_fd_sc_hd__diode_2
XFILLER_13_115 vssd1 vssd1 vccd1 vccd1 sky130_fd_sc_hd__fill_8
XTAP_TAPCELL_ROW_23_187 vssd1 vccd1 sky130_fd_sc_hd__tapvpwrvgnd_1
XFILLER_3_27 vccd1 vssd1 vccd1 vssd1 sky130_ef_sc_hd__decap_40_12
X_0981_ clknet_3_1__leaf_clk _0027_ net25 vssd1 vssd1 vccd1 vccd1 MATMULT_INST.parallel_out2\[5\]
+ sky130_fd_sc_hd__dfstp_1
XFILLER_5_155 vssd1 vssd1 vccd1 vccd1 sky130_fd_sc_hd__fill_1
XTAP_TAPCELL_ROW_11_135 vssd1 vccd1 sky130_fd_sc_hd__tapvpwrvgnd_1
XTAP_TAPCELL_ROW_34_238 vssd1 vccd1 sky130_fd_sc_hd__tapvpwrvgnd_1
X_0964_ clknet_3_2__leaf_clk _0010_ net28 vssd1 vssd1 vccd1 vccd1 MATMULT_INST.uart_rcv.data_buff.packet_data\[5\]
+ sky130_fd_sc_hd__dfstp_1
X_0895_ MATMULT_INST.parallel_out2\[4\] MATMULT_INST.parallel_out2\[3\] _0419_ vssd1
+ vssd1 vccd1 vccd1 _0420_ sky130_fd_sc_hd__a21oi_1
XFILLER_4_81 vssd1 vssd1 vccd1 vccd1 sky130_fd_sc_hd__fill_2
XFILLER_23_221 vssd1 vssd1 vccd1 vccd1 sky130_fd_sc_hd__fill_2
XFILLER_23_57 vssd1 vssd1 vccd1 vccd1 sky130_fd_sc_hd__fill_1
XFILLER_9_15 vssd1 vssd1 vccd1 vccd1 sky130_fd_sc_hd__fill_8
X_0680_ net119 _0256_ _0202_ vssd1 vssd1 vccd1 vccd1 MATMULT_INST.uart_rcv.control.next_state\[1\]
+ sky130_fd_sc_hd__o21bai_1
XTAP_TAPCELL_ROW_0_82 vssd1 vccd1 sky130_fd_sc_hd__tapvpwrvgnd_1
XANTENNA__1028__SET_B net37 vssd1 vssd1 vccd1 vccd1 sky130_fd_sc_hd__diode_2
X_0947_ clknet_3_2__leaf_clk MATMULT_INST.uart_tx.count.next_cnt_out\[2\] net28 vssd1
+ vssd1 vccd1 vccd1 MATMULT_INST.uart_tx.clk_cnt\[2\] sky130_fd_sc_hd__dfrtp_1
X_0878_ MATMULT_INST.parallel_out2\[0\] MATMULT_INST.parallel_out2\[5\] MATMULT_INST.parallel_out2\[1\]
+ MATMULT_INST.parallel_out2\[4\] vssd1 vssd1 vccd1 vccd1 _0405_ sky130_fd_sc_hd__a22o_1
XFILLER_18_35 vssd1 vssd1 vccd1 vccd1 sky130_fd_sc_hd__fill_1
XFILLER_18_57 vssd1 vssd1 vccd1 vccd1 sky130_fd_sc_hd__fill_4
XANTENNA_fanout29_A net30 vssd1 vssd1 vccd1 vccd1 sky130_fd_sc_hd__diode_2
Xclkload0 clknet_3_0__leaf_clk vssd1 vssd1 vccd1 vccd1 clkload0/Y sky130_fd_sc_hd__inv_6
XPHY_EDGE_ROW_28_Left_67 vssd1 vssd1 vccd1 vccd1 sky130_fd_sc_hd__decap_3
X_0801_ MATMULT_INST.parallel_out1\[1\] MATMULT_INST.parallel_out1\[6\] MATMULT_INST.parallel_out1\[2\]
+ MATMULT_INST.parallel_out1\[7\] vssd1 vssd1 vccd1 vccd1 _0355_ sky130_fd_sc_hd__and4_1
X_0663_ net16 MATMULT_INST.uart_rcv.tim.clock_count.next_cnt_out\[6\] vssd1 vssd1
+ vccd1 vccd1 _0241_ sky130_fd_sc_hd__xor2_1
X_0732_ _0271_ _0305_ vssd1 vssd1 vccd1 vccd1 _0306_ sky130_fd_sc_hd__xnor2_1
X_0594_ net11 MATMULT_INST.uart_rcv.tim.clk_cnt\[1\] vssd1 vssd1 vccd1 vccd1 _0186_
+ sky130_fd_sc_hd__nand2b_1
XFILLER_1_93 vssd1 vssd1 vccd1 vccd1 sky130_fd_sc_hd__fill_8
XFILLER_4_209 vssd1 vssd1 vccd1 vccd1 sky130_fd_sc_hd__fill_8
XFILLER_20_25 vssd1 vssd1 vccd1 vccd1 sky130_fd_sc_hd__fill_2
Xhold23 MATMULT_INST.prod_adder.gen_for_loop\[3\].adder_n.a vssd1 vssd1 vccd1 vccd1
+ net126 sky130_fd_sc_hd__dlygate4sd3_1
Xhold12 MATMULT_INST.uart_tx.tx_ctrl.state\[0\] vssd1 vssd1 vccd1 vccd1 net115 sky130_fd_sc_hd__dlygate4sd3_1
XFILLER_3_253 vssd1 vssd1 vccd1 vccd1 sky130_fd_sc_hd__fill_2
XFILLER_3_220 vssd1 vssd1 vccd1 vccd1 sky130_fd_sc_hd__fill_4
X_1000_ clknet_3_7__leaf_clk MATMULT_INST.uart_rcv.tim.bit_count.next_cnt_out\[3\]
+ net35 vssd1 vssd1 vccd1 vccd1 MATMULT_INST.uart_rcv.tim.bit_cnt\[3\] sky130_fd_sc_hd__dfrtp_1
X_0715_ _0286_ _0288_ vssd1 vssd1 vccd1 vccd1 _0289_ sky130_fd_sc_hd__or2_1
XANTENNA_clkbuf_0_clk_A clk vssd1 vssd1 vccd1 vccd1 sky130_fd_sc_hd__diode_2
X_0646_ MATMULT_INST.uart_rcv.tim.clk_cnt\[11\] _0226_ vssd1 vssd1 vccd1 vccd1 _0227_
+ sky130_fd_sc_hd__and2_1
X_0577_ net8 _0155_ vssd1 vssd1 vccd1 vccd1 _0171_ sky130_fd_sc_hd__nand2_1
XFILLER_25_113 vssd1 vssd1 vccd1 vccd1 sky130_fd_sc_hd__fill_4
XFILLER_31_57 vssd1 vssd1 vccd1 vccd1 sky130_fd_sc_hd__fill_8
XFILLER_0_223 vssd1 vssd1 vccd1 vccd1 sky130_fd_sc_hd__fill_1
XFILLER_16_113 vccd1 vssd1 vccd1 vssd1 sky130_ef_sc_hd__decap_40_12
XFILLER_16_146 vccd1 vssd1 vccd1 vssd1 sky130_ef_sc_hd__decap_40_12
XPHY_EDGE_ROW_19_Right_19 vssd1 vssd1 vccd1 vccd1 sky130_fd_sc_hd__decap_3
XFILLER_31_116 vssd1 vssd1 vccd1 vccd1 sky130_fd_sc_hd__fill_1
XFILLER_31_138 vssd1 vssd1 vccd1 vccd1 sky130_fd_sc_hd__fill_1
Xclkbuf_3_1__f_clk clknet_0_clk vssd1 vssd1 vccd1 vccd1 clknet_3_1__leaf_clk sky130_fd_sc_hd__clkbuf_16
X_0500_ net13 MATMULT_INST.uart_tx.clk_cnt\[3\] vssd1 vssd1 vccd1 vccd1 _0108_ sky130_fd_sc_hd__and2b_1
XPHY_EDGE_ROW_28_Right_28 vssd1 vssd1 vccd1 vccd1 sky130_fd_sc_hd__decap_3
XPHY_EDGE_ROW_37_Right_37 vssd1 vssd1 vccd1 vccd1 sky130_fd_sc_hd__decap_3
XFILLER_22_105 vssd1 vssd1 vccd1 vccd1 sky130_fd_sc_hd__fill_2
XPHY_EDGE_ROW_15_Left_54 vssd1 vssd1 vccd1 vccd1 sky130_fd_sc_hd__decap_3
X_0629_ _0214_ _0215_ net21 vssd1 vssd1 vccd1 vccd1 _0216_ sky130_fd_sc_hd__or3b_1
XFILLER_21_193 vssd1 vssd1 vccd1 vccd1 sky130_fd_sc_hd__fill_4
XTAP_TAPCELL_ROW_23_188 vssd1 vccd1 sky130_fd_sc_hd__tapvpwrvgnd_1
XFILLER_3_39 vccd1 vssd1 vccd1 vssd1 sky130_ef_sc_hd__decap_40_12
XTAP_TAPCELL_ROW_8_120 vssd1 vccd1 sky130_fd_sc_hd__tapvpwrvgnd_1
X_0980_ clknet_3_1__leaf_clk _0026_ net26 vssd1 vssd1 vccd1 vccd1 MATMULT_INST.parallel_out2\[4\]
+ sky130_fd_sc_hd__dfstp_1
XFILLER_8_120 vccd1 vssd1 vccd1 vssd1 sky130_ef_sc_hd__decap_40_12
XFILLER_12_160 vssd1 vssd1 vccd1 vccd1 sky130_fd_sc_hd__fill_1
XFILLER_12_15 vccd1 vssd1 vccd1 vssd1 sky130_ef_sc_hd__decap_40_12
XPHY_EDGE_ROW_0_Left_39 vssd1 vssd1 vccd1 vccd1 sky130_fd_sc_hd__decap_3
XFILLER_37_89 vssd1 vssd1 vccd1 vccd1 sky130_fd_sc_hd__fill_1
XTAP_TAPCELL_ROW_34_239 vssd1 vccd1 sky130_fd_sc_hd__tapvpwrvgnd_1
X_0894_ _0415_ _0418_ vssd1 vssd1 vccd1 vccd1 _0419_ sky130_fd_sc_hd__xnor2_1
X_0963_ clknet_3_0__leaf_clk _0009_ net27 vssd1 vssd1 vccd1 vccd1 MATMULT_INST.uart_rcv.data_buff.packet_data\[4\]
+ sky130_fd_sc_hd__dfstp_1
XFILLER_23_36 vccd1 vssd1 vccd1 vssd1 sky130_ef_sc_hd__decap_40_12
XFILLER_2_137 vssd1 vssd1 vccd1 vccd1 sky130_fd_sc_hd__fill_2
XFILLER_2_126 vssd1 vssd1 vccd1 vccd1 sky130_fd_sc_hd__fill_2
XFILLER_0_29 vssd1 vssd1 vccd1 vccd1 sky130_fd_sc_hd__fill_2
XTAP_TAPCELL_ROW_0_83 vssd1 vccd1 sky130_fd_sc_hd__tapvpwrvgnd_1
X_0877_ MATMULT_INST.parallel_out2\[5\] MATMULT_INST.parallel_out2\[1\] _0403_ vssd1
+ vssd1 vccd1 vccd1 _0404_ sky130_fd_sc_hd__nand3_1
X_0946_ clknet_3_2__leaf_clk MATMULT_INST.uart_tx.count.next_cnt_out\[1\] net29 vssd1
+ vssd1 vccd1 vccd1 MATMULT_INST.uart_tx.clk_cnt\[1\] sky130_fd_sc_hd__dfrtp_1
XTAP_TAPCELL_ROW_30_220 vssd1 vccd1 sky130_fd_sc_hd__tapvpwrvgnd_1
XFILLER_34_57 vssd1 vssd1 vccd1 vccd1 sky130_fd_sc_hd__fill_2
Xclkload1 clknet_3_1__leaf_clk vssd1 vssd1 vccd1 vccd1 clkload1/Y sky130_fd_sc_hd__clkinv_2
XPHY_EDGE_ROW_3_Left_42 vssd1 vssd1 vccd1 vccd1 sky130_fd_sc_hd__decap_3
X_0731_ _0269_ _0270_ vssd1 vssd1 vccd1 vccd1 _0305_ sky130_fd_sc_hd__nor2_1
XFILLER_6_251 vssd1 vssd1 vccd1 vccd1 sky130_fd_sc_hd__fill_1
X_0800_ net126 _0330_ _0353_ _0354_ vssd1 vssd1 vccd1 vccd1 _0017_ sky130_fd_sc_hd__a22o_1
X_0662_ _0237_ _0238_ _0239_ vssd1 vssd1 vccd1 vccd1 _0240_ sky130_fd_sc_hd__and3_1
X_0593_ net7 MATMULT_INST.uart_rcv.tim.clk_cnt\[12\] vssd1 vssd1 vccd1 vccd1 _0185_
+ sky130_fd_sc_hd__nand2b_1
XFILLER_37_111 vssd1 vssd1 vccd1 vccd1 sky130_fd_sc_hd__fill_1
X_0929_ MATMULT_INST.cntrl.data_read _0448_ vssd1 vssd1 vccd1 vccd1 _0052_ sky130_fd_sc_hd__nor2_1
Xhold13 MATMULT_INST.cntrl.framing_error vssd1 vssd1 vccd1 vccd1 net116 sky130_fd_sc_hd__dlygate4sd3_1
XFILLER_29_68 vssd1 vssd1 vccd1 vccd1 sky130_fd_sc_hd__fill_1
XFILLER_28_188 vssd1 vssd1 vccd1 vccd1 sky130_fd_sc_hd__fill_8
XFILLER_34_125 vccd1 vssd1 vccd1 vssd1 sky130_ef_sc_hd__decap_40_12
X_0645_ _0226_ net21 _0225_ vssd1 vssd1 vccd1 vccd1 MATMULT_INST.uart_rcv.tim.clock_count.next_cnt_out\[10\]
+ sky130_fd_sc_hd__and3b_1
X_0714_ _0279_ _0287_ vssd1 vssd1 vccd1 vccd1 _0288_ sky130_fd_sc_hd__xnor2_1
X_0576_ net6 MATMULT_INST.uart_tx.count.next_cnt_out\[11\] vssd1 vssd1 vccd1 vccd1
+ _0170_ sky130_fd_sc_hd__xnor2_1
XFILLER_15_15 vssd1 vssd1 vccd1 vccd1 sky130_fd_sc_hd__fill_8
XFILLER_25_169 vccd1 vssd1 vccd1 vssd1 sky130_ef_sc_hd__decap_40_12
XFILLER_31_47 vssd1 vssd1 vccd1 vccd1 sky130_fd_sc_hd__fill_8
XFILLER_0_202 vssd1 vssd1 vccd1 vccd1 sky130_fd_sc_hd__fill_4
XFILLER_16_125 vssd1 vssd1 vccd1 vccd1 sky130_fd_sc_hd__fill_2
XFILLER_21_80 vssd1 vssd1 vccd1 vccd1 sky130_fd_sc_hd__fill_8
XFILLER_15_180 vccd1 vssd1 vccd1 vssd1 sky130_ef_sc_hd__decap_40_12
XFILLER_22_139 vssd1 vssd1 vccd1 vccd1 sky130_fd_sc_hd__fill_1
X_0628_ MATMULT_INST.uart_rcv.tim.clk_cnt\[4\] _0210_ MATMULT_INST.uart_rcv.tim.clk_cnt\[5\]
+ vssd1 vssd1 vccd1 vccd1 _0215_ sky130_fd_sc_hd__a21oi_1
X_0559_ MATMULT_INST.uart_tx.clk_cnt\[13\] _0152_ net22 vssd1 vssd1 vccd1 vccd1 _0154_
+ sky130_fd_sc_hd__o21ai_1
XTAP_TAPCELL_ROW_23_189 vssd1 vccd1 sky130_fd_sc_hd__tapvpwrvgnd_1
XTAP_TAPCELL_ROW_8_121 vssd1 vccd1 sky130_fd_sc_hd__tapvpwrvgnd_1
XPHY_EDGE_ROW_32_Left_71 vssd1 vssd1 vccd1 vccd1 sky130_fd_sc_hd__decap_3
XFILLER_8_132 vssd1 vssd1 vccd1 vccd1 sky130_fd_sc_hd__fill_8
XTAP_TAPCELL_ROW_14_145 vssd1 vccd1 sky130_fd_sc_hd__tapvpwrvgnd_1
XFILLER_8_176 vssd1 vssd1 vccd1 vccd1 sky130_fd_sc_hd__fill_2
XFILLER_35_253 vssd1 vssd1 vccd1 vccd1 sky130_fd_sc_hd__fill_2
XFILLER_10_109 vssd1 vssd1 vccd1 vccd1 sky130_fd_sc_hd__fill_4
XFILLER_12_27 vssd1 vssd1 vccd1 vccd1 sky130_fd_sc_hd__fill_1
XFILLER_37_79 vssd1 vssd1 vccd1 vccd1 sky130_fd_sc_hd__fill_4
XFILLER_37_57 vccd1 vssd1 vccd1 vssd1 sky130_ef_sc_hd__decap_40_12
XFILLER_37_13 vssd1 vssd1 vccd1 vccd1 sky130_fd_sc_hd__fill_2
XFILLER_26_220 vssd1 vssd1 vccd1 vccd1 sky130_fd_sc_hd__fill_4
XFILLER_26_253 vssd1 vssd1 vccd1 vccd1 sky130_fd_sc_hd__fill_2
XFILLER_5_113 vssd1 vssd1 vccd1 vccd1 sky130_fd_sc_hd__fill_1
XFILLER_32_234 vccd1 vssd1 vccd1 vssd1 sky130_ef_sc_hd__decap_40_12
X_0893_ _0416_ _0417_ vssd1 vssd1 vccd1 vccd1 _0418_ sky130_fd_sc_hd__and2b_1
X_0962_ clknet_3_0__leaf_clk _0008_ net27 vssd1 vssd1 vccd1 vccd1 MATMULT_INST.uart_rcv.data_buff.packet_data\[3\]
+ sky130_fd_sc_hd__dfstp_1
XFILLER_4_83 vssd1 vssd1 vccd1 vccd1 sky130_fd_sc_hd__fill_1
XFILLER_23_15 vssd1 vssd1 vccd1 vccd1 sky130_fd_sc_hd__fill_1
XFILLER_23_48 vssd1 vssd1 vccd1 vccd1 sky130_fd_sc_hd__fill_8
XFILLER_23_223 vssd1 vssd1 vccd1 vccd1 sky130_fd_sc_hd__fill_1
XTAP_TAPCELL_ROW_0_84 vssd1 vccd1 sky130_fd_sc_hd__tapvpwrvgnd_1
XFILLER_20_237 vssd1 vssd1 vccd1 vccd1 sky130_fd_sc_hd__fill_1
XTAP_TAPCELL_ROW_30_221 vssd1 vccd1 sky130_fd_sc_hd__tapvpwrvgnd_1
X_0876_ _0403_ MATMULT_INST.prod_adder.gen_for_loop\[0\].adder_n.b _0402_ vssd1 vssd1
+ vccd1 vccd1 _0044_ sky130_fd_sc_hd__mux2_1
X_0945_ clknet_3_6__leaf_clk MATMULT_INST.uart_tx.count.next_cnt_out\[0\] net30 vssd1
+ vssd1 vccd1 vccd1 MATMULT_INST.uart_tx.clk_cnt\[0\] sky130_fd_sc_hd__dfrtp_1
XFILLER_18_15 vccd1 vssd1 vccd1 vssd1 sky130_ef_sc_hd__decap_40_12
XFILLER_34_36 vssd1 vssd1 vccd1 vccd1 sky130_fd_sc_hd__fill_4
Xclkload2 clknet_3_2__leaf_clk vssd1 vssd1 vccd1 vccd1 clkload2/Y sky130_fd_sc_hd__clkinv_4
XANTENNA_clkbuf_3_4__f_clk_A clknet_0_clk vssd1 vssd1 vccd1 vccd1 sky130_fd_sc_hd__diode_2
X_0661_ net12 MATMULT_INST.uart_rcv.tim.clock_count.next_cnt_out\[2\] vssd1 vssd1
+ vccd1 vccd1 _0239_ sky130_fd_sc_hd__xnor2_1
X_0730_ MATMULT_INST.uart_tx.tx_ctrl.state\[2\] _0261_ _0262_ _0298_ vssd1 vssd1 vccd1
+ vccd1 _0304_ sky130_fd_sc_hd__and4_1
X_0592_ net8 MATMULT_INST.uart_rcv.tim.clk_cnt\[13\] vssd1 vssd1 vccd1 vccd1 _0184_
+ sky130_fd_sc_hd__and2b_1
XFILLER_27_3 vssd1 vssd1 vccd1 vccd1 sky130_fd_sc_hd__fill_1
XFILLER_37_189 vssd1 vssd1 vccd1 vccd1 sky130_fd_sc_hd__fill_2
XFILLER_37_167 vssd1 vssd1 vccd1 vccd1 sky130_fd_sc_hd__fill_1
X_0859_ _0065_ _0066_ _0381_ _0100_ MATMULT_INST.cntrl.state\[0\] vssd1 vssd1 vccd1
+ vccd1 _0392_ sky130_fd_sc_hd__o32a_1
XFILLER_20_27 vssd1 vssd1 vccd1 vccd1 sky130_fd_sc_hd__fill_1
X_0928_ net107 _0447_ net109 vssd1 vssd1 vccd1 vccd1 _0448_ sky130_fd_sc_hd__a21oi_1
Xhold14 MATMULT_INST.uart_rcv.shift_strobe vssd1 vssd1 vccd1 vccd1 net117 sky130_fd_sc_hd__dlygate4sd3_1
XFILLER_28_178 vssd1 vssd1 vccd1 vccd1 sky130_fd_sc_hd__fill_4
XFILLER_6_29 vccd1 vssd1 vccd1 vssd1 sky130_ef_sc_hd__decap_40_12
XFILLER_6_18 vssd1 vssd1 vccd1 vccd1 sky130_fd_sc_hd__fill_8
XFILLER_34_137 vssd1 vssd1 vccd1 vccd1 sky130_fd_sc_hd__fill_2
X_0644_ MATMULT_INST.uart_rcv.tim.clk_cnt\[7\] MATMULT_INST.uart_rcv.tim.clk_cnt\[10\]
+ _0217_ _0223_ vssd1 vssd1 vccd1 vccd1 _0226_ sky130_fd_sc_hd__and4_1
X_0713_ _0265_ _0266_ vssd1 vssd1 vccd1 vccd1 _0287_ sky130_fd_sc_hd__and2b_1
X_0575_ net5 MATMULT_INST.uart_tx.count.next_cnt_out\[10\] vssd1 vssd1 vccd1 vccd1
+ _0169_ sky130_fd_sc_hd__xnor2_1
XFILLER_33_181 vccd1 vssd1 vccd1 vssd1 sky130_ef_sc_hd__decap_40_12
XFILLER_25_104 vssd1 vssd1 vccd1 vccd1 sky130_fd_sc_hd__fill_8
XPHY_EDGE_ROW_1_Right_1 vssd1 vssd1 vccd1 vccd1 sky130_fd_sc_hd__decap_3
XFILLER_0_225 vssd1 vssd1 vccd1 vccd1 sky130_fd_sc_hd__fill_2
XFILLER_16_104 vssd1 vssd1 vccd1 vccd1 sky130_fd_sc_hd__fill_2
XANTENNA_fanout37_X net37 vssd1 vssd1 vccd1 vccd1 sky130_fd_sc_hd__diode_2
XFILLER_22_129 vssd1 vssd1 vccd1 vccd1 sky130_fd_sc_hd__fill_8
XFILLER_7_72 vssd1 vssd1 vccd1 vccd1 sky130_fd_sc_hd__fill_2
XFILLER_15_192 vssd1 vssd1 vccd1 vccd1 sky130_fd_sc_hd__fill_1
X_0627_ MATMULT_INST.uart_rcv.tim.clk_cnt\[4\] MATMULT_INST.uart_rcv.tim.clk_cnt\[5\]
+ _0210_ vssd1 vssd1 vccd1 vccd1 _0214_ sky130_fd_sc_hd__and3_1
X_0558_ _0152_ _0153_ vssd1 vssd1 vccd1 vccd1 MATMULT_INST.uart_tx.count.next_cnt_out\[12\]
+ sky130_fd_sc_hd__nor2_1
X_0489_ net124 _0087_ _0098_ vssd1 vssd1 vccd1 vccd1 MATMULT_INST.uart_rcv.tim.bit_count.next_cnt_out\[1\]
+ sky130_fd_sc_hd__o21a_1
XTAP_TAPCELL_ROW_8_122 vssd1 vccd1 sky130_fd_sc_hd__tapvpwrvgnd_1
XANTENNA_input14_A gpio_in[6] vssd1 vssd1 vccd1 vccd1 sky130_fd_sc_hd__diode_2
XFILLER_32_80 vssd1 vssd1 vccd1 vccd1 sky130_fd_sc_hd__fill_1
XFILLER_8_111 vssd1 vssd1 vccd1 vccd1 sky130_fd_sc_hd__fill_2
XFILLER_12_195 vssd1 vssd1 vccd1 vccd1 sky130_fd_sc_hd__fill_1
XTAP_TAPCELL_ROW_14_146 vssd1 vccd1 sky130_fd_sc_hd__tapvpwrvgnd_1
XFILLER_16_81 vssd1 vssd1 vccd1 vccd1 sky130_fd_sc_hd__fill_2
XTAP_TAPCELL_ROW_37_249 vssd1 vccd1 sky130_fd_sc_hd__tapvpwrvgnd_1
XANTENNA_input6_A gpio_in[13] vssd1 vssd1 vccd1 vccd1 sky130_fd_sc_hd__diode_2
XFILLER_37_69 vssd1 vssd1 vccd1 vccd1 sky130_fd_sc_hd__fill_2
XFILLER_5_169 vssd1 vssd1 vccd1 vccd1 sky130_fd_sc_hd__fill_1
XFILLER_32_246 vssd1 vssd1 vccd1 vccd1 sky130_fd_sc_hd__fill_2
X_0961_ clknet_3_0__leaf_clk _0007_ net25 vssd1 vssd1 vccd1 vccd1 MATMULT_INST.uart_rcv.data_buff.packet_data\[2\]
+ sky130_fd_sc_hd__dfstp_1
X_0892_ MATMULT_INST.parallel_out2\[1\] MATMULT_INST.parallel_out2\[6\] MATMULT_INST.parallel_out2\[7\]
+ MATMULT_INST.parallel_out2\[0\] vssd1 vssd1 vccd1 vccd1 _0417_ sky130_fd_sc_hd__a22o_1
XFILLER_2_139 vssd1 vssd1 vccd1 vccd1 sky130_fd_sc_hd__fill_1
XTAP_TAPCELL_ROW_0_85 vssd1 vccd1 sky130_fd_sc_hd__tapvpwrvgnd_1
Xclkbuf_3_7__f_clk clknet_0_clk vssd1 vssd1 vccd1 vccd1 clknet_3_7__leaf_clk sky130_fd_sc_hd__clkbuf_16
XFILLER_9_250 vssd1 vssd1 vccd1 vccd1 sky130_fd_sc_hd__fill_4
X_0944_ clknet_3_6__leaf_clk MATMULT_INST.uart_tx.count.next_roflag net33 vssd1 vssd1
+ vccd1 vccd1 MATMULT_INST.uart_tx.count.roflag_ff sky130_fd_sc_hd__dfrtp_1
X_0875_ MATMULT_INST.parallel_out2\[0\] MATMULT_INST.parallel_out2\[4\] vssd1 vssd1
+ vccd1 vccd1 _0403_ sky130_fd_sc_hd__and2_1
XANTENNA__0867__A _0096_ vssd1 vssd1 vccd1 vccd1 sky130_fd_sc_hd__diode_2
XFILLER_18_27 vssd1 vssd1 vccd1 vccd1 sky130_fd_sc_hd__fill_1
XFILLER_34_26 vssd1 vssd1 vccd1 vccd1 sky130_fd_sc_hd__fill_2
XFILLER_11_249 vssd1 vssd1 vccd1 vccd1 sky130_fd_sc_hd__fill_4
Xclkload3 clknet_3_3__leaf_clk vssd1 vssd1 vccd1 vccd1 clkload3/Y sky130_fd_sc_hd__inv_6
X_0660_ net15 _0216_ vssd1 vssd1 vccd1 vccd1 _0238_ sky130_fd_sc_hd__or2_1
X_0591_ MATMULT_INST.uart_rcv.tim.clk_cnt\[5\] net15 vssd1 vssd1 vccd1 vccd1 _0183_
+ sky130_fd_sc_hd__nand2b_1
XFILLER_6_253 vssd1 vssd1 vccd1 vccd1 sky130_fd_sc_hd__fill_2
XFILLER_37_113 vssd1 vssd1 vccd1 vccd1 sky130_fd_sc_hd__fill_4
X_0927_ _0067_ MATMULT_INST.uart_rcv.control.state\[0\] MATMULT_INST.uart_rcv.control.state\[2\]
+ vssd1 vssd1 vccd1 vccd1 _0447_ sky130_fd_sc_hd__and3_4
X_0789_ MATMULT_INST.parallel_out1\[1\] MATMULT_INST.parallel_out1\[6\] MATMULT_INST.parallel_out1\[7\]
+ MATMULT_INST.parallel_out1\[0\] vssd1 vssd1 vccd1 vccd1 _0344_ sky130_fd_sc_hd__a22o_1
X_0858_ _0379_ _0386_ _0390_ vssd1 vssd1 vccd1 vccd1 _0391_ sky130_fd_sc_hd__and3_1
Xhold15 MATMULT_INST.uart_rcv.tim.bit_count.next_cnt_out\[0\] vssd1 vssd1 vccd1 vccd1
+ net118 sky130_fd_sc_hd__dlygate4sd3_1
XANTENNA_fanout27_A net37 vssd1 vssd1 vccd1 vccd1 sky130_fd_sc_hd__diode_2
XFILLER_10_61 vssd1 vssd1 vccd1 vccd1 sky130_fd_sc_hd__fill_2
XFILLER_34_149 vssd1 vssd1 vccd1 vccd1 sky130_fd_sc_hd__fill_2
X_0643_ MATMULT_INST.uart_rcv.tim.clk_cnt\[7\] _0217_ _0223_ MATMULT_INST.uart_rcv.tim.clk_cnt\[10\]
+ vssd1 vssd1 vccd1 vccd1 _0225_ sky130_fd_sc_hd__a31o_1
X_0712_ MATMULT_INST.uart_tx.tx_ctrl.state\[4\] MATMULT_INST.uart_tx.tx_ctrl.state\[2\]
+ MATMULT_INST.uart_tx.tx_ctrl.state\[3\] vssd1 vssd1 vccd1 vccd1 _0286_ sky130_fd_sc_hd__nand3b_1
X_0574_ _0162_ _0163_ _0166_ _0167_ vssd1 vssd1 vccd1 vccd1 _0168_ sky130_fd_sc_hd__or4_1
XFILLER_33_193 vccd1 vssd1 vccd1 vssd1 sky130_ef_sc_hd__decap_40_12
XFILLER_0_237 vccd1 vssd1 vccd1 vssd1 sky130_ef_sc_hd__decap_40_12
XFILLER_16_127 vssd1 vssd1 vccd1 vccd1 sky130_fd_sc_hd__fill_1
XFILLER_16_138 vssd1 vssd1 vccd1 vccd1 sky130_fd_sc_hd__fill_2
XFILLER_24_193 vssd1 vssd1 vccd1 vccd1 sky130_fd_sc_hd__fill_2
XTAP_TAPCELL_ROW_26_199 vssd1 vccd1 sky130_fd_sc_hd__tapvpwrvgnd_1
Xclkbuf_0_clk clk vssd1 vssd1 vccd1 vccd1 clknet_0_clk sky130_fd_sc_hd__clkbuf_16
XFILLER_30_130 vssd1 vssd1 vccd1 vccd1 sky130_fd_sc_hd__fill_4
XFILLER_7_84 vssd1 vssd1 vccd1 vccd1 sky130_fd_sc_hd__fill_1
XFILLER_30_141 vccd1 vssd1 vccd1 vssd1 sky130_ef_sc_hd__decap_40_12
X_0626_ _0213_ vssd1 vssd1 vccd1 vccd1 MATMULT_INST.uart_rcv.tim.clock_count.next_cnt_out\[4\]
+ sky130_fd_sc_hd__inv_2
XPHY_EDGE_ROW_15_Right_15 vssd1 vssd1 vccd1 vccd1 sky130_fd_sc_hd__decap_3
X_0557_ MATMULT_INST.uart_tx.clk_cnt\[12\] _0150_ _0128_ vssd1 vssd1 vccd1 vccd1 _0153_
+ sky130_fd_sc_hd__o21ai_1
X_0488_ MATMULT_INST.uart_rcv.control.packet_done _0083_ vssd1 vssd1 vccd1 vccd1 _0098_
+ sky130_fd_sc_hd__nor2_1
X_1109_ MATMULT_INST.serial_out vssd1 vssd1 vccd1 vccd1 net20 sky130_fd_sc_hd__clkbuf_1
XPHY_EDGE_ROW_24_Right_24 vssd1 vssd1 vccd1 vccd1 sky130_fd_sc_hd__decap_3
XFILLER_26_27 vssd1 vssd1 vccd1 vccd1 sky130_fd_sc_hd__fill_1
XFILLER_26_49 vssd1 vssd1 vccd1 vccd1 sky130_fd_sc_hd__fill_8
XFILLER_21_185 vssd1 vssd1 vccd1 vccd1 sky130_fd_sc_hd__fill_4
XPHY_EDGE_ROW_33_Right_33 vssd1 vssd1 vccd1 vccd1 sky130_fd_sc_hd__decap_3
XFILLER_8_101 vssd1 vssd1 vccd1 vccd1 sky130_fd_sc_hd__fill_2
XTAP_TAPCELL_ROW_14_147 vssd1 vccd1 sky130_fd_sc_hd__tapvpwrvgnd_1
XTAP_TAPCELL_ROW_3_96 vssd1 vccd1 sky130_fd_sc_hd__tapvpwrvgnd_1
XPHY_EDGE_ROW_19_Left_58 vssd1 vssd1 vccd1 vccd1 sky130_fd_sc_hd__decap_3
XFILLER_12_29 vssd1 vssd1 vccd1 vccd1 sky130_fd_sc_hd__fill_1
XFILLER_37_15 vssd1 vssd1 vccd1 vccd1 sky130_fd_sc_hd__fill_1
X_0609_ _0194_ _0200_ vssd1 vssd1 vccd1 vccd1 _0201_ sky130_fd_sc_hd__nand2_1
X_0960_ clknet_3_0__leaf_clk _0006_ net25 vssd1 vssd1 vccd1 vccd1 MATMULT_INST.uart_rcv.data_buff.packet_data\[1\]
+ sky130_fd_sc_hd__dfstp_1
XFILLER_27_92 vssd1 vssd1 vccd1 vccd1 sky130_fd_sc_hd__fill_4
X_0891_ MATMULT_INST.parallel_out2\[0\] MATMULT_INST.parallel_out2\[1\] MATMULT_INST.parallel_out2\[6\]
+ MATMULT_INST.parallel_out2\[7\] vssd1 vssd1 vccd1 vccd1 _0416_ sky130_fd_sc_hd__and4_1
XFILLER_4_85 vssd1 vssd1 vccd1 vccd1 sky130_fd_sc_hd__fill_2
XFILLER_4_41 vccd1 vssd1 vccd1 vssd1 sky130_ef_sc_hd__decap_40_12
XFILLER_23_225 vssd1 vssd1 vccd1 vccd1 sky130_fd_sc_hd__fill_4
XTAP_TAPCELL_ROW_33_231 vssd1 vccd1 sky130_fd_sc_hd__tapvpwrvgnd_1
XTAP_TAPCELL_ROW_0_86 vssd1 vccd1 sky130_fd_sc_hd__tapvpwrvgnd_1
XFILLER_1_162 vssd1 vssd1 vccd1 vccd1 sky130_fd_sc_hd__fill_2
XFILLER_38_91 vssd1 vssd1 vccd1 vccd1 sky130_fd_sc_hd__fill_1
X_0943_ clknet_3_5__leaf_clk _0004_ net32 vssd1 vssd1 vccd1 vccd1 MATMULT_INST.uart_tx.tx_ctrl.state\[4\]
+ sky130_fd_sc_hd__dfrtp_2
X_0874_ MATMULT_INST.cntrl.state\[3\] _0398_ vssd1 vssd1 vccd1 vccd1 _0402_ sky130_fd_sc_hd__nand2_4
Xclkload4 clknet_3_4__leaf_clk vssd1 vssd1 vccd1 vccd1 clkload4/Y sky130_fd_sc_hd__bufinv_16
XFILLER_24_82 vssd1 vssd1 vccd1 vccd1 sky130_fd_sc_hd__fill_2
X_0590_ MATMULT_INST.uart_rcv.tim.clk_cnt\[6\] net16 vssd1 vssd1 vccd1 vccd1 _0182_
+ sky130_fd_sc_hd__nand2b_1
XFILLER_37_136 vssd1 vssd1 vccd1 vccd1 sky130_fd_sc_hd__fill_2
XFILLER_34_6 vccd1 vssd1 vccd1 vssd1 sky130_ef_sc_hd__decap_40_12
X_0926_ _0402_ _0437_ _0444_ _0446_ vssd1 vssd1 vccd1 vccd1 _0051_ sky130_fd_sc_hd__o31a_1
X_0857_ MATMULT_INST.cntrl.state\[1\] MATMULT_INST.cntrl.state\[2\] _0065_ MATMULT_INST.cntrl.state\[4\]
+ vssd1 vssd1 vccd1 vccd1 _0390_ sky130_fd_sc_hd__a211o_1
XFILLER_20_29 vssd1 vssd1 vccd1 vccd1 sky130_fd_sc_hd__fill_4
X_0788_ MATMULT_INST.parallel_out1\[0\] MATMULT_INST.parallel_out1\[1\] MATMULT_INST.parallel_out1\[6\]
+ MATMULT_INST.parallel_out1\[7\] vssd1 vssd1 vccd1 vccd1 _0343_ sky130_fd_sc_hd__and4_1
Xhold16 MATMULT_INST.uart_rcv.control.state\[1\] vssd1 vssd1 vccd1 vccd1 net119 sky130_fd_sc_hd__dlygate4sd3_1
XPHY_EDGE_ROW_7_Left_46 vssd1 vssd1 vccd1 vccd1 sky130_fd_sc_hd__decap_3
XFILLER_34_139 vssd1 vssd1 vccd1 vccd1 sky130_fd_sc_hd__fill_1
XFILLER_34_106 vccd1 vssd1 vccd1 vssd1 sky130_ef_sc_hd__decap_40_12
X_0711_ _0282_ _0283_ vssd1 vssd1 vccd1 vccd1 _0285_ sky130_fd_sc_hd__xnor2_1
X_0642_ MATMULT_INST.uart_rcv.tim.clk_cnt\[9\] _0222_ _0224_ net21 vssd1 vssd1 vccd1
+ vccd1 MATMULT_INST.uart_rcv.tim.clock_count.next_cnt_out\[9\] sky130_fd_sc_hd__o211a_1
X_0573_ net3 _0145_ _0156_ vssd1 vssd1 vccd1 vccd1 _0167_ sky130_fd_sc_hd__o21ai_1
XFILLER_25_117 vssd1 vssd1 vccd1 vccd1 sky130_fd_sc_hd__fill_1
XFILLER_25_128 vssd1 vssd1 vccd1 vccd1 sky130_fd_sc_hd__fill_2
X_0909_ _0431_ _0432_ vssd1 vssd1 vccd1 vccd1 _0433_ sky130_fd_sc_hd__xnor2_1
XFILLER_31_109 vssd1 vssd1 vccd1 vccd1 sky130_fd_sc_hd__fill_2
XFILLER_30_153 vssd1 vssd1 vccd1 vccd1 sky130_fd_sc_hd__fill_2
X_0625_ net21 _0212_ vssd1 vssd1 vccd1 vccd1 _0213_ sky130_fd_sc_hd__nand2_1
XFILLER_7_74 vssd1 vssd1 vccd1 vccd1 sky130_fd_sc_hd__fill_1
XFILLER_7_30 vssd1 vssd1 vccd1 vccd1 sky130_fd_sc_hd__fill_4
X_0487_ MATMULT_INST.cntrl.data_read vssd1 vssd1 vccd1 vccd1 _0097_ sky130_fd_sc_hd__inv_2
X_0556_ MATMULT_INST.uart_tx.clk_cnt\[11\] MATMULT_INST.uart_tx.clk_cnt\[12\] _0149_
+ vssd1 vssd1 vccd1 vccd1 _0152_ sky130_fd_sc_hd__and3_1
XFILLER_38_253 vssd1 vssd1 vccd1 vccd1 sky130_fd_sc_hd__fill_2
X_1039_ clknet_3_0__leaf_clk _0059_ net27 vssd1 vssd1 vccd1 vccd1 MATMULT_INST.rx_data\[5\]
+ sky130_fd_sc_hd__dfstp_1
X_1108_ MATMULT_INST.cntrl.data_read vssd1 vssd1 vccd1 vccd1 net19 sky130_fd_sc_hd__clkbuf_1
XANTENNA__0830__S _0096_ vssd1 vssd1 vccd1 vccd1 sky130_fd_sc_hd__diode_2
XFILLER_29_220 vssd1 vssd1 vccd1 vccd1 sky130_fd_sc_hd__fill_4
XTAP_TAPCELL_ROW_14_148 vssd1 vccd1 sky130_fd_sc_hd__tapvpwrvgnd_1
XFILLER_16_83 vssd1 vssd1 vccd1 vccd1 sky130_fd_sc_hd__fill_1
XTAP_TAPCELL_ROW_3_97 vssd1 vccd1 sky130_fd_sc_hd__tapvpwrvgnd_1
XFILLER_12_197 vssd1 vssd1 vccd1 vccd1 sky130_fd_sc_hd__fill_2
XTAP_TAPCELL_ROW_22_181 vssd1 vccd1 sky130_fd_sc_hd__tapvpwrvgnd_1
X_0608_ _0196_ _0197_ _0198_ _0199_ vssd1 vssd1 vccd1 vccd1 _0200_ sky130_fd_sc_hd__and4_1
XTAP_TAPCELL_ROW_5_105 vssd1 vccd1 sky130_fd_sc_hd__tapvpwrvgnd_1
X_0539_ MATMULT_INST.uart_tx.clk_cnt\[6\] _0137_ vssd1 vssd1 vccd1 vccd1 _0141_ sky130_fd_sc_hd__or2_1
XANTENNA__0825__S _0096_ vssd1 vssd1 vccd1 vccd1 sky130_fd_sc_hd__diode_2
XPHY_EDGE_ROW_36_Left_75 vssd1 vssd1 vccd1 vccd1 sky130_fd_sc_hd__decap_3
XPHY_EDGE_ROW_20_Left_59 vssd1 vssd1 vccd1 vccd1 sky130_fd_sc_hd__decap_3
XFILLER_32_248 vssd1 vssd1 vccd1 vccd1 sky130_fd_sc_hd__fill_1
X_0890_ MATMULT_INST.parallel_out2\[5\] MATMULT_INST.parallel_out2\[2\] vssd1 vssd1
+ vccd1 vccd1 _0415_ sky130_fd_sc_hd__nand2_1
XFILLER_4_171 vssd1 vssd1 vccd1 vccd1 sky130_fd_sc_hd__fill_2
XFILLER_4_53 vssd1 vssd1 vccd1 vccd1 sky130_fd_sc_hd__fill_4
XTAP_TAPCELL_ROW_33_232 vssd1 vccd1 sky130_fd_sc_hd__tapvpwrvgnd_1
Xfanout30 net37 vssd1 vssd1 vccd1 vccd1 net30 sky130_fd_sc_hd__clkbuf_4
XFILLER_13_95 vssd1 vssd1 vccd1 vccd1 sky130_fd_sc_hd__fill_4
XFILLER_38_81 vssd1 vssd1 vccd1 vccd1 sky130_fd_sc_hd__fill_2
X_0942_ clknet_3_5__leaf_clk _0003_ net32 vssd1 vssd1 vccd1 vccd1 MATMULT_INST.uart_tx.tx_ctrl.state\[3\]
+ sky130_fd_sc_hd__dfrtp_2
X_0873_ MATMULT_INST.uart_rcv.sbc.stop_bit _0260_ _0256_ net116 vssd1 vssd1 vccd1
+ vccd1 _0043_ sky130_fd_sc_hd__a2bb2o_1
XFILLER_18_29 vssd1 vssd1 vccd1 vccd1 sky130_fd_sc_hd__fill_4
Xclkload5 clknet_3_5__leaf_clk vssd1 vssd1 vccd1 vccd1 clkload5/Y sky130_fd_sc_hd__inv_8
XFILLER_10_251 vssd1 vssd1 vccd1 vccd1 sky130_fd_sc_hd__fill_1
XPHY_EDGE_ROW_23_Left_62 vssd1 vssd1 vccd1 vccd1 sky130_fd_sc_hd__decap_3
X_0925_ MATMULT_INST.cntrl.state\[3\] _0398_ MATMULT_INST.prod_adder.gen_for_loop\[7\].adder_n.b
+ vssd1 vssd1 vccd1 vccd1 _0446_ sky130_fd_sc_hd__a21o_1
X_0787_ MATMULT_INST.parallel_out1\[5\] MATMULT_INST.parallel_out1\[2\] vssd1 vssd1
+ vccd1 vccd1 _0342_ sky130_fd_sc_hd__nand2_1
X_0856_ _0384_ _0389_ vssd1 vssd1 vccd1 vccd1 _0038_ sky130_fd_sc_hd__xnor2_1
Xhold17 MATMULT_INST.uart_tx.tx_ctrl.state\[4\] vssd1 vssd1 vccd1 vccd1 net120 sky130_fd_sc_hd__dlygate4sd3_1
XANTENNA__0833__S _0092_ vssd1 vssd1 vccd1 vccd1 sky130_fd_sc_hd__diode_2
XFILLER_3_225 vccd1 vssd1 vccd1 vssd1 sky130_ef_sc_hd__decap_40_12
XFILLER_10_85 vssd1 vssd1 vccd1 vccd1 sky130_fd_sc_hd__fill_1
XFILLER_19_61 vssd1 vssd1 vccd1 vccd1 sky130_fd_sc_hd__fill_1
XFILLER_19_115 vssd1 vssd1 vccd1 vccd1 sky130_fd_sc_hd__fill_1
XFILLER_34_118 vssd1 vssd1 vccd1 vccd1 sky130_fd_sc_hd__fill_4
X_0641_ _0220_ _0223_ vssd1 vssd1 vccd1 vccd1 _0224_ sky130_fd_sc_hd__nand2_1
X_0710_ MATMULT_INST.uart_tx.tx_ctrl.state\[2\] MATMULT_INST.uart_tx.tx_ctrl.state\[3\]
+ MATMULT_INST.uart_tx.tx_ctrl.state\[4\] vssd1 vssd1 vccd1 vccd1 _0284_ sky130_fd_sc_hd__or3b_2
X_0572_ _0157_ _0158_ _0159_ _0165_ vssd1 vssd1 vccd1 vccd1 _0166_ sky130_fd_sc_hd__or4b_1
XFILLER_18_170 vssd1 vssd1 vccd1 vccd1 sky130_fd_sc_hd__fill_1
XFILLER_18_192 vssd1 vssd1 vccd1 vccd1 sky130_fd_sc_hd__fill_4
X_0908_ _0420_ _0424_ _0421_ vssd1 vssd1 vccd1 vccd1 _0432_ sky130_fd_sc_hd__o21ba_1
XFILLER_0_217 vssd1 vssd1 vccd1 vccd1 sky130_fd_sc_hd__fill_2
X_0839_ MATMULT_INST.parallel_out1\[6\] MATMULT_INST.rx_data\[6\] _0092_ vssd1 vssd1
+ vccd1 vccd1 _0036_ sky130_fd_sc_hd__mux2_1
XANTENNA__0828__S _0096_ vssd1 vssd1 vccd1 vccd1 sky130_fd_sc_hd__diode_2
XANTENNA_fanout32_A net37 vssd1 vssd1 vccd1 vccd1 sky130_fd_sc_hd__diode_2
XFILLER_24_195 vssd1 vssd1 vccd1 vccd1 sky130_fd_sc_hd__fill_1
XFILLER_21_40 vssd1 vssd1 vccd1 vccd1 sky130_fd_sc_hd__fill_2
XFILLER_30_121 vssd1 vssd1 vccd1 vccd1 sky130_fd_sc_hd__fill_4
X_0624_ MATMULT_INST.uart_rcv.tim.clk_cnt\[4\] _0210_ vssd1 vssd1 vccd1 vccd1 _0212_
+ sky130_fd_sc_hd__xor2_1
X_0486_ _0092_ _0096_ vssd1 vssd1 vccd1 vccd1 MATMULT_INST.cntrl.data_read sky130_fd_sc_hd__or2_2
X_0555_ _0150_ _0151_ vssd1 vssd1 vccd1 vccd1 MATMULT_INST.uart_tx.count.next_cnt_out\[11\]
+ sky130_fd_sc_hd__nor2_1
XPHY_EDGE_ROW_5_Right_5 vssd1 vssd1 vccd1 vccd1 sky130_fd_sc_hd__decap_3
X_1038_ clknet_3_0__leaf_clk _0058_ net25 vssd1 vssd1 vccd1 vccd1 MATMULT_INST.rx_data\[4\]
+ sky130_fd_sc_hd__dfstp_1
XFILLER_26_29 vssd1 vssd1 vccd1 vccd1 sky130_fd_sc_hd__fill_1
XFILLER_29_243 vssd1 vssd1 vccd1 vccd1 sky130_fd_sc_hd__fill_4
XFILLER_8_103 vssd1 vssd1 vccd1 vccd1 sky130_fd_sc_hd__fill_1
XTAP_TAPCELL_ROW_14_149 vssd1 vccd1 sky130_fd_sc_hd__tapvpwrvgnd_1
XFILLER_32_94 vssd1 vssd1 vccd1 vccd1 sky130_fd_sc_hd__fill_4
XFILLER_32_61 vssd1 vssd1 vccd1 vccd1 sky130_fd_sc_hd__fill_1
XTAP_TAPCELL_ROW_3_98 vssd1 vccd1 sky130_fd_sc_hd__tapvpwrvgnd_1
XFILLER_8_147 vssd1 vssd1 vccd1 vccd1 sky130_fd_sc_hd__fill_2
XTAP_TAPCELL_ROW_22_182 vssd1 vccd1 sky130_fd_sc_hd__tapvpwrvgnd_1
XANTENNA__0931__S _0447_ vssd1 vssd1 vccd1 vccd1 sky130_fd_sc_hd__diode_2
X_0607_ _0069_ MATMULT_INST.uart_rcv.tim.clk_cnt\[1\] _0185_ _0188_ _0195_ vssd1 vssd1
+ vccd1 vccd1 _0199_ sky130_fd_sc_hd__o2111a_1
XFILLER_7_191 vccd1 vssd1 vccd1 vssd1 sky130_ef_sc_hd__decap_40_12
XTAP_TAPCELL_ROW_5_106 vssd1 vccd1 sky130_fd_sc_hd__tapvpwrvgnd_1
X_0538_ MATMULT_INST.uart_tx.clk_cnt\[4\] MATMULT_INST.uart_tx.clk_cnt\[5\] MATMULT_INST.uart_tx.clk_cnt\[6\]
+ _0133_ vssd1 vssd1 vccd1 vccd1 _0140_ sky130_fd_sc_hd__and4_1
X_0469_ MATMULT_INST.prod_adder.gen_for_loop\[3\].adder_n.b vssd1 vssd1 vccd1 vccd1
+ _0082_ sky130_fd_sc_hd__inv_2
XTAP_TAPCELL_ROW_28_208 vssd1 vccd1 sky130_fd_sc_hd__tapvpwrvgnd_1
XFILLER_5_106 vssd1 vssd1 vccd1 vccd1 sky130_fd_sc_hd__fill_4
XANTENNA_input12_A gpio_in[4] vssd1 vssd1 vccd1 vccd1 sky130_fd_sc_hd__diode_2
XANTENNA_clkbuf_3_7__f_clk_A clknet_0_clk vssd1 vssd1 vccd1 vccd1 sky130_fd_sc_hd__diode_2
XTAP_TAPCELL_ROW_10_130 vssd1 vccd1 sky130_fd_sc_hd__tapvpwrvgnd_1
XFILLER_4_183 vccd1 vssd1 vccd1 vssd1 sky130_ef_sc_hd__decap_40_12
XTAP_TAPCELL_ROW_33_233 vssd1 vccd1 sky130_fd_sc_hd__tapvpwrvgnd_1
XANTENNA_input4_A gpio_in[11] vssd1 vssd1 vccd1 vccd1 sky130_fd_sc_hd__diode_2
XANTENNA__0836__S _0092_ vssd1 vssd1 vccd1 vccd1 sky130_fd_sc_hd__diode_2
Xfanout31 net32 vssd1 vssd1 vccd1 vccd1 net31 sky130_fd_sc_hd__clkbuf_4
X_0941_ clknet_3_5__leaf_clk _0002_ net32 vssd1 vssd1 vccd1 vccd1 MATMULT_INST.uart_tx.tx_ctrl.state\[2\]
+ sky130_fd_sc_hd__dfrtp_2
X_0872_ net125 _0384_ _0394_ _0401_ vssd1 vssd1 vccd1 vccd1 _0042_ sky130_fd_sc_hd__a211o_1
XFILLER_34_18 vssd1 vssd1 vccd1 vccd1 sky130_fd_sc_hd__fill_8
XFILLER_34_29 vssd1 vssd1 vccd1 vccd1 sky130_fd_sc_hd__fill_4
Xclkload6 clknet_3_6__leaf_clk vssd1 vssd1 vccd1 vccd1 clkload6/Y sky130_fd_sc_hd__bufinv_16
XFILLER_10_241 vssd1 vssd1 vccd1 vccd1 sky130_fd_sc_hd__fill_8
XFILLER_37_138 vssd1 vssd1 vccd1 vccd1 sky130_fd_sc_hd__fill_1
X_0924_ _0402_ _0437_ _0443_ _0444_ _0445_ vssd1 vssd1 vccd1 vccd1 _0050_ sky130_fd_sc_hd__o41ai_1
X_0786_ _0340_ _0341_ MATMULT_INST.prod_adder.gen_for_loop\[2\].adder_n.a _0330_ vssd1
+ vssd1 vccd1 vccd1 _0016_ sky130_fd_sc_hd__a2bb2o_1
X_0855_ _0388_ _0385_ _0328_ _0091_ vssd1 vssd1 vccd1 vccd1 _0389_ sky130_fd_sc_hd__and4b_1
Xhold18 MATMULT_INST.prod_adder.gen_for_loop\[1\].adder_n.a vssd1 vssd1 vccd1 vccd1
+ net121 sky130_fd_sc_hd__dlygate4sd3_1
XFILLER_29_18 vccd1 vssd1 vccd1 vssd1 sky130_ef_sc_hd__decap_40_12
XFILLER_28_149 vssd1 vssd1 vccd1 vccd1 sky130_fd_sc_hd__fill_2
XFILLER_3_237 vccd1 vssd1 vccd1 vssd1 sky130_ef_sc_hd__decap_40_12
XFILLER_19_73 vssd1 vssd1 vccd1 vccd1 sky130_fd_sc_hd__fill_1
X_0640_ MATMULT_INST.uart_rcv.tim.clk_cnt\[8\] MATMULT_INST.uart_rcv.tim.clk_cnt\[9\]
+ vssd1 vssd1 vccd1 vccd1 _0223_ sky130_fd_sc_hd__and2_1
X_0571_ net14 _0136_ _0139_ net15 _0164_ vssd1 vssd1 vccd1 vccd1 _0165_ sky130_fd_sc_hd__o221a_1
XFILLER_18_3 vccd1 vssd1 vccd1 vssd1 sky130_ef_sc_hd__decap_40_12
XANTENNA__0934__S _0447_ vssd1 vssd1 vccd1 vccd1 sky130_fd_sc_hd__diode_2
X_0907_ MATMULT_INST.parallel_out2\[5\] MATMULT_INST.parallel_out2\[2\] _0417_ _0416_
+ vssd1 vssd1 vccd1 vccd1 _0431_ sky130_fd_sc_hd__a31o_1
Xoutput19 net19 vssd1 vssd1 vccd1 vccd1 gpio_out[16] sky130_fd_sc_hd__buf_2
X_0838_ MATMULT_INST.parallel_out1\[5\] MATMULT_INST.rx_data\[5\] _0092_ vssd1 vssd1
+ vccd1 vccd1 _0035_ sky130_fd_sc_hd__mux2_1
X_0769_ MATMULT_INST.uart_rcv.sbc.stop_bit net9 net24 vssd1 vssd1 vccd1 vccd1 _0013_
+ sky130_fd_sc_hd__mux2_1
XFILLER_15_130 vssd1 vssd1 vccd1 vccd1 sky130_fd_sc_hd__fill_2
X_0554_ MATMULT_INST.uart_tx.clk_cnt\[11\] _0149_ net22 vssd1 vssd1 vccd1 vccd1 _0151_
+ sky130_fd_sc_hd__o21ai_1
X_0623_ _0210_ _0211_ net21 vssd1 vssd1 vccd1 vccd1 MATMULT_INST.uart_rcv.tim.clock_count.next_cnt_out\[3\]
+ sky130_fd_sc_hd__and3b_1
X_0485_ _0093_ _0095_ vssd1 vssd1 vccd1 vccd1 _0096_ sky130_fd_sc_hd__nor2_4
X_1037_ clknet_3_0__leaf_clk _0057_ net25 vssd1 vssd1 vccd1 vccd1 MATMULT_INST.rx_data\[3\]
+ sky130_fd_sc_hd__dfstp_1
XFILLER_21_111 vssd1 vssd1 vccd1 vccd1 sky130_fd_sc_hd__fill_1
XFILLER_21_166 vssd1 vssd1 vccd1 vccd1 sky130_fd_sc_hd__fill_2
XANTENNA__0839__S _0092_ vssd1 vssd1 vccd1 vccd1 sky130_fd_sc_hd__diode_2
XPHY_EDGE_ROW_11_Right_11 vssd1 vssd1 vccd1 vccd1 sky130_fd_sc_hd__decap_3
XFILLER_12_199 vssd1 vssd1 vccd1 vccd1 sky130_fd_sc_hd__fill_1
XFILLER_16_85 vssd1 vssd1 vccd1 vccd1 sky130_fd_sc_hd__fill_8
XTAP_TAPCELL_ROW_22_183 vssd1 vccd1 sky130_fd_sc_hd__tapvpwrvgnd_1
XTAP_TAPCELL_ROW_3_99 vssd1 vccd1 sky130_fd_sc_hd__tapvpwrvgnd_1
XPHY_EDGE_ROW_20_Right_20 vssd1 vssd1 vccd1 vccd1 sky130_fd_sc_hd__decap_3
X_0606_ net17 _0080_ _0178_ _0179_ _0184_ vssd1 vssd1 vccd1 vccd1 _0198_ sky130_fd_sc_hd__a2111oi_1
XTAP_TAPCELL_ROW_5_107 vssd1 vccd1 sky130_fd_sc_hd__tapvpwrvgnd_1
X_0537_ _0139_ vssd1 vssd1 vccd1 vccd1 MATMULT_INST.uart_tx.count.next_cnt_out\[5\]
+ sky130_fd_sc_hd__inv_2
X_0468_ MATMULT_INST.uart_rcv.tim.clk_cnt\[9\] vssd1 vssd1 vccd1 vccd1 _0081_ sky130_fd_sc_hd__inv_2
XFILLER_26_247 vssd1 vssd1 vccd1 vccd1 sky130_fd_sc_hd__fill_2
XTAP_TAPCELL_ROW_28_209 vssd1 vccd1 sky130_fd_sc_hd__tapvpwrvgnd_1
XFILLER_27_84 vssd1 vssd1 vccd1 vccd1 sky130_fd_sc_hd__fill_1
XTAP_TAPCELL_ROW_10_131 vssd1 vccd1 sky130_fd_sc_hd__tapvpwrvgnd_1
XFILLER_4_195 vssd1 vssd1 vccd1 vccd1 sky130_fd_sc_hd__fill_1
XFILLER_4_173 vssd1 vssd1 vccd1 vccd1 sky130_fd_sc_hd__fill_1
XTAP_TAPCELL_ROW_33_234 vssd1 vccd1 sky130_fd_sc_hd__tapvpwrvgnd_1
Xclkbuf_3_2__f_clk clknet_0_clk vssd1 vssd1 vccd1 vccd1 clknet_3_2__leaf_clk sky130_fd_sc_hd__clkbuf_16
Xfanout21 _0205_ vssd1 vssd1 vccd1 vccd1 net21 sky130_fd_sc_hd__clkbuf_2
XFILLER_14_206 vccd1 vssd1 vccd1 vssd1 sky130_ef_sc_hd__decap_40_12
Xfanout32 net37 vssd1 vssd1 vccd1 vccd1 net32 sky130_fd_sc_hd__clkbuf_4
XTAP_TAPCELL_ROW_0_78 vssd1 vccd1 sky130_fd_sc_hd__tapvpwrvgnd_1
XFILLER_1_154 vssd1 vssd1 vccd1 vccd1 sky130_fd_sc_hd__fill_8
XFILLER_38_83 vssd1 vssd1 vccd1 vccd1 sky130_fd_sc_hd__fill_1
XANTENNA__0762__S net24 vssd1 vssd1 vccd1 vccd1 sky130_fd_sc_hd__diode_2
X_0940_ clknet_3_5__leaf_clk _0001_ net32 vssd1 vssd1 vccd1 vccd1 MATMULT_INST.uart_tx.tx_ctrl.state\[1\]
+ sky130_fd_sc_hd__dfrtp_1
XFILLER_9_254 vssd1 vssd1 vccd1 vccd1 sky130_fd_sc_hd__fill_1
X_0871_ _0376_ _0377_ _0392_ vssd1 vssd1 vccd1 vccd1 _0401_ sky130_fd_sc_hd__o21ai_1
XANTENNA__0937__S _0447_ vssd1 vssd1 vccd1 vccd1 sky130_fd_sc_hd__diode_2
XFILLER_24_63 vssd1 vssd1 vccd1 vccd1 sky130_fd_sc_hd__fill_1
XFILLER_10_253 vssd1 vssd1 vccd1 vccd1 sky130_fd_sc_hd__fill_2
XFILLER_1_12 vccd1 vssd1 vccd1 vssd1 sky130_ef_sc_hd__decap_40_12
X_0923_ net106 _0402_ vssd1 vssd1 vccd1 vccd1 _0445_ sky130_fd_sc_hd__nand2_1
X_0854_ MATMULT_INST.cntrl.state\[3\] MATMULT_INST.cntrl.state\[2\] _0094_ _0387_
+ vssd1 vssd1 vccd1 vccd1 _0388_ sky130_fd_sc_hd__a31o_1
X_0785_ _0332_ _0338_ _0339_ _0330_ vssd1 vssd1 vccd1 vccd1 _0341_ sky130_fd_sc_hd__a31o_1
Xhold19 MATMULT_INST.uart_rcv.tim.bit_cnt\[2\] vssd1 vssd1 vccd1 vccd1 net122 sky130_fd_sc_hd__dlygate4sd3_1
XFILLER_36_183 vccd1 vssd1 vccd1 vssd1 sky130_ef_sc_hd__decap_40_12
XFILLER_3_249 vssd1 vssd1 vccd1 vccd1 sky130_fd_sc_hd__fill_4
XFILLER_19_52 vssd1 vssd1 vccd1 vccd1 sky130_fd_sc_hd__fill_4
X_0570_ net16 MATMULT_INST.uart_tx.count.next_cnt_out\[6\] vssd1 vssd1 vccd1 vccd1
+ _0164_ sky130_fd_sc_hd__xnor2_1
X_0906_ _0428_ _0429_ vssd1 vssd1 vccd1 vccd1 _0430_ sky130_fd_sc_hd__xnor2_1
X_0837_ MATMULT_INST.parallel_out1\[4\] MATMULT_INST.rx_data\[4\] _0092_ vssd1 vssd1
+ vccd1 vccd1 _0034_ sky130_fd_sc_hd__mux2_1
XFILLER_0_219 vssd1 vssd1 vccd1 vccd1 sky130_fd_sc_hd__fill_1
X_0699_ MATMULT_INST.prod_adder.gen_for_loop\[2\].adder_n.a _0270_ _0272_ vssd1 vssd1
+ vccd1 vccd1 _0273_ sky130_fd_sc_hd__nor3_1
X_0768_ MATMULT_INST.uart_rcv.data_buff.packet_data\[7\] MATMULT_INST.uart_rcv.sbc.stop_bit
+ net24 vssd1 vssd1 vccd1 vccd1 _0012_ sky130_fd_sc_hd__mux2_1
XFILLER_21_20 vccd1 vssd1 vccd1 vssd1 sky130_ef_sc_hd__decap_40_12
XFILLER_21_53 vssd1 vssd1 vccd1 vccd1 sky130_fd_sc_hd__fill_2
XTAP_TAPCELL_ROW_17_159 vssd1 vccd1 sky130_fd_sc_hd__tapvpwrvgnd_1
X_0484_ MATMULT_INST.cntrl.state\[0\] _0094_ vssd1 vssd1 vccd1 vccd1 _0095_ sky130_fd_sc_hd__nand2_1
X_0553_ MATMULT_INST.uart_tx.clk_cnt\[11\] _0149_ vssd1 vssd1 vccd1 vccd1 _0150_ sky130_fd_sc_hd__and2_1
X_0622_ MATMULT_INST.uart_rcv.tim.clk_cnt\[3\] _0208_ vssd1 vssd1 vccd1 vccd1 _0211_
+ sky130_fd_sc_hd__or2_1
XFILLER_38_201 vssd1 vssd1 vccd1 vccd1 sky130_fd_sc_hd__fill_1
X_1036_ clknet_3_0__leaf_clk _0056_ net25 vssd1 vssd1 vccd1 vccd1 MATMULT_INST.rx_data\[2\]
+ sky130_fd_sc_hd__dfstp_1
XFILLER_21_134 vccd1 vssd1 vccd1 vssd1 sky130_ef_sc_hd__decap_40_12
XFILLER_21_189 vssd1 vssd1 vccd1 vccd1 sky130_fd_sc_hd__fill_2
XFILLER_29_234 vssd1 vssd1 vccd1 vccd1 sky130_fd_sc_hd__fill_1
XFILLER_32_41 vssd1 vssd1 vccd1 vccd1 sky130_fd_sc_hd__fill_2
XFILLER_8_149 vssd1 vssd1 vccd1 vccd1 sky130_fd_sc_hd__fill_1
XFILLER_12_134 vssd1 vssd1 vccd1 vccd1 sky130_fd_sc_hd__fill_1
XTAP_TAPCELL_ROW_22_184 vssd1 vccd1 sky130_fd_sc_hd__tapvpwrvgnd_1
XANTENNA__0765__S net24 vssd1 vssd1 vccd1 vccd1 sky130_fd_sc_hd__diode_2
X_0467_ MATMULT_INST.uart_rcv.tim.clk_cnt\[7\] vssd1 vssd1 vccd1 vccd1 _0080_ sky130_fd_sc_hd__inv_2
X_0605_ _0078_ MATMULT_INST.uart_rcv.tim.clk_cnt\[12\] _0176_ _0177_ _0183_ vssd1
+ vssd1 vccd1 vccd1 _0197_ sky130_fd_sc_hd__o2111a_1
XTAP_TAPCELL_ROW_5_108 vssd1 vccd1 sky130_fd_sc_hd__tapvpwrvgnd_1
X_0536_ _0137_ _0138_ net22 vssd1 vssd1 vccd1 vccd1 _0139_ sky130_fd_sc_hd__or3b_1
X_1019_ clknet_3_7__leaf_clk MATMULT_INST.uart_rcv.control.next_state\[1\] net35 vssd1
+ vssd1 vccd1 vccd1 MATMULT_INST.uart_rcv.control.state\[1\] sky130_fd_sc_hd__dfrtp_1
XFILLER_5_119 vccd1 vssd1 vccd1 vssd1 sky130_ef_sc_hd__decap_40_12
XFILLER_17_237 vssd1 vssd1 vccd1 vccd1 sky130_fd_sc_hd__fill_1
XFILLER_27_96 vssd1 vssd1 vccd1 vccd1 sky130_fd_sc_hd__fill_2
XFILLER_4_141 vssd1 vssd1 vccd1 vccd1 sky130_fd_sc_hd__fill_4
XFILLER_4_163 vssd1 vssd1 vccd1 vccd1 sky130_fd_sc_hd__fill_8
XFILLER_31_251 vssd1 vssd1 vccd1 vccd1 sky130_fd_sc_hd__fill_1
X_0519_ _0123_ _0126_ vssd1 vssd1 vccd1 vccd1 _0127_ sky130_fd_sc_hd__nand2_1
XFILLER_14_218 vssd1 vssd1 vccd1 vccd1 sky130_fd_sc_hd__fill_8
Xfanout33 net36 vssd1 vssd1 vccd1 vccd1 net33 sky130_fd_sc_hd__clkbuf_4
Xfanout22 _0128_ vssd1 vssd1 vccd1 vccd1 net22 sky130_fd_sc_hd__clkbuf_2
XTAP_TAPCELL_ROW_0_79 vssd1 vccd1 sky130_fd_sc_hd__tapvpwrvgnd_1
XFILLER_1_111 vssd1 vssd1 vccd1 vccd1 sky130_fd_sc_hd__fill_1
XFILLER_8_3 vccd1 vssd1 vccd1 vssd1 sky130_ef_sc_hd__decap_40_12
X_0870_ _0093_ _0381_ _0390_ vssd1 vssd1 vccd1 vccd1 _0041_ sky130_fd_sc_hd__o21ai_1
X_0999_ clknet_3_7__leaf_clk MATMULT_INST.uart_rcv.tim.bit_count.next_cnt_out\[2\]
+ net35 vssd1 vssd1 vccd1 vccd1 MATMULT_INST.uart_rcv.tim.bit_cnt\[2\] sky130_fd_sc_hd__dfrtp_1
XFILLER_24_42 vssd1 vssd1 vccd1 vccd1 sky130_fd_sc_hd__fill_1
XFILLER_1_24 vccd1 vssd1 vccd1 vssd1 sky130_ef_sc_hd__decap_40_12
XFILLER_1_57 vccd1 vssd1 vccd1 vssd1 sky130_ef_sc_hd__decap_40_12
X_0922_ MATMULT_INST.parallel_out2\[7\] MATMULT_INST.parallel_out2\[3\] _0438_ _0441_
+ vssd1 vssd1 vccd1 vccd1 _0444_ sky130_fd_sc_hd__and4_1
X_0853_ MATMULT_INST.cntrl.state\[0\] _0386_ vssd1 vssd1 vccd1 vccd1 _0387_ sky130_fd_sc_hd__nor2_1
X_0784_ _0338_ _0339_ _0332_ vssd1 vssd1 vccd1 vccd1 _0340_ sky130_fd_sc_hd__a21oi_1
Xinput1 en vssd1 vssd1 vccd1 vccd1 net1 sky130_fd_sc_hd__clkbuf_1
XFILLER_36_195 vssd1 vssd1 vccd1 vccd1 sky130_fd_sc_hd__fill_1
XANTENNA__0945__RESET_B net30 vssd1 vssd1 vccd1 vccd1 sky130_fd_sc_hd__diode_2
XPHY_EDGE_ROW_27_Left_66 vssd1 vssd1 vccd1 vccd1 sky130_fd_sc_hd__decap_3
XANTENNA__0768__S net24 vssd1 vssd1 vccd1 vccd1 sky130_fd_sc_hd__diode_2
XFILLER_18_151 vssd1 vssd1 vccd1 vccd1 sky130_fd_sc_hd__fill_2
X_0905_ MATMULT_INST.parallel_out2\[5\] MATMULT_INST.parallel_out2\[3\] vssd1 vssd1
+ vccd1 vccd1 _0429_ sky130_fd_sc_hd__and2_1
X_0836_ MATMULT_INST.parallel_out1\[3\] MATMULT_INST.rx_data\[3\] _0092_ vssd1 vssd1
+ vccd1 vccd1 _0033_ sky130_fd_sc_hd__mux2_1
X_0767_ MATMULT_INST.uart_rcv.data_buff.packet_data\[6\] MATMULT_INST.uart_rcv.data_buff.packet_data\[7\]
+ net24 vssd1 vssd1 vccd1 vccd1 _0011_ sky130_fd_sc_hd__mux2_1
X_0698_ MATMULT_INST.prod_adder.gen_for_loop\[1\].adder_n.b MATMULT_INST.prod_adder.gen_for_loop\[1\].adder_n.a
+ MATMULT_INST.prod_adder.gen_for_loop\[0\].adder_n.b MATMULT_INST.prod_adder.gen_for_loop\[0\].adder_n.a
+ vssd1 vssd1 vccd1 vccd1 _0272_ sky130_fd_sc_hd__o211a_1
XFILLER_0_209 vssd1 vssd1 vccd1 vccd1 sky130_fd_sc_hd__fill_4
XFILLER_21_32 vssd1 vssd1 vccd1 vccd1 sky130_fd_sc_hd__fill_8
XFILLER_15_132 vssd1 vssd1 vccd1 vccd1 sky130_fd_sc_hd__fill_1
XFILLER_7_34 vssd1 vssd1 vccd1 vccd1 sky130_fd_sc_hd__fill_1
X_0621_ MATMULT_INST.uart_rcv.tim.clk_cnt\[1\] MATMULT_INST.uart_rcv.tim.clk_cnt\[2\]
+ MATMULT_INST.uart_rcv.tim.clk_cnt\[3\] _0203_ vssd1 vssd1 vccd1 vccd1 _0210_ sky130_fd_sc_hd__and4_1
X_0483_ MATMULT_INST.cntrl.state\[4\] MATMULT_INST.cntrl.state\[1\] vssd1 vssd1 vccd1
+ vccd1 _0094_ sky130_fd_sc_hd__nor2_1
XFILLER_23_3 vccd1 vssd1 vccd1 vssd1 sky130_ef_sc_hd__decap_40_12
X_0552_ _0149_ net22 _0148_ vssd1 vssd1 vccd1 vccd1 MATMULT_INST.uart_tx.count.next_cnt_out\[10\]
+ sky130_fd_sc_hd__and3b_1
X_1035_ clknet_3_0__leaf_clk _0055_ net25 vssd1 vssd1 vccd1 vccd1 MATMULT_INST.rx_data\[1\]
+ sky130_fd_sc_hd__dfstp_1
XFILLER_21_113 vccd1 vssd1 vccd1 vssd1 sky130_ef_sc_hd__decap_40_12
XFILLER_21_146 vccd1 vssd1 vccd1 vssd1 sky130_ef_sc_hd__decap_40_12
X_0819_ MATMULT_INST.prod_adder.gen_for_loop\[5\].adder_n.a _0371_ _0329_ vssd1 vssd1
+ vccd1 vccd1 _0019_ sky130_fd_sc_hd__mux2_1
XFILLER_16_65 vccd1 vssd1 vccd1 vssd1 sky130_ef_sc_hd__decap_40_12
XANTENNA__1041__SET_B net30 vssd1 vssd1 vccd1 vccd1 sky130_fd_sc_hd__diode_2
XANTENNA_fanout30_A net37 vssd1 vssd1 vccd1 vccd1 sky130_fd_sc_hd__diode_2
XFILLER_32_20 vssd1 vssd1 vccd1 vccd1 sky130_fd_sc_hd__fill_1
XTAP_TAPCELL_ROW_22_185 vssd1 vccd1 sky130_fd_sc_hd__tapvpwrvgnd_1
XTAP_TAPCELL_ROW_13_141 vssd1 vccd1 sky130_fd_sc_hd__tapvpwrvgnd_1
X_0604_ _0077_ MATMULT_INST.uart_rcv.tim.clk_cnt\[11\] _0181_ _0182_ _0186_ vssd1
+ vssd1 vccd1 vccd1 _0196_ sky130_fd_sc_hd__o2111a_1
XPHY_EDGE_ROW_9_Right_9 vssd1 vssd1 vccd1 vccd1 sky130_fd_sc_hd__decap_3
X_0535_ MATMULT_INST.uart_tx.clk_cnt\[4\] _0133_ MATMULT_INST.uart_tx.clk_cnt\[5\]
+ vssd1 vssd1 vccd1 vccd1 _0138_ sky130_fd_sc_hd__a21oi_1
X_0466_ net8 vssd1 vssd1 vccd1 vccd1 _0079_ sky130_fd_sc_hd__inv_2
XTAP_TAPCELL_ROW_36_244 vssd1 vccd1 sky130_fd_sc_hd__tapvpwrvgnd_1
XPHY_EDGE_ROW_14_Left_53 vssd1 vssd1 vccd1 vccd1 sky130_fd_sc_hd__decap_3
X_1018_ clknet_3_7__leaf_clk MATMULT_INST.uart_rcv.control.next_state\[0\] net35 vssd1
+ vssd1 vccd1 vccd1 MATMULT_INST.uart_rcv.control.state\[0\] sky130_fd_sc_hd__dfrtp_2
XANTENNA__0928__A2 _0447_ vssd1 vssd1 vccd1 vccd1 sky130_fd_sc_hd__diode_2
XFILLER_4_197 vccd1 vssd1 vccd1 vssd1 sky130_ef_sc_hd__decap_40_12
XFILLER_4_57 vssd1 vssd1 vccd1 vccd1 sky130_fd_sc_hd__fill_2
X_0518_ _0116_ _0118_ _0124_ _0125_ vssd1 vssd1 vccd1 vccd1 _0126_ sky130_fd_sc_hd__nor4_1
X_0449_ MATMULT_INST.uart_rcv.tim.bit_cnt\[3\] vssd1 vssd1 vccd1 vccd1 _0062_ sky130_fd_sc_hd__inv_2
Xfanout34 net36 vssd1 vssd1 vccd1 vccd1 net34 sky130_fd_sc_hd__clkbuf_4
XFILLER_13_99 vssd1 vssd1 vccd1 vccd1 sky130_fd_sc_hd__fill_2
XFILLER_38_41 vccd1 vssd1 vccd1 vssd1 sky130_ef_sc_hd__decap_40_12
XFILLER_1_134 vccd1 vssd1 vccd1 vssd1 sky130_ef_sc_hd__decap_40_12
XFILLER_1_167 vssd1 vssd1 vccd1 vccd1 sky130_fd_sc_hd__fill_1
XANTENNA_input10_A gpio_in[2] vssd1 vssd1 vccd1 vccd1 sky130_fd_sc_hd__diode_2
XFILLER_9_234 vssd1 vssd1 vccd1 vccd1 sky130_fd_sc_hd__fill_1
XTAP_TAPCELL_ROW_30_217 vssd1 vccd1 sky130_fd_sc_hd__tapvpwrvgnd_1
XANTENNA__1010__RESET_B net30 vssd1 vssd1 vccd1 vccd1 sky130_fd_sc_hd__diode_2
X_0998_ clknet_3_7__leaf_clk MATMULT_INST.uart_rcv.tim.bit_count.next_cnt_out\[1\]
+ net35 vssd1 vssd1 vccd1 vccd1 MATMULT_INST.uart_rcv.tim.bit_cnt\[1\] sky130_fd_sc_hd__dfrtp_1
XANTENNA_input2_A gpio_in[0] vssd1 vssd1 vccd1 vccd1 sky130_fd_sc_hd__diode_2
XFILLER_10_200 vssd1 vssd1 vccd1 vccd1 sky130_fd_sc_hd__fill_2
XFILLER_1_36 vccd1 vssd1 vccd1 vssd1 sky130_ef_sc_hd__decap_40_12
XFILLER_1_69 vccd1 vssd1 vccd1 vssd1 sky130_ef_sc_hd__decap_40_12
X_0921_ MATMULT_INST.parallel_out2\[7\] MATMULT_INST.parallel_out2\[3\] _0438_ _0441_
+ vssd1 vssd1 vccd1 vccd1 _0443_ sky130_fd_sc_hd__a22oi_1
X_0783_ _0336_ _0337_ _0335_ vssd1 vssd1 vccd1 vccd1 _0339_ sky130_fd_sc_hd__o21ai_1
X_0852_ _0089_ _0093_ vssd1 vssd1 vccd1 vccd1 _0386_ sky130_fd_sc_hd__or2_1
XTAP_TAPCELL_ROW_1_90 vssd1 vccd1 sky130_fd_sc_hd__tapvpwrvgnd_1
XANTENNA_clkbuf_3_0__f_clk_A clknet_0_clk vssd1 vssd1 vccd1 vccd1 sky130_fd_sc_hd__diode_2
Xinput2 gpio_in[0] vssd1 vssd1 vccd1 vccd1 net2 sky130_fd_sc_hd__clkbuf_1
XPHY_EDGE_ROW_2_Left_41 vssd1 vssd1 vccd1 vccd1 sky130_fd_sc_hd__decap_3
XFILLER_33_111 vssd1 vssd1 vccd1 vccd1 sky130_fd_sc_hd__fill_1
X_0904_ MATMULT_INST.parallel_out2\[2\] _0426_ _0427_ vssd1 vssd1 vccd1 vccd1 _0428_
+ sky130_fd_sc_hd__a21bo_1
X_0697_ MATMULT_INST.prod_adder.gen_for_loop\[0\].adder_n.b MATMULT_INST.prod_adder.gen_for_loop\[0\].adder_n.a
+ vssd1 vssd1 vccd1 vccd1 _0271_ sky130_fd_sc_hd__nand2_1
X_0835_ MATMULT_INST.parallel_out1\[2\] MATMULT_INST.rx_data\[2\] _0092_ vssd1 vssd1
+ vccd1 vccd1 _0032_ sky130_fd_sc_hd__mux2_1
X_0766_ MATMULT_INST.uart_rcv.data_buff.packet_data\[5\] MATMULT_INST.uart_rcv.data_buff.packet_data\[6\]
+ net24 vssd1 vssd1 vccd1 vccd1 _0010_ sky130_fd_sc_hd__mux2_1
XFILLER_21_55 vssd1 vssd1 vccd1 vccd1 sky130_fd_sc_hd__fill_1
XFILLER_21_99 vccd1 vssd1 vccd1 vssd1 sky130_ef_sc_hd__decap_40_12
XFILLER_15_111 vssd1 vssd1 vccd1 vccd1 sky130_fd_sc_hd__fill_1
XFILLER_15_166 vssd1 vssd1 vccd1 vccd1 sky130_fd_sc_hd__fill_2
XFILLER_15_199 vssd1 vssd1 vccd1 vccd1 sky130_fd_sc_hd__fill_4
XFILLER_30_125 vssd1 vssd1 vccd1 vccd1 sky130_fd_sc_hd__fill_2
X_0620_ _0208_ _0209_ net21 vssd1 vssd1 vccd1 vccd1 MATMULT_INST.uart_rcv.tim.clock_count.next_cnt_out\[2\]
+ sky130_fd_sc_hd__and3b_1
XFILLER_7_57 vccd1 vssd1 vccd1 vssd1 sky130_ef_sc_hd__decap_40_12
X_0551_ MATMULT_INST.uart_tx.clk_cnt\[9\] MATMULT_INST.uart_tx.clk_cnt\[10\] _0144_
+ vssd1 vssd1 vccd1 vccd1 _0149_ sky130_fd_sc_hd__and3_1
XFILLER_16_3 vccd1 vssd1 vccd1 vssd1 sky130_ef_sc_hd__decap_40_12
X_0482_ _0065_ MATMULT_INST.cntrl.state\[2\] vssd1 vssd1 vccd1 vccd1 _0093_ sky130_fd_sc_hd__nand2_2
X_1034_ clknet_3_0__leaf_clk _0054_ net25 vssd1 vssd1 vccd1 vccd1 MATMULT_INST.rx_data\[0\]
+ sky130_fd_sc_hd__dfstp_1
XFILLER_21_125 vssd1 vssd1 vccd1 vccd1 sky130_fd_sc_hd__fill_2
XFILLER_21_158 vssd1 vssd1 vccd1 vccd1 sky130_fd_sc_hd__fill_8
XTAP_TAPCELL_ROW_8_118 vssd1 vccd1 sky130_fd_sc_hd__tapvpwrvgnd_1
X_0818_ _0368_ _0370_ vssd1 vssd1 vccd1 vccd1 _0371_ sky130_fd_sc_hd__xnor2_1
X_0749_ net18 net1 vssd1 vssd1 vccd1 vccd1 MATMULT_INST.cntrl.n_rst sky130_fd_sc_hd__and2_1
XFILLER_29_225 vssd1 vssd1 vccd1 vccd1 sky130_fd_sc_hd__fill_2
XFILLER_29_247 vssd1 vssd1 vccd1 vccd1 sky130_fd_sc_hd__fill_2
XFILLER_16_77 vssd1 vssd1 vccd1 vccd1 sky130_fd_sc_hd__fill_4
XFILLER_32_76 vssd1 vssd1 vccd1 vccd1 sky130_fd_sc_hd__fill_4
XTAP_TAPCELL_ROW_13_142 vssd1 vccd1 sky130_fd_sc_hd__tapvpwrvgnd_1
X_0603_ MATMULT_INST.uart_rcv.tim.clk_cnt\[2\] net12 vssd1 vssd1 vccd1 vccd1 _0195_
+ sky130_fd_sc_hd__nand2b_1
X_0534_ MATMULT_INST.uart_tx.clk_cnt\[4\] MATMULT_INST.uart_tx.clk_cnt\[5\] _0133_
+ vssd1 vssd1 vccd1 vccd1 _0137_ sky130_fd_sc_hd__and3_1
X_0465_ net7 vssd1 vssd1 vccd1 vccd1 _0078_ sky130_fd_sc_hd__inv_2
XTAP_TAPCELL_ROW_36_245 vssd1 vccd1 sky130_fd_sc_hd__tapvpwrvgnd_1
X_1017_ clknet_3_7__leaf_clk _0043_ net34 vssd1 vssd1 vccd1 vccd1 MATMULT_INST.cntrl.framing_error
+ sky130_fd_sc_hd__dfrtp_1
XFILLER_27_76 vssd1 vssd1 vccd1 vccd1 sky130_fd_sc_hd__fill_2
XPHY_EDGE_ROW_31_Left_70 vssd1 vssd1 vccd1 vccd1 sky130_fd_sc_hd__decap_3
X_0517_ MATMULT_INST.uart_tx.clk_cnt\[11\] _0077_ _0107_ _0109_ _0113_ vssd1 vssd1
+ vccd1 vccd1 _0125_ sky130_fd_sc_hd__a2111o_1
Xfanout24 MATMULT_INST.uart_rcv.shift_strobe vssd1 vssd1 vccd1 vccd1 net24 sky130_fd_sc_hd__clkbuf_4
Xfanout35 net36 vssd1 vssd1 vccd1 vccd1 net35 sky130_fd_sc_hd__buf_2
XFILLER_22_253 vssd1 vssd1 vccd1 vccd1 sky130_fd_sc_hd__fill_2
XFILLER_1_113 vssd1 vssd1 vccd1 vccd1 sky130_fd_sc_hd__fill_2
XFILLER_38_53 vssd1 vssd1 vccd1 vccd1 sky130_fd_sc_hd__fill_2
XFILLER_1_146 vssd1 vssd1 vccd1 vccd1 sky130_fd_sc_hd__fill_2
XTAP_TAPCELL_ROW_30_218 vssd1 vccd1 sky130_fd_sc_hd__tapvpwrvgnd_1
X_0997_ clknet_3_7__leaf_clk net118 net35 vssd1 vssd1 vccd1 vccd1 MATMULT_INST.uart_rcv.tim.bit_cnt\[0\]
+ sky130_fd_sc_hd__dfrtp_1
XFILLER_6_216 vssd1 vssd1 vccd1 vccd1 sky130_fd_sc_hd__fill_2
XFILLER_6_249 vssd1 vssd1 vccd1 vccd1 sky130_fd_sc_hd__fill_2
XFILLER_1_48 vssd1 vssd1 vccd1 vccd1 sky130_fd_sc_hd__fill_8
X_0920_ _0442_ MATMULT_INST.prod_adder.gen_for_loop\[5\].adder_n.b _0402_ vssd1 vssd1
+ vccd1 vccd1 _0049_ sky130_fd_sc_hd__mux2_1
X_0782_ _0335_ _0336_ _0337_ vssd1 vssd1 vccd1 vccd1 _0338_ sky130_fd_sc_hd__or3_1
X_0851_ MATMULT_INST.cntrl.overrun_error MATMULT_INST.cntrl.framing_error _0375_ vssd1
+ vssd1 vccd1 vccd1 _0385_ sky130_fd_sc_hd__or3_1
XPHY_EDGE_ROW_18_Right_18 vssd1 vssd1 vccd1 vccd1 sky130_fd_sc_hd__decap_3
Xinput3 gpio_in[10] vssd1 vssd1 vccd1 vccd1 net3 sky130_fd_sc_hd__clkbuf_2
XPHY_EDGE_ROW_27_Right_27 vssd1 vssd1 vccd1 vccd1 sky130_fd_sc_hd__decap_3
XPHY_EDGE_ROW_36_Right_36 vssd1 vssd1 vccd1 vccd1 sky130_fd_sc_hd__decap_3
XFILLER_3_208 vccd1 vssd1 vccd1 vssd1 sky130_ef_sc_hd__decap_40_12
XANTENNA__0954__RESET_B net30 vssd1 vssd1 vccd1 vccd1 sky130_fd_sc_hd__diode_2
XFILLER_27_153 vssd1 vssd1 vccd1 vccd1 sky130_fd_sc_hd__fill_1
XFILLER_35_98 vssd1 vssd1 vccd1 vccd1 sky130_fd_sc_hd__fill_1
XFILLER_35_65 vssd1 vssd1 vccd1 vccd1 sky130_fd_sc_hd__fill_2
XFILLER_35_10 vssd1 vssd1 vccd1 vccd1 sky130_fd_sc_hd__fill_1
XFILLER_33_134 vssd1 vssd1 vccd1 vccd1 sky130_fd_sc_hd__fill_2
XFILLER_18_197 vssd1 vssd1 vccd1 vccd1 sky130_fd_sc_hd__fill_4
X_0903_ MATMULT_INST.parallel_out2\[6\] MATMULT_INST.parallel_out2\[2\] MATMULT_INST.parallel_out2\[7\]
+ MATMULT_INST.parallel_out2\[1\] vssd1 vssd1 vccd1 vccd1 _0427_ sky130_fd_sc_hd__a22o_1
X_0834_ MATMULT_INST.parallel_out1\[1\] MATMULT_INST.rx_data\[1\] _0092_ vssd1 vssd1
+ vccd1 vccd1 _0031_ sky130_fd_sc_hd__mux2_1
X_0696_ MATMULT_INST.prod_adder.gen_for_loop\[1\].adder_n.b MATMULT_INST.prod_adder.gen_for_loop\[1\].adder_n.a
+ vssd1 vssd1 vccd1 vccd1 _0270_ sky130_fd_sc_hd__and2_1
X_0765_ MATMULT_INST.uart_rcv.data_buff.packet_data\[4\] MATMULT_INST.uart_rcv.data_buff.packet_data\[5\]
+ net24 vssd1 vssd1 vccd1 vccd1 _0009_ sky130_fd_sc_hd__mux2_1
XTAP_TAPCELL_ROW_19_170 vssd1 vccd1 sky130_fd_sc_hd__tapvpwrvgnd_1
XFILLER_24_189 vssd1 vssd1 vccd1 vccd1 sky130_fd_sc_hd__fill_1
XTAP_TAPCELL_ROW_25_195 vssd1 vccd1 sky130_fd_sc_hd__tapvpwrvgnd_1
XFILLER_30_137 vssd1 vssd1 vccd1 vccd1 sky130_fd_sc_hd__fill_2
XFILLER_7_69 vssd1 vssd1 vccd1 vccd1 sky130_fd_sc_hd__fill_1
X_0550_ MATMULT_INST.uart_tx.clk_cnt\[10\] _0147_ vssd1 vssd1 vccd1 vccd1 _0148_ sky130_fd_sc_hd__or2_1
X_0481_ _0089_ _0091_ vssd1 vssd1 vccd1 vccd1 _0092_ sky130_fd_sc_hd__nor2_4
X_1033_ clknet_3_7__leaf_clk net9 net34 vssd1 vssd1 vccd1 vccd1 MATMULT_INST.uart_rcv.sbd.sync_phase
+ sky130_fd_sc_hd__dfstp_1
X_0817_ _0366_ _0369_ vssd1 vssd1 vccd1 vccd1 _0370_ sky130_fd_sc_hd__nand2b_1
X_0679_ MATMULT_INST.uart_rcv.control.state\[2\] MATMULT_INST.uart_rcv.control.state\[0\]
+ vssd1 vssd1 vccd1 vccd1 _0256_ sky130_fd_sc_hd__nand2b_1
XTAP_TAPCELL_ROW_8_119 vssd1 vccd1 sky130_fd_sc_hd__tapvpwrvgnd_1
X_0748_ _0263_ _0293_ _0320_ vssd1 vssd1 vccd1 vccd1 MATMULT_INST.serial_out sky130_fd_sc_hd__o21ai_1
XFILLER_29_204 vssd1 vssd1 vccd1 vccd1 sky130_fd_sc_hd__fill_1
XPHY_EDGE_ROW_0_Right_0 vssd1 vssd1 vccd1 vccd1 sky130_fd_sc_hd__decap_3
XFILLER_12_148 vccd1 vssd1 vccd1 vssd1 sky130_ef_sc_hd__decap_40_12
XTAP_TAPCELL_ROW_13_143 vssd1 vccd1 sky130_fd_sc_hd__tapvpwrvgnd_1
X_0602_ _0175_ _0190_ _0192_ _0193_ vssd1 vssd1 vccd1 vccd1 _0194_ sky130_fd_sc_hd__and4_1
X_0533_ _0136_ vssd1 vssd1 vccd1 vccd1 MATMULT_INST.uart_tx.count.next_cnt_out\[4\]
+ sky130_fd_sc_hd__inv_2
X_0464_ net6 vssd1 vssd1 vccd1 vccd1 _0077_ sky130_fd_sc_hd__inv_2
X_1016_ clknet_3_6__leaf_clk MATMULT_INST.uart_rcv.tim.clock_count.next_roflag net36
+ vssd1 vssd1 vccd1 vccd1 MATMULT_INST.uart_rcv.shift_strobe sky130_fd_sc_hd__dfrtp_1
XTAP_TAPCELL_ROW_36_246 vssd1 vccd1 sky130_fd_sc_hd__tapvpwrvgnd_1
XTAP_TAPCELL_ROW_4_100 vssd1 vccd1 sky130_fd_sc_hd__tapvpwrvgnd_1
XFILLER_4_59 vssd1 vssd1 vccd1 vccd1 sky130_fd_sc_hd__fill_1
XFILLER_4_26 vssd1 vssd1 vccd1 vccd1 sky130_fd_sc_hd__fill_2
XFILLER_16_240 vssd1 vssd1 vccd1 vccd1 sky130_fd_sc_hd__fill_4
X_0516_ MATMULT_INST.uart_tx.clk_cnt\[10\] _0076_ _0105_ _0106_ _0108_ vssd1 vssd1
+ vccd1 vccd1 _0124_ sky130_fd_sc_hd__a2111o_1
Xfanout25 net27 vssd1 vssd1 vccd1 vccd1 net25 sky130_fd_sc_hd__clkbuf_4
Xfanout36 net37 vssd1 vssd1 vccd1 vccd1 net36 sky130_fd_sc_hd__clkbuf_2
XFILLER_9_203 vssd1 vssd1 vccd1 vccd1 sky130_fd_sc_hd__fill_2
XFILLER_9_214 vssd1 vssd1 vccd1 vccd1 sky130_fd_sc_hd__fill_4
XTAP_TAPCELL_ROW_30_219 vssd1 vccd1 sky130_fd_sc_hd__tapvpwrvgnd_1
XFILLER_0_191 vssd1 vssd1 vccd1 vccd1 sky130_fd_sc_hd__fill_1
X_0996_ clknet_3_7__leaf_clk _0042_ net34 vssd1 vssd1 vccd1 vccd1 MATMULT_INST.cntrl.state\[4\]
+ sky130_fd_sc_hd__dfrtp_2
XFILLER_10_213 vssd1 vssd1 vccd1 vccd1 sky130_fd_sc_hd__fill_4
XFILLER_10_224 vssd1 vssd1 vccd1 vccd1 sky130_fd_sc_hd__fill_1
XFILLER_24_78 vssd1 vssd1 vccd1 vccd1 sky130_fd_sc_hd__fill_4
X_0850_ _0378_ _0383_ vssd1 vssd1 vccd1 vccd1 _0384_ sky130_fd_sc_hd__nand2_2
X_0781_ MATMULT_INST.parallel_out1\[5\] MATMULT_INST.parallel_out1\[1\] MATMULT_INST.parallel_out1\[6\]
+ MATMULT_INST.parallel_out1\[0\] vssd1 vssd1 vccd1 vccd1 _0337_ sky130_fd_sc_hd__a22oi_1
Xinput4 gpio_in[11] vssd1 vssd1 vccd1 vccd1 net4 sky130_fd_sc_hd__clkbuf_2
X_0979_ clknet_3_1__leaf_clk _0025_ net27 vssd1 vssd1 vccd1 vccd1 MATMULT_INST.parallel_out2\[3\]
+ sky130_fd_sc_hd__dfstp_1
XFILLER_27_110 vssd1 vssd1 vccd1 vccd1 sky130_fd_sc_hd__fill_2
XANTENNA__0994__RESET_B net37 vssd1 vssd1 vccd1 vccd1 sky130_fd_sc_hd__diode_2
XFILLER_2_253 vssd1 vssd1 vccd1 vccd1 sky130_fd_sc_hd__fill_2
XFILLER_33_113 vssd1 vssd1 vccd1 vccd1 sky130_fd_sc_hd__fill_4
X_0902_ MATMULT_INST.parallel_out2\[1\] MATMULT_INST.parallel_out2\[6\] MATMULT_INST.parallel_out2\[7\]
+ vssd1 vssd1 vccd1 vccd1 _0426_ sky130_fd_sc_hd__and3_1
X_0833_ MATMULT_INST.parallel_out1\[0\] MATMULT_INST.rx_data\[0\] _0092_ vssd1 vssd1
+ vccd1 vccd1 _0030_ sky130_fd_sc_hd__mux2_1
X_0695_ MATMULT_INST.prod_adder.gen_for_loop\[1\].adder_n.b MATMULT_INST.prod_adder.gen_for_loop\[1\].adder_n.a
+ vssd1 vssd1 vccd1 vccd1 _0269_ sky130_fd_sc_hd__nor2_1
X_0764_ MATMULT_INST.uart_rcv.data_buff.packet_data\[3\] MATMULT_INST.uart_rcv.data_buff.packet_data\[4\]
+ net24 vssd1 vssd1 vccd1 vccd1 _0008_ sky130_fd_sc_hd__mux2_1
XFILLER_2_81 vssd1 vssd1 vccd1 vccd1 sky130_fd_sc_hd__fill_2
XTAP_TAPCELL_ROW_19_171 vssd1 vccd1 sky130_fd_sc_hd__tapvpwrvgnd_1
XFILLER_21_68 vccd1 vssd1 vccd1 vssd1 sky130_ef_sc_hd__decap_40_12
XFILLER_15_113 vccd1 vssd1 vccd1 vssd1 sky130_ef_sc_hd__decap_40_12
XFILLER_15_146 vssd1 vssd1 vccd1 vccd1 sky130_fd_sc_hd__fill_2
XTAP_TAPCELL_ROW_25_196 vssd1 vccd1 sky130_fd_sc_hd__tapvpwrvgnd_1
X_0480_ MATMULT_INST.cntrl.state\[0\] _0090_ vssd1 vssd1 vccd1 vccd1 _0091_ sky130_fd_sc_hd__or2_1
X_1032_ clknet_3_7__leaf_clk net105 net35 vssd1 vssd1 vccd1 vccd1 MATMULT_INST.uart_rcv.sbd.old_sample
+ sky130_fd_sc_hd__dfstp_1
X_0747_ _0295_ _0296_ _0297_ _0315_ _0319_ vssd1 vssd1 vccd1 vccd1 _0320_ sky130_fd_sc_hd__o311a_1
X_0816_ MATMULT_INST.parallel_out1\[2\] MATMULT_INST.parallel_out1\[7\] MATMULT_INST.parallel_out1\[3\]
+ MATMULT_INST.parallel_out1\[6\] vssd1 vssd1 vccd1 vccd1 _0369_ sky130_fd_sc_hd__a22o_1
X_0678_ _0247_ _0251_ _0255_ vssd1 vssd1 vccd1 vccd1 MATMULT_INST.uart_rcv.tim.clock_count.next_roflag
+ sky130_fd_sc_hd__and3_1
XFILLER_32_12 vssd1 vssd1 vccd1 vccd1 sky130_fd_sc_hd__fill_4
X_0601_ _0068_ MATMULT_INST.uart_rcv.tim.clk_cnt\[0\] MATMULT_INST.uart_rcv.tim.clk_cnt\[13\]
+ _0079_ vssd1 vssd1 vccd1 vccd1 _0193_ sky130_fd_sc_hd__o2bb2a_1
XFILLER_7_175 vssd1 vssd1 vccd1 vccd1 sky130_fd_sc_hd__fill_1
XTAP_TAPCELL_ROW_13_144 vssd1 vccd1 sky130_fd_sc_hd__tapvpwrvgnd_1
X_0532_ MATMULT_INST.uart_tx.clk_cnt\[4\] _0133_ _0135_ vssd1 vssd1 vccd1 vccd1 _0136_
+ sky130_fd_sc_hd__a21o_1
X_0463_ net5 vssd1 vssd1 vccd1 vccd1 _0076_ sky130_fd_sc_hd__inv_2
XTAP_TAPCELL_ROW_36_247 vssd1 vccd1 sky130_fd_sc_hd__tapvpwrvgnd_1
X_1015_ clknet_3_6__leaf_clk MATMULT_INST.uart_rcv.tim.clock_count.next_cnt_out\[13\]
+ net33 vssd1 vssd1 vccd1 vccd1 MATMULT_INST.uart_rcv.tim.clk_cnt\[13\] sky130_fd_sc_hd__dfrtp_1
XFILLER_26_208 vccd1 vssd1 vccd1 vssd1 sky130_ef_sc_hd__decap_40_12
XTAP_TAPCELL_ROW_4_101 vssd1 vccd1 sky130_fd_sc_hd__tapvpwrvgnd_1
XFILLER_4_101 vccd1 vssd1 vccd1 vssd1 sky130_ef_sc_hd__decap_40_12
XFILLER_31_233 vccd1 vssd1 vccd1 vssd1 sky130_ef_sc_hd__decap_40_12
XPHY_EDGE_ROW_18_Left_57 vssd1 vssd1 vccd1 vccd1 sky130_fd_sc_hd__decap_3
X_0515_ _0119_ _0120_ _0121_ _0122_ vssd1 vssd1 vccd1 vccd1 _0123_ sky130_fd_sc_hd__and4_1
Xfanout26 net27 vssd1 vssd1 vccd1 vccd1 net26 sky130_fd_sc_hd__clkbuf_4
Xfanout37 MATMULT_INST.cntrl.n_rst vssd1 vssd1 vccd1 vccd1 net37 sky130_fd_sc_hd__buf_2
XFILLER_1_115 vssd1 vssd1 vccd1 vccd1 sky130_fd_sc_hd__fill_1
XFILLER_38_55 vssd1 vssd1 vccd1 vccd1 sky130_fd_sc_hd__fill_1
XANTENNA__0481__Y _0092_ vssd1 vssd1 vccd1 vccd1 sky130_fd_sc_hd__diode_2
XFILLER_0_181 vssd1 vssd1 vccd1 vccd1 sky130_fd_sc_hd__fill_8
X_0995_ clknet_3_5__leaf_clk _0041_ net32 vssd1 vssd1 vccd1 vccd1 MATMULT_INST.cntrl.state\[3\]
+ sky130_fd_sc_hd__dfrtp_2
XANTENNA__0930__B1 _0447_ vssd1 vssd1 vccd1 vccd1 sky130_fd_sc_hd__diode_2
X_0780_ MATMULT_INST.parallel_out1\[0\] MATMULT_INST.parallel_out1\[5\] MATMULT_INST.parallel_out1\[1\]
+ MATMULT_INST.parallel_out1\[6\] vssd1 vssd1 vccd1 vccd1 _0336_ sky130_fd_sc_hd__and4_1
Xinput5 gpio_in[12] vssd1 vssd1 vccd1 vccd1 net5 sky130_fd_sc_hd__clkbuf_2
X_0978_ clknet_3_1__leaf_clk _0024_ net26 vssd1 vssd1 vccd1 vccd1 MATMULT_INST.parallel_out2\[2\]
+ sky130_fd_sc_hd__dfstp_2
XFILLER_10_15 vccd1 vssd1 vccd1 vssd1 sky130_ef_sc_hd__decap_40_12
XFILLER_35_67 vssd1 vssd1 vccd1 vccd1 sky130_fd_sc_hd__fill_1
XFILLER_19_57 vssd1 vssd1 vccd1 vccd1 sky130_fd_sc_hd__fill_4
XFILLER_2_221 vccd1 vssd1 vccd1 vssd1 sky130_ef_sc_hd__decap_40_12
XFILLER_33_169 vccd1 vssd1 vccd1 vssd1 sky130_ef_sc_hd__decap_40_12
XFILLER_33_147 vssd1 vssd1 vccd1 vccd1 sky130_fd_sc_hd__fill_1
X_0901_ _0425_ MATMULT_INST.prod_adder.gen_for_loop\[3\].adder_n.b _0402_ vssd1 vssd1
+ vccd1 vccd1 _0047_ sky130_fd_sc_hd__mux2_1
X_0832_ MATMULT_INST.parallel_out2\[7\] MATMULT_INST.rx_data\[7\] _0096_ vssd1 vssd1
+ vccd1 vccd1 _0029_ sky130_fd_sc_hd__mux2_1
X_0763_ MATMULT_INST.uart_rcv.data_buff.packet_data\[2\] MATMULT_INST.uart_rcv.data_buff.packet_data\[3\]
+ net24 vssd1 vssd1 vccd1 vccd1 _0007_ sky130_fd_sc_hd__mux2_1
X_0694_ MATMULT_INST.prod_adder.gen_for_loop\[4\].adder_n.b MATMULT_INST.prod_adder.gen_for_loop\[4\].adder_n.a
+ vssd1 vssd1 vccd1 vccd1 _0268_ sky130_fd_sc_hd__or2_1
XFILLER_24_125 vssd1 vssd1 vccd1 vccd1 sky130_fd_sc_hd__fill_1
XPHY_EDGE_ROW_6_Left_45 vssd1 vssd1 vccd1 vccd1 sky130_fd_sc_hd__decap_3
XFILLER_15_158 vssd1 vssd1 vccd1 vccd1 sky130_fd_sc_hd__fill_8
Xmax_cap23 _0126_ vssd1 vssd1 vccd1 vccd1 net23 sky130_fd_sc_hd__clkbuf_1
XTAP_TAPCELL_ROW_25_197 vssd1 vccd1 sky130_fd_sc_hd__tapvpwrvgnd_1
XFILLER_30_139 vssd1 vssd1 vccd1 vccd1 sky130_fd_sc_hd__fill_1
XFILLER_38_239 vssd1 vssd1 vccd1 vccd1 sky130_fd_sc_hd__fill_4
X_1031_ clknet_3_7__leaf_clk net104 net34 vssd1 vssd1 vccd1 vccd1 MATMULT_INST.uart_rcv.sbd.new_sample
+ sky130_fd_sc_hd__dfstp_1
X_0746_ _0278_ _0316_ _0317_ _0318_ vssd1 vssd1 vccd1 vccd1 _0319_ sky130_fd_sc_hd__a211o_1
X_0815_ _0363_ _0367_ vssd1 vssd1 vccd1 vccd1 _0368_ sky130_fd_sc_hd__xnor2_1
X_0677_ _0252_ _0253_ _0254_ vssd1 vssd1 vccd1 vccd1 _0255_ sky130_fd_sc_hd__and3_1
XFILLER_20_150 vssd1 vssd1 vccd1 vccd1 sky130_fd_sc_hd__fill_2
X_0600_ _0071_ MATMULT_INST.uart_rcv.tim.clk_cnt\[3\] _0081_ net4 _0191_ vssd1 vssd1
+ vccd1 vccd1 _0192_ sky130_fd_sc_hd__o221a_1
XFILLER_7_132 vssd1 vssd1 vccd1 vccd1 sky130_fd_sc_hd__fill_2
X_0531_ MATMULT_INST.uart_tx.clk_cnt\[4\] _0133_ net22 vssd1 vssd1 vccd1 vccd1 _0135_
+ sky130_fd_sc_hd__o21ai_1
XFILLER_14_3 vccd1 vssd1 vccd1 vssd1 sky130_ef_sc_hd__decap_40_12
X_0462_ MATMULT_INST.uart_tx.clk_cnt\[10\] vssd1 vssd1 vccd1 vccd1 _0075_ sky130_fd_sc_hd__inv_2
XTAP_TAPCELL_ROW_36_248 vssd1 vccd1 sky130_fd_sc_hd__tapvpwrvgnd_1
X_1014_ clknet_3_6__leaf_clk MATMULT_INST.uart_rcv.tim.clock_count.next_cnt_out\[12\]
+ net33 vssd1 vssd1 vccd1 vccd1 MATMULT_INST.uart_rcv.tim.clk_cnt\[12\] sky130_fd_sc_hd__dfrtp_1
XFILLER_34_253 vssd1 vssd1 vccd1 vccd1 sky130_fd_sc_hd__fill_2
X_0729_ _0299_ _0300_ _0301_ MATMULT_INST.prod_adder.gen_for_loop\[2\].adder_n.b vssd1
+ vssd1 vccd1 vccd1 _0303_ sky130_fd_sc_hd__o22a_1
XTAP_TAPCELL_ROW_4_102 vssd1 vccd1 sky130_fd_sc_hd__tapvpwrvgnd_1
XFILLER_27_24 vssd1 vssd1 vccd1 vccd1 sky130_fd_sc_hd__fill_2
XTAP_TAPCELL_ROW_27_204 vssd1 vccd1 sky130_fd_sc_hd__tapvpwrvgnd_1
XFILLER_4_113 vssd1 vssd1 vccd1 vccd1 sky130_fd_sc_hd__fill_2
XFILLER_16_253 vssd1 vssd1 vccd1 vccd1 sky130_fd_sc_hd__fill_2
XFILLER_17_90 vccd1 vssd1 vccd1 vssd1 sky130_ef_sc_hd__decap_40_12
XFILLER_31_245 vssd1 vssd1 vccd1 vccd1 sky130_fd_sc_hd__fill_4
X_0514_ _0068_ MATMULT_INST.uart_tx.clk_cnt\[0\] _0073_ net17 vssd1 vssd1 vccd1 vccd1
+ _0122_ sky130_fd_sc_hd__o22a_1
XANTENNA_clkbuf_3_3__f_clk_A clknet_0_clk vssd1 vssd1 vccd1 vccd1 sky130_fd_sc_hd__diode_2
Xfanout27 net37 vssd1 vssd1 vccd1 vccd1 net27 sky130_fd_sc_hd__buf_2
XFILLER_22_245 vssd1 vssd1 vccd1 vccd1 sky130_fd_sc_hd__fill_4
XFILLER_1_105 vssd1 vssd1 vccd1 vccd1 sky130_fd_sc_hd__fill_2
XANTENNA_fanout24_X net24 vssd1 vssd1 vccd1 vccd1 sky130_fd_sc_hd__diode_2
XPHY_EDGE_ROW_35_Left_74 vssd1 vssd1 vccd1 vccd1 sky130_fd_sc_hd__decap_3
X_0994_ clknet_3_5__leaf_clk _0040_ net37 vssd1 vssd1 vccd1 vccd1 MATMULT_INST.cntrl.state\[2\]
+ sky130_fd_sc_hd__dfrtp_4
XFILLER_5_82 vccd1 vssd1 vccd1 vssd1 sky130_ef_sc_hd__decap_40_12
XFILLER_24_14 vssd1 vssd1 vccd1 vccd1 sky130_fd_sc_hd__fill_1
XANTENNA__0486__A _0092_ vssd1 vssd1 vccd1 vccd1 sky130_fd_sc_hd__diode_2
XFILLER_5_230 vssd1 vssd1 vccd1 vccd1 sky130_fd_sc_hd__fill_1
XFILLER_5_252 vssd1 vssd1 vccd1 vccd1 sky130_fd_sc_hd__fill_2
Xinput6 gpio_in[13] vssd1 vssd1 vccd1 vccd1 net6 sky130_fd_sc_hd__dlymetal6s2s_1
X_0977_ clknet_3_1__leaf_clk _0023_ net26 vssd1 vssd1 vccd1 vccd1 MATMULT_INST.parallel_out2\[1\]
+ sky130_fd_sc_hd__dfstp_1
XFILLER_10_27 vssd1 vssd1 vccd1 vccd1 sky130_fd_sc_hd__fill_1
XFILLER_35_57 vssd1 vssd1 vccd1 vccd1 sky130_fd_sc_hd__fill_8
XFILLER_35_24 vssd1 vssd1 vccd1 vccd1 sky130_fd_sc_hd__fill_2
XFILLER_27_167 vssd1 vssd1 vccd1 vccd1 sky130_fd_sc_hd__fill_1
XFILLER_27_189 vssd1 vssd1 vccd1 vccd1 sky130_fd_sc_hd__fill_4
XPHY_EDGE_ROW_14_Right_14 vssd1 vssd1 vccd1 vccd1 sky130_fd_sc_hd__decap_3
Xclkbuf_3_3__f_clk clknet_0_clk vssd1 vssd1 vccd1 vccd1 clknet_3_3__leaf_clk sky130_fd_sc_hd__clkbuf_16
XFILLER_2_233 vccd1 vssd1 vccd1 vssd1 sky130_ef_sc_hd__decap_40_12
XPHY_EDGE_ROW_23_Right_23 vssd1 vssd1 vccd1 vccd1 sky130_fd_sc_hd__decap_3
XFILLER_18_123 vssd1 vssd1 vccd1 vccd1 sky130_fd_sc_hd__fill_1
XPHY_EDGE_ROW_32_Right_32 vssd1 vssd1 vccd1 vccd1 sky130_fd_sc_hd__decap_3
X_0900_ _0422_ _0424_ vssd1 vssd1 vccd1 vccd1 _0425_ sky130_fd_sc_hd__xnor2_1
X_0693_ MATMULT_INST.prod_adder.gen_for_loop\[4\].adder_n.b MATMULT_INST.prod_adder.gen_for_loop\[4\].adder_n.a
+ vssd1 vssd1 vccd1 vccd1 _0267_ sky130_fd_sc_hd__nand2_1
X_0762_ MATMULT_INST.uart_rcv.data_buff.packet_data\[1\] MATMULT_INST.uart_rcv.data_buff.packet_data\[2\]
+ net24 vssd1 vssd1 vccd1 vccd1 _0006_ sky130_fd_sc_hd__mux2_1
X_0831_ MATMULT_INST.parallel_out2\[6\] MATMULT_INST.rx_data\[6\] _0096_ vssd1 vssd1
+ vccd1 vccd1 _0028_ sky130_fd_sc_hd__mux2_1
XPHY_EDGE_ROW_22_Left_61 vssd1 vssd1 vccd1 vccd1 sky130_fd_sc_hd__decap_3
XFILLER_2_83 vssd1 vssd1 vccd1 vccd1 sky130_fd_sc_hd__fill_1
XFILLER_24_148 vssd1 vssd1 vccd1 vccd1 sky130_fd_sc_hd__fill_1
XFILLER_15_148 vssd1 vssd1 vccd1 vccd1 sky130_fd_sc_hd__fill_1
XTAP_TAPCELL_ROW_25_198 vssd1 vccd1 sky130_fd_sc_hd__tapvpwrvgnd_1
XFILLER_11_81 vssd1 vssd1 vccd1 vccd1 sky130_fd_sc_hd__fill_1
X_1030_ clknet_3_6__leaf_clk _0053_ net34 vssd1 vssd1 vccd1 vccd1 MATMULT_INST.cntrl.data_ready
+ sky130_fd_sc_hd__dfrtp_1
XTAP_TAPCELL_ROW_16_154 vssd1 vccd1 sky130_fd_sc_hd__tapvpwrvgnd_1
X_0814_ MATMULT_INST.parallel_out1\[5\] MATMULT_INST.parallel_out1\[3\] _0356_ _0355_
+ vssd1 vssd1 vccd1 vccd1 _0367_ sky130_fd_sc_hd__a31o_1
X_0676_ net7 MATMULT_INST.uart_rcv.tim.clock_count.next_cnt_out\[12\] vssd1 vssd1
+ vccd1 vccd1 _0254_ sky130_fd_sc_hd__xnor2_1
X_0745_ MATMULT_INST.uart_tx.tx_ctrl.state\[4\] _0307_ MATMULT_INST.uart_tx.tx_ctrl.state\[3\]
+ vssd1 vssd1 vccd1 vccd1 _0318_ sky130_fd_sc_hd__or3b_1
XFILLER_12_118 vccd1 vssd1 vccd1 vssd1 sky130_ef_sc_hd__decap_40_12
XFILLER_16_15 vccd1 vssd1 vccd1 vssd1 sky130_ef_sc_hd__decap_40_12
XFILLER_20_195 vssd1 vssd1 vccd1 vccd1 sky130_fd_sc_hd__fill_1
X_0530_ _0133_ _0134_ net22 vssd1 vssd1 vccd1 vccd1 MATMULT_INST.uart_tx.count.next_cnt_out\[3\]
+ sky130_fd_sc_hd__and3b_1
X_0461_ net4 vssd1 vssd1 vccd1 vccd1 _0074_ sky130_fd_sc_hd__inv_2
X_1013_ clknet_3_6__leaf_clk MATMULT_INST.uart_rcv.tim.clock_count.next_cnt_out\[11\]
+ net33 vssd1 vssd1 vccd1 vccd1 MATMULT_INST.uart_rcv.tim.clk_cnt\[11\] sky130_fd_sc_hd__dfrtp_1
X_0659_ net15 _0216_ vssd1 vssd1 vccd1 vccd1 _0237_ sky130_fd_sc_hd__nand2_1
X_0728_ MATMULT_INST.prod_adder.gen_for_loop\[2\].adder_n.b _0301_ vssd1 vssd1 vccd1
+ vccd1 _0302_ sky130_fd_sc_hd__nand2_1
XPHY_EDGE_ROW_4_Right_4 vssd1 vssd1 vccd1 vccd1 sky130_fd_sc_hd__decap_3
XTAP_TAPCELL_ROW_4_103 vssd1 vccd1 sky130_fd_sc_hd__tapvpwrvgnd_1
XFILLER_25_232 vccd1 vssd1 vccd1 vssd1 sky130_ef_sc_hd__decap_40_12
XTAP_TAPCELL_ROW_27_205 vssd1 vccd1 sky130_fd_sc_hd__tapvpwrvgnd_1
XFILLER_4_29 vccd1 vssd1 vccd1 vssd1 sky130_ef_sc_hd__decap_40_12
XFILLER_4_18 vssd1 vssd1 vccd1 vccd1 sky130_fd_sc_hd__fill_8
XTAP_TAPCELL_ROW_10_127 vssd1 vccd1 sky130_fd_sc_hd__tapvpwrvgnd_1
XFILLER_33_90 vssd1 vssd1 vccd1 vccd1 sky130_fd_sc_hd__fill_1
XFILLER_3_180 vssd1 vssd1 vccd1 vccd1 sky130_fd_sc_hd__fill_1
X_0513_ MATMULT_INST.uart_tx.clk_cnt\[12\] _0078_ MATMULT_INST.uart_tx.clk_cnt\[13\]
+ _0079_ vssd1 vssd1 vccd1 vccd1 _0121_ sky130_fd_sc_hd__o2bb2a_1
XTAP_TAPCELL_ROW_32_230 vssd1 vccd1 sky130_fd_sc_hd__tapvpwrvgnd_1
Xfanout28 net30 vssd1 vssd1 vccd1 vccd1 net28 sky130_fd_sc_hd__clkbuf_4
XFILLER_38_57 vccd1 vssd1 vccd1 vssd1 sky130_ef_sc_hd__decap_40_12
XFILLER_13_246 vssd1 vssd1 vccd1 vccd1 sky130_fd_sc_hd__fill_1
X_0993_ clknet_3_7__leaf_clk _0039_ net34 vssd1 vssd1 vccd1 vccd1 MATMULT_INST.cntrl.state\[1\]
+ sky130_fd_sc_hd__dfrtp_2
XFILLER_8_250 vssd1 vssd1 vccd1 vccd1 sky130_fd_sc_hd__fill_2
XFILLER_5_94 vccd1 vssd1 vccd1 vssd1 sky130_ef_sc_hd__decap_40_12
XFILLER_10_249 vssd1 vssd1 vccd1 vccd1 sky130_fd_sc_hd__fill_2
XFILLER_6_6 vccd1 vssd1 vccd1 vssd1 sky130_ef_sc_hd__decap_40_12
XANTENNA__0486__B _0096_ vssd1 vssd1 vccd1 vccd1 sky130_fd_sc_hd__diode_2
XFILLER_30_91 vssd1 vssd1 vccd1 vccd1 sky130_fd_sc_hd__fill_1
Xinput7 gpio_in[14] vssd1 vssd1 vccd1 vccd1 net7 sky130_fd_sc_hd__clkbuf_2
X_0976_ clknet_3_1__leaf_clk _0022_ net25 vssd1 vssd1 vccd1 vccd1 MATMULT_INST.parallel_out2\[0\]
+ sky130_fd_sc_hd__dfstp_1
XFILLER_19_15 vccd1 vssd1 vccd1 vssd1 sky130_ef_sc_hd__decap_40_12
XFILLER_27_113 vssd1 vssd1 vccd1 vccd1 sky130_fd_sc_hd__fill_2
XFILLER_2_245 vssd1 vssd1 vccd1 vccd1 sky130_fd_sc_hd__fill_4
XFILLER_33_127 vssd1 vssd1 vccd1 vccd1 sky130_fd_sc_hd__fill_1
X_0830_ MATMULT_INST.parallel_out2\[5\] MATMULT_INST.rx_data\[5\] _0096_ vssd1 vssd1
+ vccd1 vccd1 _0027_ sky130_fd_sc_hd__mux2_1
XFILLER_25_80 vssd1 vssd1 vccd1 vccd1 sky130_fd_sc_hd__fill_4
X_0761_ MATMULT_INST.uart_rcv.data_buff.packet_data\[0\] MATMULT_INST.uart_rcv.data_buff.packet_data\[1\]
+ net24 vssd1 vssd1 vccd1 vccd1 _0005_ sky130_fd_sc_hd__mux2_1
X_0692_ MATMULT_INST.prod_adder.gen_for_loop\[5\].adder_n.b MATMULT_INST.prod_adder.gen_for_loop\[5\].adder_n.a
+ vssd1 vssd1 vccd1 vccd1 _0266_ sky130_fd_sc_hd__or2_1
XFILLER_24_138 vssd1 vssd1 vccd1 vccd1 sky130_fd_sc_hd__fill_2
XFILLER_32_193 vssd1 vssd1 vccd1 vccd1 sky130_fd_sc_hd__fill_2
X_0959_ clknet_3_0__leaf_clk _0005_ net25 vssd1 vssd1 vccd1 vccd1 MATMULT_INST.uart_rcv.data_buff.packet_data\[0\]
+ sky130_fd_sc_hd__dfstp_1
XFILLER_7_18 vccd1 vssd1 vccd1 vssd1 sky130_ef_sc_hd__decap_40_12
XFILLER_15_138 vssd1 vssd1 vccd1 vccd1 sky130_fd_sc_hd__fill_8
XTAP_TAPCELL_ROW_16_155 vssd1 vccd1 sky130_fd_sc_hd__tapvpwrvgnd_1
Xinput10 gpio_in[2] vssd1 vssd1 vccd1 vccd1 net10 sky130_fd_sc_hd__buf_1
X_0813_ MATMULT_INST.parallel_out1\[6\] MATMULT_INST.parallel_out1\[2\] MATMULT_INST.parallel_out1\[7\]
+ MATMULT_INST.parallel_out1\[3\] vssd1 vssd1 vccd1 vccd1 _0366_ sky130_fd_sc_hd__and4_1
X_0675_ _0079_ MATMULT_INST.uart_rcv.tim.clock_count.next_cnt_out\[13\] vssd1 vssd1
+ vccd1 vccd1 _0253_ sky130_fd_sc_hd__nand2_1
X_0744_ _0278_ _0316_ vssd1 vssd1 vccd1 vccd1 _0317_ sky130_fd_sc_hd__nor2_1
XFILLER_16_27 vssd1 vssd1 vccd1 vccd1 sky130_fd_sc_hd__fill_1
XFILLER_20_152 vssd1 vssd1 vccd1 vccd1 sky130_fd_sc_hd__fill_1
XFILLER_28_230 vssd1 vssd1 vccd1 vccd1 sky130_fd_sc_hd__fill_1
XTAP_TAPCELL_ROW_21_180 vssd1 vccd1 sky130_fd_sc_hd__tapvpwrvgnd_1
X_0460_ MATMULT_INST.uart_tx.clk_cnt\[7\] vssd1 vssd1 vccd1 vccd1 _0073_ sky130_fd_sc_hd__inv_2
X_1012_ clknet_3_6__leaf_clk MATMULT_INST.uart_rcv.tim.clock_count.next_cnt_out\[10\]
+ net30 vssd1 vssd1 vccd1 vccd1 MATMULT_INST.uart_rcv.tim.clk_cnt\[10\] sky130_fd_sc_hd__dfrtp_1
X_0727_ _0273_ _0274_ vssd1 vssd1 vccd1 vccd1 _0301_ sky130_fd_sc_hd__nor2_1
XFILLER_8_61 vssd1 vssd1 vccd1 vccd1 sky130_fd_sc_hd__fill_2
X_0658_ net3 MATMULT_INST.uart_rcv.tim.clock_count.next_cnt_out\[8\] vssd1 vssd1 vccd1
+ vccd1 _0236_ sky130_fd_sc_hd__xnor2_1
X_0589_ MATMULT_INST.uart_rcv.tim.clk_cnt\[9\] net4 vssd1 vssd1 vccd1 vccd1 _0181_
+ sky130_fd_sc_hd__nand2b_1
XTAP_TAPCELL_ROW_4_104 vssd1 vccd1 sky130_fd_sc_hd__tapvpwrvgnd_1
XFILLER_25_222 vssd1 vssd1 vccd1 vccd1 sky130_fd_sc_hd__fill_2
XFILLER_25_244 vssd1 vssd1 vccd1 vccd1 sky130_fd_sc_hd__fill_8
XTAP_TAPCELL_ROW_27_206 vssd1 vccd1 sky130_fd_sc_hd__tapvpwrvgnd_1
XTAP_TAPCELL_ROW_10_128 vssd1 vccd1 sky130_fd_sc_hd__tapvpwrvgnd_1
XFILLER_4_137 vssd1 vssd1 vccd1 vccd1 sky130_fd_sc_hd__fill_2
XFILLER_16_244 vssd1 vssd1 vccd1 vccd1 sky130_fd_sc_hd__fill_2
X_0512_ _0070_ net12 MATMULT_INST.uart_tx.clk_cnt\[3\] _0071_ _0110_ vssd1 vssd1 vccd1
+ vccd1 _0120_ sky130_fd_sc_hd__o221a_1
Xfanout29 net30 vssd1 vssd1 vccd1 vccd1 net29 sky130_fd_sc_hd__clkbuf_2
XFILLER_22_236 vssd1 vssd1 vccd1 vccd1 sky130_fd_sc_hd__fill_1
XFILLER_1_107 vssd1 vssd1 vccd1 vccd1 sky130_fd_sc_hd__fill_1
XFILLER_38_69 vccd1 vssd1 vccd1 vssd1 sky130_ef_sc_hd__decap_40_12
XFILLER_13_225 vssd1 vssd1 vccd1 vccd1 sky130_fd_sc_hd__fill_2
XFILLER_9_218 vssd1 vssd1 vccd1 vccd1 sky130_fd_sc_hd__fill_1
XFILLER_0_195 vssd1 vssd1 vccd1 vccd1 sky130_fd_sc_hd__fill_1
X_0992_ clknet_3_7__leaf_clk _0038_ net34 vssd1 vssd1 vccd1 vccd1 MATMULT_INST.cntrl.state\[0\]
+ sky130_fd_sc_hd__dfrtp_2
XFILLER_24_27 vssd1 vssd1 vccd1 vccd1 sky130_fd_sc_hd__fill_1
XFILLER_10_217 vssd1 vssd1 vccd1 vccd1 sky130_fd_sc_hd__fill_2
XFILLER_5_254 vssd1 vssd1 vccd1 vccd1 sky130_fd_sc_hd__fill_1
XFILLER_30_81 vssd1 vssd1 vccd1 vccd1 sky130_fd_sc_hd__fill_2
Xinput8 gpio_in[15] vssd1 vssd1 vccd1 vccd1 net8 sky130_fd_sc_hd__buf_1
X_0975_ clknet_3_4__leaf_clk _0021_ net33 vssd1 vssd1 vccd1 vccd1 MATMULT_INST.prod_adder.gen_for_loop\[7\].adder_n.a
+ sky130_fd_sc_hd__dfstp_1
XFILLER_19_27 vssd1 vssd1 vccd1 vccd1 sky130_fd_sc_hd__fill_4
XFILLER_35_48 vssd1 vssd1 vccd1 vccd1 sky130_fd_sc_hd__fill_8
XFILLER_35_26 vssd1 vssd1 vccd1 vccd1 sky130_fd_sc_hd__fill_1
XFILLER_33_117 vssd1 vssd1 vccd1 vccd1 sky130_fd_sc_hd__fill_2
X_0760_ net120 _0323_ _0327_ vssd1 vssd1 vccd1 vccd1 _0004_ sky130_fd_sc_hd__a21o_1
X_0691_ MATMULT_INST.prod_adder.gen_for_loop\[5\].adder_n.b MATMULT_INST.prod_adder.gen_for_loop\[5\].adder_n.a
+ vssd1 vssd1 vccd1 vccd1 _0265_ sky130_fd_sc_hd__and2_1
XFILLER_2_96 vssd1 vssd1 vccd1 vccd1 sky130_fd_sc_hd__fill_2
XFILLER_2_85 vssd1 vssd1 vccd1 vccd1 sky130_fd_sc_hd__fill_4
XFILLER_2_41 vccd1 vssd1 vccd1 vssd1 sky130_ef_sc_hd__decap_40_12
X_0889_ _0402_ _0413_ _0414_ _0407_ vssd1 vssd1 vccd1 vccd1 _0046_ sky130_fd_sc_hd__o31ai_1
X_0958_ clknet_3_6__leaf_clk MATMULT_INST.uart_tx.count.next_cnt_out\[13\] net36 vssd1
+ vssd1 vccd1 vccd1 MATMULT_INST.uart_tx.clk_cnt\[13\] sky130_fd_sc_hd__dfrtp_1
XFILLER_30_109 vccd1 vssd1 vccd1 vssd1 sky130_ef_sc_hd__decap_40_12
XTAP_TAPCELL_ROW_16_156 vssd1 vccd1 sky130_fd_sc_hd__tapvpwrvgnd_1
X_0743_ _0267_ _0268_ vssd1 vssd1 vccd1 vccd1 _0316_ sky130_fd_sc_hd__nand2_1
X_0812_ MATMULT_INST.prod_adder.gen_for_loop\[4\].adder_n.a _0365_ _0329_ vssd1 vssd1
+ vccd1 vccd1 _0018_ sky130_fd_sc_hd__mux2_1
Xinput11 gpio_in[3] vssd1 vssd1 vccd1 vccd1 net11 sky130_fd_sc_hd__buf_1
X_0674_ _0079_ MATMULT_INST.uart_rcv.tim.clock_count.next_cnt_out\[13\] vssd1 vssd1
+ vccd1 vccd1 _0252_ sky130_fd_sc_hd__or2_1
XFILLER_37_220 vssd1 vssd1 vccd1 vccd1 sky130_fd_sc_hd__fill_4
XFILLER_32_49 vccd1 vssd1 vccd1 vssd1 sky130_ef_sc_hd__decap_40_12
XFILLER_20_186 vssd1 vssd1 vccd1 vccd1 sky130_fd_sc_hd__fill_4
XFILLER_28_253 vssd1 vssd1 vccd1 vccd1 sky130_fd_sc_hd__fill_2
X_1011_ clknet_3_3__leaf_clk MATMULT_INST.uart_rcv.tim.clock_count.next_cnt_out\[9\]
+ net30 vssd1 vssd1 vccd1 vccd1 MATMULT_INST.uart_rcv.tim.clk_cnt\[9\] sky130_fd_sc_hd__dfrtp_1
XFILLER_34_201 vssd1 vssd1 vccd1 vccd1 sky130_fd_sc_hd__fill_2
X_0726_ _0262_ _0291_ vssd1 vssd1 vccd1 vccd1 _0300_ sky130_fd_sc_hd__nor2_1
X_0657_ _0074_ MATMULT_INST.uart_rcv.tim.clock_count.next_cnt_out\[9\] _0234_ vssd1
+ vssd1 vccd1 vccd1 _0235_ sky130_fd_sc_hd__a21o_1
X_0588_ net13 MATMULT_INST.uart_rcv.tim.clk_cnt\[3\] vssd1 vssd1 vccd1 vccd1 _0180_
+ sky130_fd_sc_hd__nand2b_1
XTAP_TAPCELL_ROW_35_240 vssd1 vccd1 sky130_fd_sc_hd__tapvpwrvgnd_1
XTAP_TAPCELL_ROW_27_207 vssd1 vccd1 sky130_fd_sc_hd__tapvpwrvgnd_1
XTAP_TAPCELL_ROW_10_129 vssd1 vccd1 sky130_fd_sc_hd__tapvpwrvgnd_1
XANTENNA_input17_A gpio_in[9] vssd1 vssd1 vccd1 vccd1 sky130_fd_sc_hd__diode_2
Xteam_07_90 vssd1 vssd1 vccd1 vccd1 gpio_oeb[20] team_07_90/LO sky130_fd_sc_hd__conb_1
X_0511_ MATMULT_INST.uart_tx.clk_cnt\[12\] _0078_ _0111_ _0112_ _0114_ vssd1 vssd1
+ vccd1 vccd1 _0119_ sky130_fd_sc_hd__o2111a_1
XFILLER_3_160 vssd1 vssd1 vccd1 vccd1 sky130_fd_sc_hd__fill_8
XFILLER_12_3 vccd1 vssd1 vccd1 vssd1 sky130_ef_sc_hd__decap_40_12
X_0709_ MATMULT_INST.prod_adder.gen_for_loop\[7\].adder_n.b MATMULT_INST.prod_adder.gen_for_loop\[7\].adder_n.a
+ vssd1 vssd1 vccd1 vccd1 _0283_ sky130_fd_sc_hd__xnor2_1
XFILLER_38_15 vccd1 vssd1 vccd1 vssd1 sky130_ef_sc_hd__decap_40_12
XANTENNA_input9_A gpio_in[1] vssd1 vssd1 vccd1 vccd1 sky130_fd_sc_hd__diode_2
XFILLER_0_141 vccd1 vssd1 vccd1 vssd1 sky130_ef_sc_hd__decap_40_12
XFILLER_28_81 vssd1 vssd1 vccd1 vccd1 sky130_fd_sc_hd__fill_2
XFILLER_8_230 vssd1 vssd1 vccd1 vccd1 sky130_fd_sc_hd__fill_1
X_0991_ clknet_3_3__leaf_clk _0037_ net30 vssd1 vssd1 vccd1 vccd1 MATMULT_INST.parallel_out1\[7\]
+ sky130_fd_sc_hd__dfstp_1
XFILLER_5_30 vccd1 vssd1 vccd1 vssd1 sky130_ef_sc_hd__decap_40_12
XFILLER_5_222 vssd1 vssd1 vccd1 vccd1 sky130_fd_sc_hd__fill_2
Xinput9 gpio_in[1] vssd1 vssd1 vccd1 vccd1 net9 sky130_fd_sc_hd__buf_1
X_0974_ clknet_3_4__leaf_clk _0020_ net33 vssd1 vssd1 vccd1 vccd1 MATMULT_INST.prod_adder.gen_for_loop\[6\].adder_n.a
+ sky130_fd_sc_hd__dfstp_1
XFILLER_27_137 vccd1 vssd1 vccd1 vssd1 sky130_ef_sc_hd__decap_40_12
XFILLER_35_181 vssd1 vssd1 vccd1 vccd1 sky130_fd_sc_hd__fill_2
XFILLER_33_107 vssd1 vssd1 vccd1 vccd1 sky130_fd_sc_hd__fill_4
XFILLER_26_181 vccd1 vssd1 vccd1 vssd1 sky130_ef_sc_hd__decap_40_12
X_0690_ MATMULT_INST.prod_adder.gen_for_loop\[6\].adder_n.b MATMULT_INST.prod_adder.gen_for_loop\[6\].adder_n.a
+ vssd1 vssd1 vccd1 vccd1 _0264_ sky130_fd_sc_hd__nor2_1
XFILLER_2_53 vccd1 vssd1 vccd1 vssd1 sky130_ef_sc_hd__decap_40_12
XPHY_EDGE_ROW_10_Right_10 vssd1 vssd1 vccd1 vccd1 sky130_fd_sc_hd__decap_3
XFILLER_32_195 vssd1 vssd1 vccd1 vccd1 sky130_fd_sc_hd__fill_1
X_0888_ _0404_ _0411_ _0412_ vssd1 vssd1 vccd1 vccd1 _0414_ sky130_fd_sc_hd__and3_1
X_0957_ clknet_3_6__leaf_clk MATMULT_INST.uart_tx.count.next_cnt_out\[12\] net33 vssd1
+ vssd1 vccd1 vccd1 MATMULT_INST.uart_tx.clk_cnt\[12\] sky130_fd_sc_hd__dfrtp_1
XTAP_TAPCELL_ROW_16_157 vssd1 vccd1 sky130_fd_sc_hd__tapvpwrvgnd_1
XPHY_EDGE_ROW_26_Left_65 vssd1 vssd1 vccd1 vccd1 sky130_fd_sc_hd__decap_3
X_0673_ _0249_ _0250_ _0248_ vssd1 vssd1 vccd1 vccd1 _0251_ sky130_fd_sc_hd__a21oi_1
X_0742_ _0302_ _0303_ _0310_ _0314_ vssd1 vssd1 vccd1 vccd1 _0315_ sky130_fd_sc_hd__a211oi_1
XPHY_EDGE_ROW_10_Left_49 vssd1 vssd1 vccd1 vccd1 sky130_fd_sc_hd__decap_3
X_0811_ _0363_ _0364_ vssd1 vssd1 vccd1 vccd1 _0365_ sky130_fd_sc_hd__and2_1
XTAP_TAPCELL_ROW_24_190 vssd1 vccd1 sky130_fd_sc_hd__tapvpwrvgnd_1
Xinput12 gpio_in[4] vssd1 vssd1 vccd1 vccd1 net12 sky130_fd_sc_hd__clkbuf_2
XANTENNA_clkbuf_3_6__f_clk_A clknet_0_clk vssd1 vssd1 vccd1 vccd1 sky130_fd_sc_hd__diode_2
XFILLER_16_29 vssd1 vssd1 vccd1 vccd1 sky130_fd_sc_hd__fill_2
XTAP_TAPCELL_ROW_7_114 vssd1 vccd1 sky130_fd_sc_hd__tapvpwrvgnd_1
XTAP_TAPCELL_ROW_38_260 vssd1 vccd1 sky130_fd_sc_hd__tapvpwrvgnd_1
XFILLER_11_121 vssd1 vssd1 vccd1 vccd1 sky130_fd_sc_hd__fill_1
XFILLER_22_83 vssd1 vssd1 vccd1 vccd1 sky130_fd_sc_hd__fill_1
XFILLER_21_8 vccd1 vssd1 vccd1 vssd1 sky130_ef_sc_hd__decap_40_12
X_1010_ clknet_3_3__leaf_clk MATMULT_INST.uart_rcv.tim.clock_count.next_cnt_out\[8\]
+ net30 vssd1 vssd1 vccd1 vccd1 MATMULT_INST.uart_rcv.tim.clk_cnt\[8\] sky130_fd_sc_hd__dfrtp_1
XFILLER_8_85 vccd1 vssd1 vccd1 vssd1 sky130_ef_sc_hd__decap_40_12
X_0656_ _0074_ MATMULT_INST.uart_rcv.tim.clock_count.next_cnt_out\[9\] _0232_ _0233_
+ vssd1 vssd1 vccd1 vccd1 _0234_ sky130_fd_sc_hd__a2bb2o_1
X_0725_ MATMULT_INST.uart_tx.tx_ctrl.state\[0\] MATMULT_INST.uart_tx.tx_ctrl.state\[1\]
+ MATMULT_INST.uart_tx.tx_ctrl.state\[2\] _0298_ vssd1 vssd1 vccd1 vccd1 _0299_ sky130_fd_sc_hd__and4_1
X_0587_ net6 MATMULT_INST.uart_rcv.tim.clk_cnt\[11\] vssd1 vssd1 vccd1 vccd1 _0179_
+ sky130_fd_sc_hd__and2b_1
XTAP_TAPCELL_ROW_35_241 vssd1 vccd1 sky130_fd_sc_hd__tapvpwrvgnd_1
XFILLER_4_139 vssd1 vssd1 vccd1 vccd1 sky130_fd_sc_hd__fill_1
XANTENNA__0831__S _0096_ vssd1 vssd1 vccd1 vccd1 sky130_fd_sc_hd__diode_2
Xteam_07_91 vssd1 vssd1 vccd1 vccd1 gpio_oeb[21] team_07_91/LO sky130_fd_sc_hd__conb_1
Xteam_07_80 vssd1 vssd1 vccd1 vccd1 gpio_oeb[7] team_07_80/LO sky130_fd_sc_hd__conb_1
XFILLER_16_213 vssd1 vssd1 vccd1 vccd1 sky130_fd_sc_hd__fill_2
XFILLER_31_249 vssd1 vssd1 vccd1 vccd1 sky130_fd_sc_hd__fill_2
X_0510_ _0070_ net12 _0072_ net16 _0117_ vssd1 vssd1 vccd1 vccd1 _0118_ sky130_fd_sc_hd__a221o_1
Xhold1 MATMULT_INST.uart_rcv.sbd.sync_phase vssd1 vssd1 vccd1 vccd1 net104 sky130_fd_sc_hd__dlygate4sd3_1
XPHY_EDGE_ROW_8_Right_8 vssd1 vssd1 vccd1 vccd1 sky130_fd_sc_hd__decap_3
XFILLER_22_205 vssd1 vssd1 vccd1 vccd1 sky130_fd_sc_hd__fill_4
XFILLER_38_27 vssd1 vssd1 vccd1 vccd1 sky130_fd_sc_hd__fill_1
X_0639_ _0222_ _0205_ _0221_ vssd1 vssd1 vccd1 vccd1 MATMULT_INST.uart_rcv.tim.clock_count.next_cnt_out\[8\]
+ sky130_fd_sc_hd__and3b_1
X_0708_ _0264_ _0280_ _0281_ vssd1 vssd1 vccd1 vccd1 _0282_ sky130_fd_sc_hd__o21ba_1
XPHY_EDGE_ROW_13_Left_52 vssd1 vssd1 vccd1 vccd1 sky130_fd_sc_hd__decap_3
XANTENNA__0826__S _0096_ vssd1 vssd1 vccd1 vccd1 sky130_fd_sc_hd__diode_2
XFILLER_13_216 vssd1 vssd1 vccd1 vccd1 sky130_fd_sc_hd__fill_2
XFILLER_13_227 vssd1 vssd1 vccd1 vccd1 sky130_fd_sc_hd__fill_1
XFILLER_0_153 vccd1 vssd1 vccd1 vssd1 sky130_ef_sc_hd__decap_40_12
XFILLER_0_197 vssd1 vssd1 vccd1 vccd1 sky130_fd_sc_hd__fill_2
XFILLER_8_253 vssd1 vssd1 vccd1 vccd1 sky130_fd_sc_hd__fill_2
X_0990_ clknet_3_1__leaf_clk _0036_ net27 vssd1 vssd1 vccd1 vccd1 MATMULT_INST.parallel_out1\[6\]
+ sky130_fd_sc_hd__dfstp_1
XFILLER_5_42 vccd1 vssd1 vccd1 vssd1 sky130_ef_sc_hd__decap_40_12
XFILLER_14_62 vssd1 vssd1 vccd1 vccd1 sky130_fd_sc_hd__fill_1
XTAP_TAPCELL_ROW_1_87 vssd1 vccd1 sky130_fd_sc_hd__tapvpwrvgnd_1
XFILLER_30_83 vssd1 vssd1 vccd1 vccd1 sky130_fd_sc_hd__fill_1
XFILLER_36_138 vssd1 vssd1 vccd1 vccd1 sky130_fd_sc_hd__fill_2
X_0973_ clknet_3_5__leaf_clk _0019_ net31 vssd1 vssd1 vccd1 vccd1 MATMULT_INST.prod_adder.gen_for_loop\[5\].adder_n.a
+ sky130_fd_sc_hd__dfstp_1
XFILLER_27_149 vssd1 vssd1 vccd1 vccd1 sky130_fd_sc_hd__fill_4
XFILLER_4_6 vccd1 vssd1 vccd1 vssd1 sky130_ef_sc_hd__decap_40_12
XFILLER_26_193 vssd1 vssd1 vccd1 vccd1 sky130_fd_sc_hd__fill_2
XFILLER_2_65 vccd1 vssd1 vccd1 vssd1 sky130_ef_sc_hd__decap_40_12
XFILLER_32_141 vccd1 vssd1 vccd1 vssd1 sky130_ef_sc_hd__decap_40_12
XFILLER_32_130 vssd1 vssd1 vccd1 vccd1 sky130_fd_sc_hd__fill_2
X_0956_ clknet_3_6__leaf_clk MATMULT_INST.uart_tx.count.next_cnt_out\[11\] net33 vssd1
+ vssd1 vccd1 vccd1 MATMULT_INST.uart_tx.clk_cnt\[11\] sky130_fd_sc_hd__dfrtp_1
X_0887_ _0411_ _0412_ _0404_ vssd1 vssd1 vccd1 vccd1 _0413_ sky130_fd_sc_hd__a21oi_1
XANTENNA__0834__S _0092_ vssd1 vssd1 vccd1 vccd1 sky130_fd_sc_hd__diode_2
XPHY_EDGE_ROW_1_Left_40 vssd1 vssd1 vccd1 vccd1 sky130_fd_sc_hd__decap_3
XTAP_TAPCELL_ROW_16_158 vssd1 vccd1 sky130_fd_sc_hd__tapvpwrvgnd_1
X_0810_ _0359_ _0362_ vssd1 vssd1 vccd1 vccd1 _0364_ sky130_fd_sc_hd__or2_1
XTAP_TAPCELL_ROW_24_191 vssd1 vccd1 sky130_fd_sc_hd__tapvpwrvgnd_1
Xinput13 gpio_in[5] vssd1 vssd1 vccd1 vccd1 net13 sky130_fd_sc_hd__dlymetal6s2s_1
X_0672_ net5 MATMULT_INST.uart_rcv.tim.clock_count.next_cnt_out\[10\] vssd1 vssd1
+ vccd1 vccd1 _0250_ sky130_fd_sc_hd__or2_1
X_0741_ _0003_ _0313_ _0295_ _0311_ vssd1 vssd1 vccd1 vccd1 _0314_ sky130_fd_sc_hd__and4b_1
X_0939_ clknet_3_5__leaf_clk _0000_ net32 vssd1 vssd1 vccd1 vccd1 MATMULT_INST.uart_tx.tx_ctrl.state\[0\]
+ sky130_fd_sc_hd__dfrtp_1
XTAP_TAPCELL_ROW_7_115 vssd1 vccd1 sky130_fd_sc_hd__tapvpwrvgnd_1
XANTENNA__0829__S _0096_ vssd1 vssd1 vccd1 vccd1 sky130_fd_sc_hd__diode_2
XTAP_TAPCELL_ROW_38_261 vssd1 vccd1 sky130_fd_sc_hd__tapvpwrvgnd_1
XFILLER_28_222 vssd1 vssd1 vccd1 vccd1 sky130_fd_sc_hd__fill_8
XFILLER_34_236 vccd1 vssd1 vccd1 vssd1 sky130_ef_sc_hd__decap_40_12
XFILLER_34_203 vssd1 vssd1 vccd1 vccd1 sky130_fd_sc_hd__fill_1
XFILLER_8_97 vssd1 vssd1 vccd1 vccd1 sky130_fd_sc_hd__fill_4
X_0655_ net17 MATMULT_INST.uart_rcv.tim.clock_count.next_cnt_out\[7\] vssd1 vssd1
+ vccd1 vccd1 _0233_ sky130_fd_sc_hd__or2_1
X_0586_ net15 MATMULT_INST.uart_rcv.tim.clk_cnt\[5\] vssd1 vssd1 vccd1 vccd1 _0178_
+ sky130_fd_sc_hd__and2b_1
X_0724_ MATMULT_INST.uart_tx.tx_ctrl.state\[4\] MATMULT_INST.uart_tx.tx_ctrl.state\[3\]
+ vssd1 vssd1 vccd1 vccd1 _0298_ sky130_fd_sc_hd__nor2_1
XTAP_TAPCELL_ROW_35_242 vssd1 vccd1 sky130_fd_sc_hd__tapvpwrvgnd_1
XFILLER_4_129 vssd1 vssd1 vccd1 vccd1 sky130_fd_sc_hd__fill_8
Xteam_07_70 vssd1 vssd1 vccd1 vccd1 team_07_70/HI gpio_out[31] sky130_fd_sc_hd__conb_1
Xteam_07_81 vssd1 vssd1 vccd1 vccd1 gpio_oeb[8] team_07_81/LO sky130_fd_sc_hd__conb_1
Xteam_07_92 vssd1 vssd1 vccd1 vccd1 gpio_oeb[22] team_07_92/LO sky130_fd_sc_hd__conb_1
XFILLER_3_184 vccd1 vssd1 vccd1 vssd1 sky130_ef_sc_hd__decap_40_12
Xhold2 MATMULT_INST.uart_rcv.sbd.new_sample vssd1 vssd1 vccd1 vccd1 net105 sky130_fd_sc_hd__dlygate4sd3_1
XANTENNA__0932__S _0447_ vssd1 vssd1 vccd1 vccd1 sky130_fd_sc_hd__diode_2
X_0707_ MATMULT_INST.prod_adder.gen_for_loop\[6\].adder_n.b MATMULT_INST.prod_adder.gen_for_loop\[6\].adder_n.a
+ vssd1 vssd1 vccd1 vccd1 _0281_ sky130_fd_sc_hd__and2_1
X_0638_ MATMULT_INST.uart_rcv.tim.clk_cnt\[7\] MATMULT_INST.uart_rcv.tim.clk_cnt\[8\]
+ _0217_ vssd1 vssd1 vccd1 vccd1 _0222_ sky130_fd_sc_hd__and3_1
X_0569_ _0069_ MATMULT_INST.uart_tx.count.next_cnt_out\[1\] vssd1 vssd1 vccd1 vccd1
+ _0163_ sky130_fd_sc_hd__xnor2_1
XFILLER_0_165 vssd1 vssd1 vccd1 vccd1 sky130_fd_sc_hd__fill_2
XFILLER_28_83 vssd1 vssd1 vccd1 vccd1 sky130_fd_sc_hd__fill_1
XFILLER_5_54 vssd1 vssd1 vccd1 vccd1 sky130_fd_sc_hd__fill_2
XANTENNA__0837__S _0092_ vssd1 vssd1 vccd1 vccd1 sky130_fd_sc_hd__diode_2
XTAP_TAPCELL_ROW_1_88 vssd1 vccd1 sky130_fd_sc_hd__tapvpwrvgnd_1
XFILLER_30_95 vssd1 vssd1 vccd1 vccd1 sky130_fd_sc_hd__fill_4
X_0972_ clknet_3_4__leaf_clk _0018_ net31 vssd1 vssd1 vccd1 vccd1 MATMULT_INST.prod_adder.gen_for_loop\[4\].adder_n.a
+ sky130_fd_sc_hd__dfstp_1
XFILLER_25_84 vssd1 vssd1 vccd1 vccd1 sky130_fd_sc_hd__fill_1
XANTENNA__0991__SET_B net30 vssd1 vssd1 vccd1 vccd1 sky130_fd_sc_hd__diode_2
XFILLER_2_77 vssd1 vssd1 vccd1 vccd1 sky130_fd_sc_hd__fill_4
XFILLER_17_183 vssd1 vssd1 vccd1 vccd1 sky130_fd_sc_hd__fill_2
XFILLER_24_109 vssd1 vssd1 vccd1 vccd1 sky130_fd_sc_hd__fill_4
XFILLER_32_153 vssd1 vssd1 vccd1 vccd1 sky130_fd_sc_hd__fill_4
X_0886_ _0409_ _0410_ _0408_ vssd1 vssd1 vccd1 vccd1 _0412_ sky130_fd_sc_hd__o21ai_1
X_0955_ clknet_3_6__leaf_clk MATMULT_INST.uart_tx.count.next_cnt_out\[10\] net33 vssd1
+ vssd1 vccd1 vccd1 MATMULT_INST.uart_tx.clk_cnt\[10\] sky130_fd_sc_hd__dfrtp_1
XFILLER_15_109 vssd1 vssd1 vccd1 vccd1 sky130_fd_sc_hd__fill_2
XFILLER_23_142 vssd1 vssd1 vccd1 vccd1 sky130_fd_sc_hd__fill_2
XFILLER_36_61 vssd1 vssd1 vccd1 vccd1 sky130_fd_sc_hd__fill_1
X_0740_ _0304_ _0308_ vssd1 vssd1 vccd1 vccd1 _0313_ sky130_fd_sc_hd__nor2_1
XTAP_TAPCELL_ROW_24_192 vssd1 vccd1 sky130_fd_sc_hd__tapvpwrvgnd_1
Xinput14 gpio_in[6] vssd1 vssd1 vccd1 vccd1 net14 sky130_fd_sc_hd__clkbuf_2
X_0671_ net5 MATMULT_INST.uart_rcv.tim.clock_count.next_cnt_out\[10\] vssd1 vssd1
+ vccd1 vccd1 _0249_ sky130_fd_sc_hd__nand2_1
XANTENNA__0935__S _0447_ vssd1 vssd1 vccd1 vccd1 sky130_fd_sc_hd__diode_2
X_0869_ _0400_ MATMULT_INST.cntrl.state\[2\] _0384_ vssd1 vssd1 vccd1 vccd1 _0040_
+ sky130_fd_sc_hd__mux2_1
X_0938_ MATMULT_INST.rx_data\[7\] MATMULT_INST.uart_rcv.data_buff.packet_data\[7\]
+ _0447_ vssd1 vssd1 vccd1 vccd1 _0061_ sky130_fd_sc_hd__mux2_1
XTAP_TAPCELL_ROW_7_116 vssd1 vccd1 sky130_fd_sc_hd__tapvpwrvgnd_1
XFILLER_22_41 vccd1 vssd1 vccd1 vssd1 sky130_ef_sc_hd__decap_40_12
XFILLER_22_63 vccd1 vssd1 vccd1 vssd1 sky130_ef_sc_hd__decap_40_12
XFILLER_22_85 vssd1 vssd1 vccd1 vccd1 sky130_fd_sc_hd__fill_1
XFILLER_34_248 vssd1 vssd1 vccd1 vccd1 sky130_fd_sc_hd__fill_1
X_0723_ _0264_ _0280_ _0281_ vssd1 vssd1 vccd1 vccd1 _0297_ sky130_fd_sc_hd__nor3_1
XTAP_TAPCELL_ROW_12_140 vssd1 vccd1 sky130_fd_sc_hd__tapvpwrvgnd_1
X_0654_ net17 MATMULT_INST.uart_rcv.tim.clock_count.next_cnt_out\[7\] vssd1 vssd1
+ vccd1 vccd1 _0232_ sky130_fd_sc_hd__nand2_1
X_0585_ MATMULT_INST.uart_rcv.tim.clk_cnt\[8\] net3 vssd1 vssd1 vccd1 vccd1 _0177_
+ sky130_fd_sc_hd__nand2b_1
XTAP_TAPCELL_ROW_35_243 vssd1 vccd1 sky130_fd_sc_hd__tapvpwrvgnd_1
Xteam_07_71 vssd1 vssd1 vccd1 vccd1 team_07_71/HI gpio_out[32] sky130_fd_sc_hd__conb_1
Xteam_07_82 vssd1 vssd1 vccd1 vccd1 gpio_oeb[9] team_07_82/LO sky130_fd_sc_hd__conb_1
Xteam_07_93 vssd1 vssd1 vccd1 vccd1 gpio_oeb[23] team_07_93/LO sky130_fd_sc_hd__conb_1
Xteam_07_60 vssd1 vssd1 vccd1 vccd1 team_07_60/HI gpio_out[21] sky130_fd_sc_hd__conb_1
XFILLER_33_51 vssd1 vssd1 vccd1 vccd1 sky130_fd_sc_hd__fill_4
XFILLER_33_40 vssd1 vssd1 vccd1 vccd1 sky130_fd_sc_hd__fill_2
XFILLER_3_196 vccd1 vssd1 vccd1 vssd1 sky130_ef_sc_hd__decap_40_12
Xhold3 MATMULT_INST.prod_adder.gen_for_loop\[6\].adder_n.b vssd1 vssd1 vccd1 vccd1
+ net106 sky130_fd_sc_hd__dlygate4sd3_1
X_0706_ _0265_ _0279_ _0266_ vssd1 vssd1 vccd1 vccd1 _0280_ sky130_fd_sc_hd__o21ai_1
X_0637_ MATMULT_INST.uart_rcv.tim.clk_cnt\[8\] _0220_ vssd1 vssd1 vccd1 vccd1 _0221_
+ sky130_fd_sc_hd__or2_1
XFILLER_38_29 vccd1 vssd1 vccd1 vssd1 sky130_ef_sc_hd__decap_40_12
X_0568_ net3 _0145_ _0160_ _0161_ vssd1 vssd1 vccd1 vccd1 _0162_ sky130_fd_sc_hd__a211o_1
X_0499_ MATMULT_INST.uart_tx.clk_cnt\[9\] net4 vssd1 vssd1 vccd1 vccd1 _0107_ sky130_fd_sc_hd__and2b_1
XFILLER_21_240 vssd1 vssd1 vccd1 vccd1 sky130_fd_sc_hd__fill_4
XFILLER_0_111 vssd1 vssd1 vccd1 vccd1 sky130_fd_sc_hd__fill_1
XANTENNA_input15_A gpio_in[7] vssd1 vssd1 vccd1 vccd1 sky130_fd_sc_hd__diode_2
XFILLER_12_251 vssd1 vssd1 vccd1 vccd1 sky130_fd_sc_hd__fill_1
XFILLER_10_3 vccd1 vssd1 vccd1 vssd1 sky130_ef_sc_hd__decap_40_12
XFILLER_38_181 vccd1 vssd1 vccd1 vssd1 sky130_ef_sc_hd__decap_40_12
XANTENNA_input7_A gpio_in[14] vssd1 vssd1 vccd1 vccd1 sky130_fd_sc_hd__diode_2
XFILLER_14_31 vssd1 vssd1 vccd1 vccd1 sky130_fd_sc_hd__fill_1
XFILLER_30_41 vssd1 vssd1 vccd1 vccd1 sky130_fd_sc_hd__fill_2
XTAP_TAPCELL_ROW_1_89 vssd1 vccd1 sky130_fd_sc_hd__tapvpwrvgnd_1
XFILLER_30_85 vssd1 vssd1 vccd1 vccd1 sky130_fd_sc_hd__fill_4
XANTENNA__0763__S net24 vssd1 vssd1 vccd1 vccd1 sky130_fd_sc_hd__diode_2
X_0971_ clknet_3_4__leaf_clk _0017_ net32 vssd1 vssd1 vccd1 vccd1 MATMULT_INST.prod_adder.gen_for_loop\[3\].adder_n.a
+ sky130_fd_sc_hd__dfstp_1
XANTENNA__0938__S _0447_ vssd1 vssd1 vccd1 vccd1 sky130_fd_sc_hd__diode_2
XFILLER_25_96 vssd1 vssd1 vccd1 vccd1 sky130_fd_sc_hd__fill_1
XFILLER_26_195 vssd1 vssd1 vccd1 vccd1 sky130_fd_sc_hd__fill_1
XFILLER_32_110 vssd1 vssd1 vccd1 vccd1 sky130_fd_sc_hd__fill_4
XFILLER_17_173 vssd1 vssd1 vccd1 vccd1 sky130_fd_sc_hd__fill_1
XTAP_TAPCELL_ROW_19_168 vssd1 vccd1 sky130_fd_sc_hd__tapvpwrvgnd_1
X_0885_ _0408_ _0409_ _0410_ vssd1 vssd1 vccd1 vccd1 _0411_ sky130_fd_sc_hd__or3_1
X_0954_ clknet_3_6__leaf_clk MATMULT_INST.uart_tx.count.next_cnt_out\[9\] net30 vssd1
+ vssd1 vccd1 vccd1 MATMULT_INST.uart_tx.clk_cnt\[9\] sky130_fd_sc_hd__dfrtp_1
X_0670_ _0077_ MATMULT_INST.uart_rcv.tim.clock_count.next_cnt_out\[11\] vssd1 vssd1
+ vccd1 vccd1 _0248_ sky130_fd_sc_hd__xnor2_1
Xinput15 gpio_in[7] vssd1 vssd1 vccd1 vccd1 net15 sky130_fd_sc_hd__clkbuf_2
XTAP_TAPCELL_ROW_24_193 vssd1 vccd1 sky130_fd_sc_hd__tapvpwrvgnd_1
X_0799_ _0350_ _0352_ _0330_ vssd1 vssd1 vccd1 vccd1 _0354_ sky130_fd_sc_hd__a21oi_1
X_0868_ _0388_ _0399_ _0385_ vssd1 vssd1 vccd1 vccd1 _0400_ sky130_fd_sc_hd__or3b_1
X_0937_ MATMULT_INST.rx_data\[6\] MATMULT_INST.uart_rcv.data_buff.packet_data\[6\]
+ _0447_ vssd1 vssd1 vccd1 vccd1 _0060_ sky130_fd_sc_hd__mux2_1
XFILLER_20_179 vssd1 vssd1 vccd1 vccd1 sky130_fd_sc_hd__fill_4
XTAP_TAPCELL_ROW_7_117 vssd1 vccd1 sky130_fd_sc_hd__tapvpwrvgnd_1
XFILLER_7_128 vssd1 vssd1 vccd1 vccd1 sky130_fd_sc_hd__fill_4
XFILLER_7_106 vssd1 vssd1 vccd1 vccd1 sky130_fd_sc_hd__fill_1
XFILLER_11_113 vssd1 vssd1 vccd1 vccd1 sky130_fd_sc_hd__fill_8
XFILLER_22_53 vssd1 vssd1 vccd1 vccd1 sky130_fd_sc_hd__fill_2
XFILLER_22_75 vssd1 vssd1 vccd1 vccd1 sky130_fd_sc_hd__fill_8
XANTENNA_fanout28_A net30 vssd1 vssd1 vccd1 vccd1 sky130_fd_sc_hd__diode_2
Xclkbuf_3_4__f_clk clknet_0_clk vssd1 vssd1 vccd1 vccd1 clknet_3_4__leaf_clk sky130_fd_sc_hd__clkbuf_16
X_0653_ net108 _0229_ _0231_ vssd1 vssd1 vccd1 vccd1 MATMULT_INST.uart_rcv.tim.clock_count.next_cnt_out\[13\]
+ sky130_fd_sc_hd__a21oi_1
X_0722_ _0264_ _0281_ _0280_ vssd1 vssd1 vccd1 vccd1 _0296_ sky130_fd_sc_hd__o21a_1
X_0584_ net5 MATMULT_INST.uart_rcv.tim.clk_cnt\[10\] vssd1 vssd1 vccd1 vccd1 _0176_
+ sky130_fd_sc_hd__nand2b_1
XFILLER_25_205 vssd1 vssd1 vccd1 vccd1 sky130_fd_sc_hd__fill_4
Xteam_07_50 vssd1 vssd1 vccd1 vccd1 team_07_50/HI gpio_out[9] sky130_fd_sc_hd__conb_1
Xteam_07_72 vssd1 vssd1 vccd1 vccd1 team_07_72/HI gpio_out[33] sky130_fd_sc_hd__conb_1
Xteam_07_94 vssd1 vssd1 vccd1 vccd1 gpio_oeb[24] team_07_94/LO sky130_fd_sc_hd__conb_1
Xteam_07_61 vssd1 vssd1 vccd1 vccd1 team_07_61/HI gpio_out[22] sky130_fd_sc_hd__conb_1
Xteam_07_83 vssd1 vssd1 vccd1 vccd1 gpio_oeb[10] team_07_83/LO sky130_fd_sc_hd__conb_1
XFILLER_16_205 vssd1 vssd1 vccd1 vccd1 sky130_fd_sc_hd__fill_1
XTAP_TAPCELL_ROW_26_200 vssd1 vccd1 sky130_fd_sc_hd__tapvpwrvgnd_1
XFILLER_33_96 vssd1 vssd1 vccd1 vccd1 sky130_fd_sc_hd__fill_2
Xhold4 MATMULT_INST.cntrl.data_ready vssd1 vssd1 vccd1 vccd1 net107 sky130_fd_sc_hd__dlygate4sd3_1
XANTENNA__0766__S net24 vssd1 vssd1 vccd1 vccd1 sky130_fd_sc_hd__diode_2
X_0636_ _0220_ net21 _0219_ vssd1 vssd1 vccd1 vccd1 MATMULT_INST.uart_rcv.tim.clock_count.next_cnt_out\[7\]
+ sky130_fd_sc_hd__and3b_1
X_0705_ _0267_ _0278_ _0268_ vssd1 vssd1 vccd1 vccd1 _0279_ sky130_fd_sc_hd__a21boi_1
X_0498_ MATMULT_INST.uart_tx.clk_cnt\[8\] net3 vssd1 vssd1 vccd1 vccd1 _0106_ sky130_fd_sc_hd__and2b_1
X_0567_ _0068_ MATMULT_INST.uart_tx.count.next_cnt_out\[0\] vssd1 vssd1 vccd1 vccd1
+ _0161_ sky130_fd_sc_hd__xnor2_1
XFILLER_13_208 vssd1 vssd1 vccd1 vccd1 sky130_fd_sc_hd__fill_8
XPHY_EDGE_ROW_17_Right_17 vssd1 vssd1 vccd1 vccd1 sky130_fd_sc_hd__decap_3
XFILLER_0_167 vssd1 vssd1 vccd1 vccd1 sky130_fd_sc_hd__fill_1
XPHY_EDGE_ROW_26_Right_26 vssd1 vssd1 vccd1 vccd1 sky130_fd_sc_hd__decap_3
XFILLER_0_189 vssd1 vssd1 vccd1 vccd1 sky130_fd_sc_hd__fill_2
XPHY_EDGE_ROW_35_Right_35 vssd1 vssd1 vccd1 vccd1 sky130_fd_sc_hd__decap_3
XPHY_EDGE_ROW_17_Left_56 vssd1 vssd1 vccd1 vccd1 sky130_fd_sc_hd__decap_3
X_0619_ MATMULT_INST.uart_rcv.tim.clk_cnt\[2\] _0206_ vssd1 vssd1 vccd1 vccd1 _0209_
+ sky130_fd_sc_hd__or2_1
XFILLER_38_193 vssd1 vssd1 vccd1 vccd1 sky130_fd_sc_hd__fill_2
X_0970_ clknet_3_4__leaf_clk _0016_ net31 vssd1 vssd1 vccd1 vccd1 MATMULT_INST.prod_adder.gen_for_loop\[2\].adder_n.a
+ sky130_fd_sc_hd__dfstp_1
XFILLER_18_119 vssd1 vssd1 vccd1 vccd1 sky130_fd_sc_hd__fill_4
XFILLER_26_141 vssd1 vssd1 vccd1 vccd1 sky130_fd_sc_hd__fill_4
XFILLER_37_9 vssd1 vssd1 vccd1 vccd1 sky130_fd_sc_hd__fill_1
XFILLER_1_251 vssd1 vssd1 vccd1 vccd1 sky130_fd_sc_hd__fill_1
XTAP_TAPCELL_ROW_19_169 vssd1 vccd1 sky130_fd_sc_hd__tapvpwrvgnd_1
X_0884_ MATMULT_INST.parallel_out2\[5\] MATMULT_INST.parallel_out2\[1\] MATMULT_INST.parallel_out2\[6\]
+ MATMULT_INST.parallel_out2\[0\] vssd1 vssd1 vccd1 vccd1 _0410_ sky130_fd_sc_hd__a22oi_1
X_0953_ clknet_3_3__leaf_clk MATMULT_INST.uart_tx.count.next_cnt_out\[8\] net37 vssd1
+ vssd1 vccd1 vccd1 MATMULT_INST.uart_tx.clk_cnt\[8\] sky130_fd_sc_hd__dfrtp_1
XFILLER_23_177 vssd1 vssd1 vccd1 vccd1 sky130_fd_sc_hd__fill_1
XFILLER_2_6 vccd1 vssd1 vccd1 vssd1 sky130_ef_sc_hd__decap_40_12
XFILLER_11_44 vssd1 vssd1 vccd1 vccd1 sky130_fd_sc_hd__fill_1
XTAP_TAPCELL_ROW_24_194 vssd1 vccd1 sky130_fd_sc_hd__tapvpwrvgnd_1
Xinput16 gpio_in[8] vssd1 vssd1 vccd1 vccd1 net16 sky130_fd_sc_hd__clkbuf_2
XFILLER_35_6 vssd1 vssd1 vccd1 vccd1 sky130_fd_sc_hd__fill_4
XANTENNA__0769__S net24 vssd1 vssd1 vccd1 vccd1 sky130_fd_sc_hd__diode_2
XFILLER_37_225 vssd1 vssd1 vccd1 vccd1 sky130_fd_sc_hd__fill_4
XTAP_TAPCELL_ROW_15_150 vssd1 vccd1 sky130_fd_sc_hd__tapvpwrvgnd_1
X_0936_ MATMULT_INST.rx_data\[5\] MATMULT_INST.uart_rcv.data_buff.packet_data\[5\]
+ _0447_ vssd1 vssd1 vccd1 vccd1 _0059_ sky130_fd_sc_hd__mux2_1
X_0798_ _0350_ _0352_ vssd1 vssd1 vccd1 vccd1 _0353_ sky130_fd_sc_hd__or2_1
X_0867_ _0096_ _0398_ vssd1 vssd1 vccd1 vccd1 _0399_ sky130_fd_sc_hd__or2_1
XTAP_TAPCELL_ROW_38_253 vssd1 vccd1 sky130_fd_sc_hd__tapvpwrvgnd_1
XPHY_EDGE_ROW_5_Left_44 vssd1 vssd1 vccd1 vccd1 sky130_fd_sc_hd__decap_3
X_0652_ MATMULT_INST.uart_rcv.tim.clk_cnt\[13\] _0229_ net21 vssd1 vssd1 vccd1 vccd1
+ _0231_ sky130_fd_sc_hd__o21ai_1
X_0721_ _0262_ _0284_ _0294_ vssd1 vssd1 vccd1 vccd1 _0295_ sky130_fd_sc_hd__o21a_1
XFILLER_10_180 vssd1 vssd1 vccd1 vccd1 sky130_fd_sc_hd__fill_1
X_0583_ net17 _0080_ MATMULT_INST.uart_rcv.tim.clk_cnt\[10\] _0076_ vssd1 vssd1 vccd1
+ vccd1 _0175_ sky130_fd_sc_hd__o22a_1
X_0919_ _0439_ _0441_ vssd1 vssd1 vccd1 vccd1 _0442_ sky130_fd_sc_hd__xnor2_1
Xteam_07_51 vssd1 vssd1 vccd1 vccd1 team_07_51/HI gpio_out[10] sky130_fd_sc_hd__conb_1
Xteam_07_62 vssd1 vssd1 vccd1 vccd1 team_07_62/HI gpio_out[23] sky130_fd_sc_hd__conb_1
Xteam_07_84 vssd1 vssd1 vccd1 vccd1 gpio_oeb[11] team_07_84/LO sky130_fd_sc_hd__conb_1
Xteam_07_73 vssd1 vssd1 vccd1 vccd1 gpio_oeb[0] team_07_73/LO sky130_fd_sc_hd__conb_1
Xteam_07_40 vssd1 vssd1 vccd1 vccd1 team_07_40/HI gpio_oeb[18] sky130_fd_sc_hd__conb_1
Xteam_07_95 vssd1 vssd1 vccd1 vccd1 gpio_oeb[25] team_07_95/LO sky130_fd_sc_hd__conb_1
XFILLER_16_217 vssd1 vssd1 vccd1 vccd1 sky130_fd_sc_hd__fill_2
XFILLER_16_228 vccd1 vssd1 vccd1 vssd1 sky130_ef_sc_hd__decap_40_12
XTAP_TAPCELL_ROW_26_201 vssd1 vccd1 sky130_fd_sc_hd__tapvpwrvgnd_1
XFILLER_33_42 vssd1 vssd1 vccd1 vccd1 sky130_fd_sc_hd__fill_1
Xhold5 MATMULT_INST.uart_rcv.tim.clk_cnt\[13\] vssd1 vssd1 vccd1 vccd1 net108 sky130_fd_sc_hd__dlygate4sd3_1
XTAP_TAPCELL_ROW_32_226 vssd1 vccd1 sky130_fd_sc_hd__tapvpwrvgnd_1
XFILLER_30_253 vssd1 vssd1 vccd1 vccd1 sky130_fd_sc_hd__fill_2
X_0635_ MATMULT_INST.uart_rcv.tim.clk_cnt\[7\] _0217_ vssd1 vssd1 vccd1 vccd1 _0220_
+ sky130_fd_sc_hd__and2_1
X_0704_ _0082_ _0276_ _0277_ vssd1 vssd1 vccd1 vccd1 _0278_ sky130_fd_sc_hd__a21bo_1
X_0566_ net14 _0136_ _0139_ net15 vssd1 vssd1 vccd1 vccd1 _0160_ sky130_fd_sc_hd__a22o_1
X_0497_ net10 MATMULT_INST.uart_tx.clk_cnt\[0\] vssd1 vssd1 vccd1 vccd1 _0105_ sky130_fd_sc_hd__and2b_1
XFILLER_0_90 vssd1 vssd1 vccd1 vccd1 sky130_fd_sc_hd__fill_4
XFILLER_0_113 vccd1 vssd1 vccd1 vssd1 sky130_ef_sc_hd__decap_40_12
XFILLER_28_20 vssd1 vssd1 vccd1 vccd1 sky130_fd_sc_hd__fill_8
XFILLER_8_246 vssd1 vssd1 vccd1 vccd1 sky130_fd_sc_hd__fill_4
XFILLER_12_253 vssd1 vssd1 vccd1 vccd1 sky130_fd_sc_hd__fill_2
XFILLER_5_57 vssd1 vssd1 vccd1 vccd1 sky130_fd_sc_hd__fill_4
XANTENNA__0953__RESET_B net37 vssd1 vssd1 vccd1 vccd1 sky130_fd_sc_hd__diode_2
X_0549_ _0147_ _0128_ _0146_ vssd1 vssd1 vccd1 vccd1 MATMULT_INST.uart_tx.count.next_cnt_out\[9\]
+ sky130_fd_sc_hd__and3b_1
X_0618_ MATMULT_INST.uart_rcv.tim.clk_cnt\[1\] MATMULT_INST.uart_rcv.tim.clk_cnt\[2\]
+ _0203_ vssd1 vssd1 vccd1 vccd1 _0208_ sky130_fd_sc_hd__and3_1
XPHY_EDGE_ROW_34_Left_73 vssd1 vssd1 vccd1 vccd1 sky130_fd_sc_hd__decap_3
XFILLER_35_142 vssd1 vssd1 vccd1 vccd1 sky130_fd_sc_hd__fill_4
XFILLER_35_131 vssd1 vssd1 vccd1 vccd1 sky130_fd_sc_hd__fill_2
XFILLER_25_43 vssd1 vssd1 vccd1 vccd1 sky130_fd_sc_hd__fill_4
XFILLER_26_131 vssd1 vssd1 vccd1 vccd1 sky130_fd_sc_hd__fill_4
XFILLER_32_189 vssd1 vssd1 vccd1 vccd1 sky130_fd_sc_hd__fill_4
X_0952_ clknet_3_3__leaf_clk MATMULT_INST.uart_tx.count.next_cnt_out\[7\] net37 vssd1
+ vssd1 vccd1 vccd1 MATMULT_INST.uart_tx.clk_cnt\[7\] sky130_fd_sc_hd__dfrtp_2
X_0883_ MATMULT_INST.parallel_out2\[0\] MATMULT_INST.parallel_out2\[5\] MATMULT_INST.parallel_out2\[1\]
+ MATMULT_INST.parallel_out2\[6\] vssd1 vssd1 vccd1 vccd1 _0409_ sky130_fd_sc_hd__and4_1
XFILLER_23_134 vssd1 vssd1 vccd1 vccd1 sky130_fd_sc_hd__fill_8
XFILLER_23_156 vccd1 vssd1 vccd1 vssd1 sky130_ef_sc_hd__decap_40_12
Xinput17 gpio_in[9] vssd1 vssd1 vccd1 vccd1 net17 sky130_fd_sc_hd__clkbuf_2
X_0935_ MATMULT_INST.rx_data\[4\] MATMULT_INST.uart_rcv.data_buff.packet_data\[4\]
+ _0447_ vssd1 vssd1 vccd1 vccd1 _0058_ sky130_fd_sc_hd__mux2_1
XTAP_TAPCELL_ROW_15_151 vssd1 vccd1 sky130_fd_sc_hd__tapvpwrvgnd_1
X_0866_ MATMULT_INST.cntrl.state\[2\] _0381_ vssd1 vssd1 vccd1 vccd1 _0398_ sky130_fd_sc_hd__nor2_1
XPHY_EDGE_ROW_21_Left_60 vssd1 vssd1 vccd1 vccd1 sky130_fd_sc_hd__decap_3
X_0797_ _0347_ _0351_ vssd1 vssd1 vccd1 vccd1 _0352_ sky130_fd_sc_hd__or2_1
XTAP_TAPCELL_ROW_38_254 vssd1 vccd1 sky130_fd_sc_hd__tapvpwrvgnd_1
XFILLER_22_55 vssd1 vssd1 vccd1 vccd1 sky130_fd_sc_hd__fill_1
X_0720_ _0261_ _0286_ vssd1 vssd1 vccd1 vccd1 _0294_ sky130_fd_sc_hd__or2_1
X_0651_ _0229_ _0230_ vssd1 vssd1 vccd1 vccd1 MATMULT_INST.uart_rcv.tim.clock_count.next_cnt_out\[12\]
+ sky130_fd_sc_hd__nor2_1
X_0582_ MATMULT_INST.uart_rcv.tim.bit_count.next_cnt_out\[1\] MATMULT_INST.uart_rcv.tim.bit_count.next_cnt_out\[2\]
+ MATMULT_INST.uart_rcv.tim.bit_count.next_cnt_out\[3\] MATMULT_INST.uart_rcv.tim.bit_count.next_cnt_out\[0\]
+ vssd1 vssd1 vccd1 vccd1 MATMULT_INST.uart_rcv.tim.bit_count.next_roflag sky130_fd_sc_hd__and4bb_1
XFILLER_6_141 vssd1 vssd1 vccd1 vccd1 sky130_fd_sc_hd__fill_2
XFILLER_25_218 vssd1 vssd1 vccd1 vccd1 sky130_fd_sc_hd__fill_4
X_0918_ _0434_ _0440_ vssd1 vssd1 vccd1 vccd1 _0441_ sky130_fd_sc_hd__xnor2_1
X_0849_ net9 _0382_ _0379_ net2 vssd1 vssd1 vccd1 vccd1 _0383_ sky130_fd_sc_hd__o2bb2a_1
Xteam_07_74 vssd1 vssd1 vccd1 vccd1 gpio_oeb[1] team_07_74/LO sky130_fd_sc_hd__conb_1
Xteam_07_41 vssd1 vssd1 vccd1 vccd1 team_07_41/HI gpio_out[0] sky130_fd_sc_hd__conb_1
Xteam_07_63 vssd1 vssd1 vccd1 vccd1 team_07_63/HI gpio_out[24] sky130_fd_sc_hd__conb_1
Xteam_07_85 vssd1 vssd1 vccd1 vccd1 gpio_oeb[12] team_07_85/LO sky130_fd_sc_hd__conb_1
Xteam_07_52 vssd1 vssd1 vccd1 vccd1 team_07_52/HI gpio_out[11] sky130_fd_sc_hd__conb_1
Xteam_07_96 vssd1 vssd1 vccd1 vccd1 gpio_oeb[26] team_07_96/LO sky130_fd_sc_hd__conb_1
XFILLER_17_55 vssd1 vssd1 vccd1 vccd1 sky130_fd_sc_hd__fill_1
XTAP_TAPCELL_ROW_26_202 vssd1 vccd1 sky130_fd_sc_hd__tapvpwrvgnd_1
XFILLER_33_65 vssd1 vssd1 vccd1 vccd1 sky130_fd_sc_hd__fill_2
XFILLER_33_32 vssd1 vssd1 vccd1 vccd1 sky130_fd_sc_hd__fill_8
XFILLER_24_251 vssd1 vssd1 vccd1 vccd1 sky130_fd_sc_hd__fill_1
Xhold6 MATMULT_INST.cntrl.overrun_error vssd1 vssd1 vccd1 vccd1 net109 sky130_fd_sc_hd__dlygate4sd3_1
XTAP_TAPCELL_ROW_32_227 vssd1 vccd1 sky130_fd_sc_hd__tapvpwrvgnd_1
X_0703_ MATMULT_INST.prod_adder.gen_for_loop\[3\].adder_n.a _0274_ _0275_ vssd1 vssd1
+ vccd1 vccd1 _0277_ sky130_fd_sc_hd__or3_1
XFILLER_30_243 vssd1 vssd1 vccd1 vccd1 sky130_fd_sc_hd__fill_4
X_0634_ MATMULT_INST.uart_rcv.tim.clk_cnt\[7\] _0217_ vssd1 vssd1 vccd1 vccd1 _0219_
+ sky130_fd_sc_hd__or2_1
X_0496_ MATMULT_INST.uart_tx.tx_ctrl.state\[0\] _0100_ _0102_ vssd1 vssd1 vccd1 vccd1
+ _0104_ sky130_fd_sc_hd__or3_1
X_0565_ net12 MATMULT_INST.uart_tx.count.next_cnt_out\[2\] vssd1 vssd1 vccd1 vccd1
+ _0159_ sky130_fd_sc_hd__xor2_1
XPHY_EDGE_ROW_3_Right_3 vssd1 vssd1 vccd1 vccd1 sky130_fd_sc_hd__decap_3
XFILLER_0_125 vccd1 vssd1 vccd1 vssd1 sky130_ef_sc_hd__decap_40_12
XFILLER_0_169 vccd1 vssd1 vccd1 vssd1 sky130_ef_sc_hd__decap_40_12
XFILLER_28_65 vssd1 vssd1 vccd1 vccd1 sky130_fd_sc_hd__fill_1
X_0617_ _0206_ _0207_ net21 vssd1 vssd1 vccd1 vccd1 MATMULT_INST.uart_rcv.tim.clock_count.next_cnt_out\[1\]
+ sky130_fd_sc_hd__and3b_1
X_0479_ MATMULT_INST.cntrl.state\[3\] MATMULT_INST.cntrl.state\[2\] vssd1 vssd1 vccd1
+ vccd1 _0090_ sky130_fd_sc_hd__or2_1
X_0548_ MATMULT_INST.uart_tx.clk_cnt\[9\] _0144_ vssd1 vssd1 vccd1 vccd1 _0147_ sky130_fd_sc_hd__and2_1
XFILLER_38_195 vssd1 vssd1 vccd1 vccd1 sky130_fd_sc_hd__fill_1
XFILLER_5_228 vssd1 vssd1 vccd1 vccd1 sky130_fd_sc_hd__fill_2
XFILLER_5_206 vccd1 vssd1 vccd1 vssd1 sky130_ef_sc_hd__decap_40_12
XFILLER_30_66 vssd1 vssd1 vccd1 vccd1 sky130_fd_sc_hd__fill_8
XFILLER_30_77 vssd1 vssd1 vccd1 vccd1 sky130_fd_sc_hd__fill_4
XFILLER_30_99 vssd1 vssd1 vccd1 vccd1 sky130_fd_sc_hd__fill_1
XANTENNA_input13_A gpio_in[5] vssd1 vssd1 vccd1 vccd1 sky130_fd_sc_hd__diode_2
XFILLER_2_209 vccd1 vssd1 vccd1 vssd1 sky130_ef_sc_hd__decap_40_12
XANTENNA_input5_A gpio_in[12] vssd1 vssd1 vccd1 vccd1 sky130_fd_sc_hd__diode_2
XFILLER_26_121 vssd1 vssd1 vccd1 vccd1 sky130_fd_sc_hd__fill_1
XFILLER_26_154 vssd1 vssd1 vccd1 vccd1 sky130_fd_sc_hd__fill_2
Xteam_07_100 vssd1 vssd1 vccd1 vccd1 gpio_oeb[30] team_07_100/LO sky130_fd_sc_hd__conb_1
XFILLER_2_26 vssd1 vssd1 vccd1 vccd1 sky130_fd_sc_hd__fill_2
XFILLER_32_157 vssd1 vssd1 vccd1 vccd1 sky130_fd_sc_hd__fill_2
X_0882_ MATMULT_INST.parallel_out2\[4\] MATMULT_INST.parallel_out2\[2\] vssd1 vssd1
+ vccd1 vccd1 _0408_ sky130_fd_sc_hd__and2_1
X_0951_ clknet_3_2__leaf_clk MATMULT_INST.uart_tx.count.next_cnt_out\[6\] net28 vssd1
+ vssd1 vccd1 vccd1 MATMULT_INST.uart_tx.clk_cnt\[6\] sky130_fd_sc_hd__dfrtp_1
XTAP_TAPCELL_ROW_2_91 vssd1 vccd1 sky130_fd_sc_hd__tapvpwrvgnd_1
XFILLER_11_57 vssd1 vssd1 vccd1 vccd1 sky130_fd_sc_hd__fill_4
XFILLER_14_146 vssd1 vssd1 vccd1 vccd1 sky130_fd_sc_hd__fill_8
Xinput18 nrst vssd1 vssd1 vccd1 vccd1 net18 sky130_fd_sc_hd__clkbuf_1
XFILLER_37_238 vssd1 vssd1 vccd1 vccd1 sky130_fd_sc_hd__fill_8
XTAP_TAPCELL_ROW_15_152 vssd1 vccd1 sky130_fd_sc_hd__tapvpwrvgnd_1
X_0934_ MATMULT_INST.rx_data\[3\] MATMULT_INST.uart_rcv.data_buff.packet_data\[3\]
+ _0447_ vssd1 vssd1 vccd1 vccd1 _0057_ sky130_fd_sc_hd__mux2_1
X_0865_ _0397_ MATMULT_INST.cntrl.state\[1\] _0384_ vssd1 vssd1 vccd1 vccd1 _0039_
+ sky130_fd_sc_hd__mux2_1
X_0796_ MATMULT_INST.parallel_out1\[4\] MATMULT_INST.parallel_out1\[3\] _0346_ vssd1
+ vssd1 vccd1 vccd1 _0351_ sky130_fd_sc_hd__a21oi_1
XTAP_TAPCELL_ROW_38_255 vssd1 vccd1 sky130_fd_sc_hd__tapvpwrvgnd_1
XFILLER_11_127 vccd1 vssd1 vccd1 vssd1 sky130_ef_sc_hd__decap_40_12
XTAP_TAPCELL_ROW_21_177 vssd1 vccd1 sky130_fd_sc_hd__tapvpwrvgnd_1
XFILLER_22_89 vccd1 vssd1 vccd1 vssd1 sky130_ef_sc_hd__decap_40_12
X_0650_ MATMULT_INST.uart_rcv.tim.clk_cnt\[12\] _0227_ _0205_ vssd1 vssd1 vccd1 vccd1
+ _0230_ sky130_fd_sc_hd__o21ai_1
XFILLER_6_197 vssd1 vssd1 vccd1 vccd1 sky130_fd_sc_hd__fill_1
X_0581_ _0168_ _0169_ _0170_ _0174_ vssd1 vssd1 vccd1 vccd1 MATMULT_INST.uart_tx.count.next_roflag
+ sky130_fd_sc_hd__and4b_1
XFILLER_19_3 vccd1 vssd1 vccd1 vssd1 sky130_ef_sc_hd__decap_40_12
X_0917_ MATMULT_INST.parallel_out2\[2\] _0426_ _0427_ _0429_ vssd1 vssd1 vccd1 vccd1
+ _0440_ sky130_fd_sc_hd__a22o_1
X_0779_ MATMULT_INST.parallel_out1\[4\] MATMULT_INST.parallel_out1\[2\] vssd1 vssd1
+ vccd1 vccd1 _0335_ sky130_fd_sc_hd__and2_1
X_0848_ _0090_ _0381_ _0380_ _0089_ vssd1 vssd1 vccd1 vccd1 _0382_ sky130_fd_sc_hd__a2bb2o_1
Xteam_07_64 vssd1 vssd1 vccd1 vccd1 team_07_64/HI gpio_out[25] sky130_fd_sc_hd__conb_1
Xteam_07_86 vssd1 vssd1 vccd1 vccd1 gpio_oeb[13] team_07_86/LO sky130_fd_sc_hd__conb_1
Xteam_07_97 vssd1 vssd1 vccd1 vccd1 gpio_oeb[27] team_07_97/LO sky130_fd_sc_hd__conb_1
Xteam_07_42 vssd1 vssd1 vccd1 vccd1 team_07_42/HI gpio_out[1] sky130_fd_sc_hd__conb_1
Xteam_07_75 vssd1 vssd1 vccd1 vccd1 gpio_oeb[2] team_07_75/LO sky130_fd_sc_hd__conb_1
Xteam_07_53 vssd1 vssd1 vccd1 vccd1 team_07_53/HI gpio_out[12] sky130_fd_sc_hd__conb_1
XFILLER_16_219 vssd1 vssd1 vccd1 vccd1 sky130_fd_sc_hd__fill_1
XFILLER_17_23 vssd1 vssd1 vccd1 vccd1 sky130_fd_sc_hd__fill_2
XTAP_TAPCELL_ROW_26_203 vssd1 vccd1 sky130_fd_sc_hd__tapvpwrvgnd_1
XFILLER_33_55 vssd1 vssd1 vccd1 vccd1 sky130_fd_sc_hd__fill_1
XFILLER_33_22 vssd1 vssd1 vccd1 vccd1 sky130_fd_sc_hd__fill_4
XFILLER_3_134 vssd1 vssd1 vccd1 vccd1 sky130_fd_sc_hd__fill_4
XFILLER_3_101 vssd1 vssd1 vccd1 vccd1 sky130_fd_sc_hd__fill_4
Xhold7 MATMULT_INST.uart_rcv.tim.bit_cnt\[3\] vssd1 vssd1 vccd1 vccd1 net110 sky130_fd_sc_hd__dlygate4sd3_1
XTAP_TAPCELL_ROW_32_228 vssd1 vccd1 sky130_fd_sc_hd__tapvpwrvgnd_1
X_0633_ _0217_ _0218_ vssd1 vssd1 vccd1 vccd1 MATMULT_INST.uart_rcv.tim.clock_count.next_cnt_out\[6\]
+ sky130_fd_sc_hd__nor2_1
X_0702_ _0274_ _0275_ MATMULT_INST.prod_adder.gen_for_loop\[3\].adder_n.a vssd1 vssd1
+ vccd1 vccd1 _0276_ sky130_fd_sc_hd__o21ai_1
X_0495_ MATMULT_INST.uart_tx.tx_ctrl.state\[0\] _0102_ vssd1 vssd1 vccd1 vccd1 _0103_
+ sky130_fd_sc_hd__nor2_1
X_0564_ net17 MATMULT_INST.uart_tx.count.next_cnt_out\[7\] vssd1 vssd1 vccd1 vccd1
+ _0158_ sky130_fd_sc_hd__xor2_1
XFILLER_21_222 vssd1 vssd1 vccd1 vccd1 sky130_fd_sc_hd__fill_2
XFILLER_21_244 vssd1 vssd1 vccd1 vccd1 sky130_fd_sc_hd__fill_2
XFILLER_0_137 vssd1 vssd1 vccd1 vccd1 sky130_fd_sc_hd__fill_2
XPHY_EDGE_ROW_13_Right_13 vssd1 vssd1 vccd1 vccd1 sky130_fd_sc_hd__decap_3
XANTENNA__0927__X _0447_ vssd1 vssd1 vccd1 vccd1 sky130_fd_sc_hd__diode_2
XPHY_EDGE_ROW_22_Right_22 vssd1 vssd1 vccd1 vccd1 sky130_fd_sc_hd__decap_3
X_0616_ MATMULT_INST.uart_rcv.tim.clk_cnt\[1\] _0203_ vssd1 vssd1 vccd1 vccd1 _0207_
+ sky130_fd_sc_hd__or2_1
XPHY_EDGE_ROW_31_Right_31 vssd1 vssd1 vccd1 vccd1 sky130_fd_sc_hd__decap_3
X_0478_ MATMULT_INST.cntrl.state\[4\] _0064_ vssd1 vssd1 vccd1 vccd1 _0089_ sky130_fd_sc_hd__or2_1
X_0547_ MATMULT_INST.uart_tx.clk_cnt\[9\] _0144_ vssd1 vssd1 vccd1 vccd1 _0146_ sky130_fd_sc_hd__or2_1
XFILLER_38_174 vssd1 vssd1 vccd1 vccd1 sky130_fd_sc_hd__fill_4
XFILLER_5_218 vssd1 vssd1 vccd1 vccd1 sky130_fd_sc_hd__fill_4
XFILLER_30_89 vssd1 vssd1 vccd1 vccd1 sky130_fd_sc_hd__fill_2
XFILLER_35_155 vssd1 vssd1 vccd1 vccd1 sky130_fd_sc_hd__fill_4
XFILLER_35_111 vssd1 vssd1 vccd1 vccd1 sky130_fd_sc_hd__fill_1
XANTENNA_clkbuf_0_clk_X clknet_0_clk vssd1 vssd1 vccd1 vccd1 sky130_fd_sc_hd__diode_2
XFILLER_26_111 vssd1 vssd1 vccd1 vccd1 sky130_fd_sc_hd__fill_1
Xteam_07_101 vssd1 vssd1 vccd1 vccd1 gpio_oeb[31] team_07_101/LO sky130_fd_sc_hd__conb_1
XFILLER_1_221 vssd1 vssd1 vccd1 vccd1 sky130_fd_sc_hd__fill_2
X_0881_ net111 _0402_ vssd1 vssd1 vccd1 vccd1 _0407_ sky130_fd_sc_hd__nand2_1
X_0950_ clknet_3_2__leaf_clk MATMULT_INST.uart_tx.count.next_cnt_out\[5\] net28 vssd1
+ vssd1 vccd1 vccd1 MATMULT_INST.uart_tx.clk_cnt\[5\] sky130_fd_sc_hd__dfrtp_1
XTAP_TAPCELL_ROW_2_92 vssd1 vccd1 sky130_fd_sc_hd__tapvpwrvgnd_1
XFILLER_23_169 vssd1 vssd1 vccd1 vccd1 sky130_fd_sc_hd__fill_8
XANTENNA__1012__RESET_B net30 vssd1 vssd1 vccd1 vccd1 sky130_fd_sc_hd__diode_2
XFILLER_36_55 vssd1 vssd1 vccd1 vccd1 sky130_fd_sc_hd__fill_4
XFILLER_22_191 vssd1 vssd1 vccd1 vccd1 sky130_fd_sc_hd__fill_1
XTAP_TAPCELL_ROW_15_153 vssd1 vccd1 sky130_fd_sc_hd__tapvpwrvgnd_1
XFILLER_20_106 vccd1 vssd1 vccd1 vssd1 sky130_ef_sc_hd__decap_40_12
XFILLER_9_173 vssd1 vssd1 vccd1 vccd1 sky130_fd_sc_hd__fill_2
X_0933_ MATMULT_INST.rx_data\[2\] MATMULT_INST.uart_rcv.data_buff.packet_data\[2\]
+ _0447_ vssd1 vssd1 vccd1 vccd1 _0056_ sky130_fd_sc_hd__mux2_1
X_0795_ _0340_ _0349_ vssd1 vssd1 vccd1 vccd1 _0350_ sky130_fd_sc_hd__xnor2_1
X_0864_ MATMULT_INST.cntrl.data_read _0394_ _0395_ _0396_ vssd1 vssd1 vccd1 vccd1
+ _0397_ sky130_fd_sc_hd__or4b_1
XTAP_TAPCELL_ROW_38_256 vssd1 vccd1 sky130_fd_sc_hd__tapvpwrvgnd_1
XFILLER_11_139 vssd1 vssd1 vccd1 vccd1 sky130_fd_sc_hd__fill_8
XTAP_TAPCELL_ROW_21_178 vssd1 vccd1 sky130_fd_sc_hd__tapvpwrvgnd_1
XANTENNA_clkbuf_3_2__f_clk_A clknet_0_clk vssd1 vssd1 vccd1 vccd1 sky130_fd_sc_hd__diode_2
XTAP_TAPCELL_ROW_6_110 vssd1 vccd1 sky130_fd_sc_hd__tapvpwrvgnd_1
XFILLER_19_228 vssd1 vssd1 vccd1 vccd1 sky130_fd_sc_hd__fill_1
XFILLER_8_15 vccd1 vssd1 vccd1 vssd1 sky130_ef_sc_hd__decap_40_12
XFILLER_10_150 vssd1 vssd1 vccd1 vccd1 sky130_fd_sc_hd__fill_2
X_0580_ _0171_ _0172_ _0173_ vssd1 vssd1 vccd1 vccd1 _0174_ sky130_fd_sc_hd__and3_1
XFILLER_33_253 vssd1 vssd1 vccd1 vccd1 sky130_fd_sc_hd__fill_2
X_0916_ _0437_ _0438_ vssd1 vssd1 vccd1 vccd1 _0439_ sky130_fd_sc_hd__nand2b_1
X_0778_ net121 _0330_ _0334_ vssd1 vssd1 vccd1 vccd1 _0015_ sky130_fd_sc_hd__a21o_1
X_0847_ _0063_ _0089_ vssd1 vssd1 vccd1 vccd1 _0381_ sky130_fd_sc_hd__or2_1
Xteam_07_76 vssd1 vssd1 vccd1 vccd1 gpio_oeb[3] team_07_76/LO sky130_fd_sc_hd__conb_1
Xteam_07_54 vssd1 vssd1 vccd1 vccd1 team_07_54/HI gpio_out[13] sky130_fd_sc_hd__conb_1
Xteam_07_65 vssd1 vssd1 vccd1 vccd1 team_07_65/HI gpio_out[26] sky130_fd_sc_hd__conb_1
Xteam_07_98 vssd1 vssd1 vccd1 vccd1 gpio_oeb[28] team_07_98/LO sky130_fd_sc_hd__conb_1
Xteam_07_87 vssd1 vssd1 vccd1 vccd1 gpio_oeb[14] team_07_87/LO sky130_fd_sc_hd__conb_1
Xteam_07_43 vssd1 vssd1 vccd1 vccd1 team_07_43/HI gpio_out[2] sky130_fd_sc_hd__conb_1
XPHY_EDGE_ROW_9_Left_48 vssd1 vssd1 vccd1 vccd1 sky130_fd_sc_hd__decap_3
XFILLER_16_209 vssd1 vssd1 vccd1 vccd1 sky130_fd_sc_hd__fill_4
XFILLER_17_68 vssd1 vssd1 vccd1 vccd1 sky130_fd_sc_hd__fill_1
XFILLER_24_253 vssd1 vssd1 vccd1 vccd1 sky130_fd_sc_hd__fill_2
XFILLER_33_78 vccd1 vssd1 vccd1 vssd1 sky130_ef_sc_hd__decap_40_12
XFILLER_33_67 vssd1 vssd1 vccd1 vccd1 sky130_fd_sc_hd__fill_1
Xhold8 MATMULT_INST.prod_adder.gen_for_loop\[2\].adder_n.b vssd1 vssd1 vccd1 vccd1
+ net111 sky130_fd_sc_hd__dlygate4sd3_1
XTAP_TAPCELL_ROW_32_229 vssd1 vccd1 sky130_fd_sc_hd__tapvpwrvgnd_1
X_0632_ MATMULT_INST.uart_rcv.tim.clk_cnt\[6\] _0214_ net21 vssd1 vssd1 vccd1 vccd1
+ _0218_ sky130_fd_sc_hd__o21ai_1
X_0701_ MATMULT_INST.prod_adder.gen_for_loop\[2\].adder_n.a _0270_ _0272_ MATMULT_INST.prod_adder.gen_for_loop\[2\].adder_n.b
+ vssd1 vssd1 vccd1 vccd1 _0275_ sky130_fd_sc_hd__o31a_1
X_0563_ _0071_ MATMULT_INST.uart_tx.count.next_cnt_out\[3\] vssd1 vssd1 vccd1 vccd1
+ _0157_ sky130_fd_sc_hd__xnor2_1
X_0494_ MATMULT_INST.uart_tx.tx_ctrl.state\[4\] MATMULT_INST.uart_tx.tx_ctrl.state\[1\]
+ MATMULT_INST.uart_tx.tx_ctrl.state\[2\] MATMULT_INST.uart_tx.tx_ctrl.state\[3\]
+ vssd1 vssd1 vccd1 vccd1 _0102_ sky130_fd_sc_hd__or4_1
X_0546_ _0145_ vssd1 vssd1 vccd1 vccd1 MATMULT_INST.uart_tx.count.next_cnt_out\[8\]
+ sky130_fd_sc_hd__inv_2
X_0615_ MATMULT_INST.uart_rcv.tim.clk_cnt\[1\] _0203_ vssd1 vssd1 vccd1 vccd1 _0206_
+ sky130_fd_sc_hd__and2_1
X_0477_ MATMULT_INST.uart_rcv.tim.bit_cnt\[0\] net117 _0088_ vssd1 vssd1 vccd1 vccd1
+ MATMULT_INST.uart_rcv.tim.bit_count.next_cnt_out\[0\] sky130_fd_sc_hd__o21a_1
XFILLER_38_197 vssd1 vssd1 vccd1 vccd1 sky130_fd_sc_hd__fill_4
X_1029_ clknet_3_7__leaf_clk _0052_ net34 vssd1 vssd1 vccd1 vccd1 MATMULT_INST.cntrl.overrun_error
+ sky130_fd_sc_hd__dfrtp_1
XFILLER_29_131 vssd1 vssd1 vccd1 vccd1 sky130_fd_sc_hd__fill_1
XFILLER_6_81 vssd1 vssd1 vccd1 vccd1 sky130_fd_sc_hd__fill_2
X_0529_ MATMULT_INST.uart_tx.clk_cnt\[3\] _0131_ vssd1 vssd1 vccd1 vccd1 _0134_ sky130_fd_sc_hd__or2_1
XFILLER_26_145 vssd1 vssd1 vccd1 vccd1 sky130_fd_sc_hd__fill_2
XPHY_EDGE_ROW_38_Left_77 vssd1 vssd1 vccd1 vccd1 sky130_fd_sc_hd__decap_3
Xteam_07_102 vssd1 vssd1 vccd1 vccd1 gpio_oeb[32] team_07_102/LO sky130_fd_sc_hd__conb_1
XFILLER_9_3 vccd1 vssd1 vccd1 vssd1 sky130_ef_sc_hd__decap_40_12
XFILLER_17_123 vssd1 vssd1 vccd1 vccd1 sky130_fd_sc_hd__fill_4
XFILLER_17_134 vccd1 vssd1 vccd1 vssd1 sky130_ef_sc_hd__decap_40_12
X_0880_ _0406_ MATMULT_INST.prod_adder.gen_for_loop\[1\].adder_n.b _0402_ vssd1 vssd1
+ vccd1 vccd1 _0045_ sky130_fd_sc_hd__mux2_1
XTAP_TAPCELL_ROW_2_93 vssd1 vccd1 sky130_fd_sc_hd__tapvpwrvgnd_1
XFILLER_23_104 vssd1 vssd1 vccd1 vccd1 sky130_fd_sc_hd__fill_4
XFILLER_11_15 vssd1 vssd1 vccd1 vccd1 sky130_fd_sc_hd__fill_4
XFILLER_14_137 vssd1 vssd1 vccd1 vccd1 sky130_fd_sc_hd__fill_2
XFILLER_37_229 vssd1 vssd1 vccd1 vccd1 sky130_fd_sc_hd__fill_1
X_0932_ MATMULT_INST.rx_data\[1\] MATMULT_INST.uart_rcv.data_buff.packet_data\[1\]
+ _0447_ vssd1 vssd1 vccd1 vccd1 _0055_ sky130_fd_sc_hd__mux2_1
X_0794_ _0335_ _0336_ _0337_ vssd1 vssd1 vccd1 vccd1 _0349_ sky130_fd_sc_hd__o21ba_1
X_0863_ _0064_ _0328_ _0375_ _0377_ vssd1 vssd1 vccd1 vccd1 _0396_ sky130_fd_sc_hd__o22a_1
XTAP_TAPCELL_ROW_38_257 vssd1 vccd1 sky130_fd_sc_hd__tapvpwrvgnd_1
XTAP_TAPCELL_ROW_21_179 vssd1 vccd1 sky130_fd_sc_hd__tapvpwrvgnd_1
XTAP_TAPCELL_ROW_6_111 vssd1 vccd1 sky130_fd_sc_hd__tapvpwrvgnd_1
XTAP_TAPCELL_ROW_29_213 vssd1 vccd1 sky130_fd_sc_hd__tapvpwrvgnd_1
XFILLER_8_27 vssd1 vssd1 vccd1 vccd1 sky130_fd_sc_hd__fill_1
XFILLER_6_188 vssd1 vssd1 vccd1 vccd1 sky130_fd_sc_hd__fill_8
XPHY_EDGE_ROW_25_Left_64 vssd1 vssd1 vccd1 vccd1 sky130_fd_sc_hd__decap_3
X_0915_ MATMULT_INST.parallel_out2\[2\] MATMULT_INST.parallel_out2\[7\] MATMULT_INST.parallel_out2\[3\]
+ MATMULT_INST.parallel_out2\[6\] vssd1 vssd1 vccd1 vccd1 _0438_ sky130_fd_sc_hd__a22o_1
Xteam_07_66 vssd1 vssd1 vccd1 vccd1 team_07_66/HI gpio_out[27] sky130_fd_sc_hd__conb_1
Xteam_07_55 vssd1 vssd1 vccd1 vccd1 team_07_55/HI gpio_out[14] sky130_fd_sc_hd__conb_1
X_0777_ _0329_ _0332_ _0333_ vssd1 vssd1 vccd1 vccd1 _0334_ sky130_fd_sc_hd__and3_1
Xteam_07_44 vssd1 vssd1 vccd1 vccd1 team_07_44/HI gpio_out[3] sky130_fd_sc_hd__conb_1
X_0846_ MATMULT_INST.cntrl.state\[4\] _0064_ _0091_ vssd1 vssd1 vccd1 vccd1 _0380_
+ sky130_fd_sc_hd__a21oi_1
Xteam_07_77 vssd1 vssd1 vccd1 vccd1 gpio_oeb[4] team_07_77/LO sky130_fd_sc_hd__conb_1
Xteam_07_99 vssd1 vssd1 vccd1 vccd1 gpio_oeb[29] team_07_99/LO sky130_fd_sc_hd__conb_1
Xteam_07_88 vssd1 vssd1 vccd1 vccd1 gpio_oeb[15] team_07_88/LO sky130_fd_sc_hd__conb_1
XFILLER_33_57 vssd1 vssd1 vccd1 vccd1 sky130_fd_sc_hd__fill_8
XANTENNA__0470__C net24 vssd1 vssd1 vccd1 vccd1 sky130_fd_sc_hd__diode_2
XFILLER_3_169 vssd1 vssd1 vccd1 vccd1 sky130_fd_sc_hd__fill_2
Xhold9 MATMULT_INST.prod_adder.gen_for_loop\[6\].adder_n.a vssd1 vssd1 vccd1 vccd1
+ net112 sky130_fd_sc_hd__dlygate4sd3_1
XANTENNA__0485__Y _0096_ vssd1 vssd1 vccd1 vccd1 sky130_fd_sc_hd__diode_2
X_0700_ _0270_ _0272_ MATMULT_INST.prod_adder.gen_for_loop\[2\].adder_n.a vssd1 vssd1
+ vccd1 vccd1 _0274_ sky130_fd_sc_hd__o21a_1
X_0631_ MATMULT_INST.uart_rcv.tim.clk_cnt\[4\] MATMULT_INST.uart_rcv.tim.clk_cnt\[5\]
+ MATMULT_INST.uart_rcv.tim.clk_cnt\[6\] _0210_ vssd1 vssd1 vccd1 vccd1 _0217_ sky130_fd_sc_hd__and4_1
X_0562_ net4 MATMULT_INST.uart_tx.count.next_cnt_out\[9\] vssd1 vssd1 vccd1 vccd1
+ _0156_ sky130_fd_sc_hd__xnor2_1
XFILLER_2_191 vssd1 vssd1 vccd1 vccd1 sky130_fd_sc_hd__fill_4
X_0493_ MATMULT_INST.uart_tx.tx_ctrl.state\[4\] MATMULT_INST.uart_tx.tx_ctrl.state\[2\]
+ vssd1 vssd1 vccd1 vccd1 _0101_ sky130_fd_sc_hd__nor2_1
XFILLER_0_83 vssd1 vssd1 vccd1 vccd1 sky130_fd_sc_hd__fill_1
XFILLER_21_246 vssd1 vssd1 vccd1 vccd1 sky130_fd_sc_hd__fill_1
X_0829_ MATMULT_INST.parallel_out2\[4\] MATMULT_INST.rx_data\[4\] _0096_ vssd1 vssd1
+ vccd1 vccd1 _0026_ sky130_fd_sc_hd__mux2_1
XFILLER_0_139 vssd1 vssd1 vccd1 vccd1 sky130_fd_sc_hd__fill_1
X_0476_ MATMULT_INST.uart_rcv.control.packet_done _0087_ vssd1 vssd1 vccd1 vccd1 _0088_
+ sky130_fd_sc_hd__nor2_1
X_0614_ _0194_ _0200_ _0202_ MATMULT_INST.uart_rcv.control.packet_done vssd1 vssd1
+ vccd1 vccd1 _0205_ sky130_fd_sc_hd__a31oi_2
XPHY_EDGE_ROW_7_Right_7 vssd1 vssd1 vccd1 vccd1 sky130_fd_sc_hd__decap_3
X_0545_ _0143_ _0144_ net22 vssd1 vssd1 vccd1 vccd1 _0145_ sky130_fd_sc_hd__or3b_1
XFILLER_14_15 vccd1 vssd1 vccd1 vssd1 sky130_ef_sc_hd__decap_40_12
X_1028_ clknet_3_5__leaf_clk _0051_ net37 vssd1 vssd1 vccd1 vccd1 MATMULT_INST.prod_adder.gen_for_loop\[7\].adder_n.b
+ sky130_fd_sc_hd__dfstp_1
XPHY_EDGE_ROW_12_Left_51 vssd1 vssd1 vccd1 vccd1 sky130_fd_sc_hd__decap_3
XFILLER_29_110 vssd1 vssd1 vccd1 vccd1 sky130_fd_sc_hd__fill_2
XFILLER_29_121 vssd1 vssd1 vccd1 vccd1 sky130_fd_sc_hd__fill_2
XFILLER_29_154 vssd1 vssd1 vccd1 vccd1 sky130_fd_sc_hd__fill_2
XFILLER_4_253 vssd1 vssd1 vccd1 vccd1 sky130_fd_sc_hd__fill_2
XFILLER_35_113 vssd1 vssd1 vccd1 vccd1 sky130_fd_sc_hd__fill_2
XFILLER_6_60 vssd1 vssd1 vccd1 vccd1 sky130_fd_sc_hd__fill_1
X_0459_ MATMULT_INST.uart_tx.clk_cnt\[6\] vssd1 vssd1 vccd1 vccd1 _0072_ sky130_fd_sc_hd__inv_2
X_0528_ MATMULT_INST.uart_tx.clk_cnt\[0\] MATMULT_INST.uart_tx.clk_cnt\[1\] MATMULT_INST.uart_tx.clk_cnt\[2\]
+ MATMULT_INST.uart_tx.clk_cnt\[3\] vssd1 vssd1 vccd1 vccd1 _0133_ sky130_fd_sc_hd__and4_1
XFILLER_25_47 vssd1 vssd1 vccd1 vccd1 sky130_fd_sc_hd__fill_2
Xteam_07_103 vssd1 vssd1 vccd1 vccd1 gpio_oeb[33] team_07_103/LO sky130_fd_sc_hd__conb_1
XFILLER_1_223 vssd1 vssd1 vccd1 vccd1 sky130_fd_sc_hd__fill_1
XFILLER_2_29 vccd1 vssd1 vccd1 vssd1 sky130_ef_sc_hd__decap_40_12
XFILLER_2_18 vssd1 vssd1 vccd1 vccd1 sky130_fd_sc_hd__fill_8
XFILLER_17_102 vssd1 vssd1 vccd1 vccd1 sky130_fd_sc_hd__fill_2
XFILLER_17_146 vccd1 vssd1 vccd1 vssd1 sky130_ef_sc_hd__decap_40_12
XANTENNA_input11_A gpio_in[3] vssd1 vssd1 vccd1 vccd1 sky130_fd_sc_hd__diode_2
XTAP_TAPCELL_ROW_2_94 vssd1 vccd1 sky130_fd_sc_hd__tapvpwrvgnd_1
XTAP_TAPCELL_ROW_18_163 vssd1 vccd1 sky130_fd_sc_hd__tapvpwrvgnd_1
XANTENNA_input3_A gpio_in[10] vssd1 vssd1 vccd1 vccd1 sky130_fd_sc_hd__diode_2
X_0931_ MATMULT_INST.rx_data\[0\] MATMULT_INST.uart_rcv.data_buff.packet_data\[0\]
+ _0447_ vssd1 vssd1 vccd1 vccd1 _0054_ sky130_fd_sc_hd__mux2_1
X_0862_ MATMULT_INST.cntrl.state\[0\] _0093_ _0094_ _0387_ vssd1 vssd1 vccd1 vccd1
+ _0395_ sky130_fd_sc_hd__a31o_1
X_0793_ MATMULT_INST.parallel_out1\[4\] MATMULT_INST.parallel_out1\[3\] _0346_ vssd1
+ vssd1 vccd1 vccd1 _0348_ sky130_fd_sc_hd__nand3_1
XTAP_TAPCELL_ROW_38_258 vssd1 vccd1 sky130_fd_sc_hd__tapvpwrvgnd_1
XFILLER_22_15 vccd1 vssd1 vccd1 vssd1 sky130_ef_sc_hd__decap_40_12
XTAP_TAPCELL_ROW_6_112 vssd1 vccd1 sky130_fd_sc_hd__tapvpwrvgnd_1
XTAP_TAPCELL_ROW_29_214 vssd1 vccd1 sky130_fd_sc_hd__tapvpwrvgnd_1
XFILLER_10_141 vssd1 vssd1 vccd1 vccd1 sky130_fd_sc_hd__fill_1
XFILLER_10_152 vssd1 vssd1 vccd1 vccd1 sky130_fd_sc_hd__fill_1
XTAP_TAPCELL_ROW_12_136 vssd1 vccd1 sky130_fd_sc_hd__tapvpwrvgnd_1
X_0914_ MATMULT_INST.parallel_out2\[6\] MATMULT_INST.parallel_out2\[2\] MATMULT_INST.parallel_out2\[7\]
+ MATMULT_INST.parallel_out2\[3\] vssd1 vssd1 vccd1 vccd1 _0437_ sky130_fd_sc_hd__and4_1
X_0845_ _0063_ _0100_ vssd1 vssd1 vccd1 vccd1 _0379_ sky130_fd_sc_hd__or2_1
Xteam_07_45 vssd1 vssd1 vccd1 vccd1 team_07_45/HI gpio_out[4] sky130_fd_sc_hd__conb_1
Xteam_07_67 vssd1 vssd1 vccd1 vccd1 team_07_67/HI gpio_out[28] sky130_fd_sc_hd__conb_1
Xteam_07_78 vssd1 vssd1 vccd1 vccd1 gpio_oeb[5] team_07_78/LO sky130_fd_sc_hd__conb_1
Xteam_07_89 vssd1 vssd1 vccd1 vccd1 gpio_oeb[19] team_07_89/LO sky130_fd_sc_hd__conb_1
X_0776_ MATMULT_INST.parallel_out1\[0\] MATMULT_INST.parallel_out1\[5\] MATMULT_INST.parallel_out1\[1\]
+ MATMULT_INST.parallel_out1\[4\] vssd1 vssd1 vccd1 vccd1 _0333_ sky130_fd_sc_hd__a22o_1
Xteam_07_56 vssd1 vssd1 vccd1 vccd1 team_07_56/HI gpio_out[15] sky130_fd_sc_hd__conb_1
XFILLER_17_15 vssd1 vssd1 vccd1 vccd1 sky130_fd_sc_hd__fill_8
XFILLER_15_233 vssd1 vssd1 vccd1 vccd1 sky130_fd_sc_hd__fill_1
XFILLER_30_247 vssd1 vssd1 vccd1 vccd1 sky130_fd_sc_hd__fill_2
X_0630_ _0216_ vssd1 vssd1 vccd1 vccd1 MATMULT_INST.uart_rcv.tim.clock_count.next_cnt_out\[5\]
+ sky130_fd_sc_hd__inv_2
X_0492_ MATMULT_INST.cntrl.state\[1\] _0090_ MATMULT_INST.cntrl.state\[4\] vssd1 vssd1
+ vccd1 vccd1 _0100_ sky130_fd_sc_hd__or3b_1
X_0561_ _0155_ vssd1 vssd1 vccd1 vccd1 MATMULT_INST.uart_tx.count.next_cnt_out\[13\]
+ sky130_fd_sc_hd__inv_2
XFILLER_0_62 vssd1 vssd1 vccd1 vccd1 sky130_fd_sc_hd__fill_4
XFILLER_17_3 vccd1 vssd1 vccd1 vssd1 sky130_ef_sc_hd__decap_40_12
XFILLER_21_225 vssd1 vssd1 vccd1 vccd1 sky130_fd_sc_hd__fill_2
X_0759_ _0284_ _0294_ _0324_ vssd1 vssd1 vccd1 vccd1 _0327_ sky130_fd_sc_hd__a21oi_1
X_0828_ MATMULT_INST.parallel_out2\[3\] MATMULT_INST.rx_data\[3\] _0096_ vssd1 vssd1
+ vccd1 vccd1 _0025_ sky130_fd_sc_hd__mux2_1
XFILLER_28_36 vssd1 vssd1 vccd1 vccd1 sky130_fd_sc_hd__fill_4
XFILLER_5_18 vccd1 vssd1 vccd1 vssd1 sky130_ef_sc_hd__decap_40_12
X_0613_ _0201_ _0203_ _0204_ MATMULT_INST.uart_rcv.control.packet_done vssd1 vssd1
+ vccd1 vccd1 MATMULT_INST.uart_rcv.tim.clock_count.next_cnt_out\[0\] sky130_fd_sc_hd__a211oi_2
XFILLER_38_111 vssd1 vssd1 vccd1 vccd1 sky130_fd_sc_hd__fill_1
X_0475_ _0062_ MATMULT_INST.uart_rcv.tim.bit_cnt\[2\] MATMULT_INST.uart_rcv.tim.bit_cnt\[1\]
+ MATMULT_INST.uart_rcv.tim.bit_cnt\[0\] MATMULT_INST.uart_rcv.shift_strobe vssd1
+ vssd1 vccd1 vccd1 _0087_ sky130_fd_sc_hd__o311a_1
X_0544_ MATMULT_INST.uart_tx.clk_cnt\[7\] MATMULT_INST.uart_tx.clk_cnt\[8\] _0140_
+ vssd1 vssd1 vccd1 vccd1 _0144_ sky130_fd_sc_hd__and3_1
XFILLER_38_133 vssd1 vssd1 vccd1 vccd1 sky130_fd_sc_hd__fill_1
X_1027_ clknet_3_4__leaf_clk _0050_ net32 vssd1 vssd1 vccd1 vccd1 MATMULT_INST.prod_adder.gen_for_loop\[6\].adder_n.b
+ sky130_fd_sc_hd__dfstp_1
Xclkbuf_3_5__f_clk clknet_0_clk vssd1 vssd1 vccd1 vccd1 clknet_3_5__leaf_clk sky130_fd_sc_hd__clkbuf_16
XFILLER_14_27 vssd1 vssd1 vccd1 vccd1 sky130_fd_sc_hd__fill_1
XFILLER_35_169 vccd1 vssd1 vccd1 vssd1 sky130_ef_sc_hd__decap_40_12
XFILLER_6_83 vssd1 vssd1 vccd1 vccd1 sky130_fd_sc_hd__fill_1
X_0527_ _0131_ _0132_ net22 vssd1 vssd1 vccd1 vccd1 MATMULT_INST.uart_tx.count.next_cnt_out\[2\]
+ sky130_fd_sc_hd__and3b_1
X_0458_ net13 vssd1 vssd1 vccd1 vccd1 _0071_ sky130_fd_sc_hd__inv_2
XFILLER_34_180 vccd1 vssd1 vccd1 vssd1 sky130_ef_sc_hd__decap_40_12
XFILLER_26_169 vccd1 vssd1 vccd1 vssd1 sky130_ef_sc_hd__decap_40_12
XFILLER_1_202 vccd1 vssd1 vccd1 vssd1 sky130_ef_sc_hd__decap_40_12
XFILLER_17_158 vssd1 vssd1 vccd1 vccd1 sky130_fd_sc_hd__fill_2
XFILLER_17_169 vssd1 vssd1 vccd1 vccd1 sky130_fd_sc_hd__fill_4
XTAP_TAPCELL_ROW_2_95 vssd1 vccd1 sky130_fd_sc_hd__tapvpwrvgnd_1
XFILLER_31_91 vssd1 vssd1 vccd1 vccd1 sky130_fd_sc_hd__fill_1
XTAP_TAPCELL_ROW_18_164 vssd1 vccd1 sky130_fd_sc_hd__tapvpwrvgnd_1
XFILLER_14_139 vssd1 vssd1 vccd1 vccd1 sky130_fd_sc_hd__fill_1
X_0792_ MATMULT_INST.parallel_out1\[4\] MATMULT_INST.parallel_out1\[3\] _0346_ vssd1
+ vssd1 vccd1 vccd1 _0347_ sky130_fd_sc_hd__and3_1
X_0861_ _0376_ _0391_ _0392_ _0393_ vssd1 vssd1 vccd1 vccd1 _0394_ sky130_fd_sc_hd__and4_1
X_0930_ net107 _0097_ _0447_ vssd1 vssd1 vccd1 vccd1 _0053_ sky130_fd_sc_hd__a21o_1
XTAP_TAPCELL_ROW_38_259 vssd1 vccd1 sky130_fd_sc_hd__tapvpwrvgnd_1
XFILLER_36_253 vssd1 vssd1 vccd1 vccd1 sky130_fd_sc_hd__fill_2
XFILLER_3_51 vssd1 vssd1 vccd1 vccd1 sky130_fd_sc_hd__fill_4
XFILLER_22_27 vssd1 vssd1 vccd1 vccd1 sky130_fd_sc_hd__fill_1
XFILLER_0_9 vssd1 vssd1 vccd1 vccd1 sky130_fd_sc_hd__fill_1
XTAP_TAPCELL_ROW_6_113 vssd1 vccd1 sky130_fd_sc_hd__tapvpwrvgnd_1
XTAP_TAPCELL_ROW_29_215 vssd1 vccd1 sky130_fd_sc_hd__tapvpwrvgnd_1
XPHY_EDGE_ROW_29_Right_29 vssd1 vssd1 vccd1 vccd1 sky130_fd_sc_hd__decap_3
XPHY_EDGE_ROW_38_Right_38 vssd1 vssd1 vccd1 vccd1 sky130_fd_sc_hd__decap_3
XFILLER_6_102 vssd1 vssd1 vccd1 vccd1 sky130_fd_sc_hd__fill_2
XFILLER_10_186 vssd1 vssd1 vccd1 vccd1 sky130_fd_sc_hd__fill_2
XTAP_TAPCELL_ROW_12_137 vssd1 vccd1 sky130_fd_sc_hd__tapvpwrvgnd_1
XFILLER_33_9 vssd1 vssd1 vccd1 vccd1 sky130_fd_sc_hd__fill_8
XFILLER_10_197 vssd1 vssd1 vccd1 vccd1 sky130_fd_sc_hd__fill_1
XFILLER_12_60 vssd1 vssd1 vccd1 vccd1 sky130_fd_sc_hd__fill_4
XFILLER_33_245 vssd1 vssd1 vccd1 vccd1 sky130_fd_sc_hd__fill_8
XFILLER_18_253 vssd1 vssd1 vccd1 vccd1 sky130_fd_sc_hd__fill_2
X_0913_ _0436_ MATMULT_INST.prod_adder.gen_for_loop\[4\].adder_n.b _0402_ vssd1 vssd1
+ vccd1 vccd1 _0048_ sky130_fd_sc_hd__mux2_1
X_0775_ MATMULT_INST.parallel_out1\[0\] MATMULT_INST.parallel_out1\[4\] MATMULT_INST.parallel_out1\[5\]
+ MATMULT_INST.parallel_out1\[1\] vssd1 vssd1 vccd1 vccd1 _0332_ sky130_fd_sc_hd__nand4_1
X_0844_ MATMULT_INST.cntrl.data_ready _0376_ _0377_ vssd1 vssd1 vccd1 vccd1 _0378_
+ sky130_fd_sc_hd__or3b_1
Xteam_07_46 vssd1 vssd1 vccd1 vccd1 team_07_46/HI gpio_out[5] sky130_fd_sc_hd__conb_1
Xteam_07_68 vssd1 vssd1 vccd1 vccd1 team_07_68/HI gpio_out[29] sky130_fd_sc_hd__conb_1
Xteam_07_79 vssd1 vssd1 vccd1 vccd1 gpio_oeb[6] team_07_79/LO sky130_fd_sc_hd__conb_1
Xteam_07_57 vssd1 vssd1 vccd1 vccd1 team_07_57/HI gpio_out[18] sky130_fd_sc_hd__conb_1
XFILLER_33_26 vssd1 vssd1 vccd1 vccd1 sky130_fd_sc_hd__fill_1
XFILLER_3_138 vssd1 vssd1 vccd1 vccd1 sky130_fd_sc_hd__fill_1
XFILLER_3_127 vssd1 vssd1 vccd1 vccd1 sky130_fd_sc_hd__fill_2
XFILLER_3_105 vssd1 vssd1 vccd1 vccd1 sky130_fd_sc_hd__fill_1
X_0491_ net122 _0083_ _0099_ vssd1 vssd1 vccd1 vccd1 MATMULT_INST.uart_rcv.tim.bit_count.next_cnt_out\[2\]
+ sky130_fd_sc_hd__o21a_1
XFILLER_24_5 vssd1 vssd1 vccd1 vccd1 sky130_fd_sc_hd__fill_4
X_0560_ MATMULT_INST.uart_tx.clk_cnt\[13\] _0152_ _0154_ vssd1 vssd1 vccd1 vccd1 _0155_
+ sky130_fd_sc_hd__a21o_1
XFILLER_0_41 vssd1 vssd1 vccd1 vccd1 sky130_fd_sc_hd__fill_4
XFILLER_0_85 vssd1 vssd1 vccd1 vccd1 sky130_fd_sc_hd__fill_2
X_0758_ _0326_ MATMULT_INST.uart_tx.tx_ctrl.state\[2\] _0324_ vssd1 vssd1 vccd1 vccd1
+ _0002_ sky130_fd_sc_hd__mux2_1
X_0827_ MATMULT_INST.parallel_out2\[2\] MATMULT_INST.rx_data\[2\] _0096_ vssd1 vssd1
+ vccd1 vccd1 _0024_ sky130_fd_sc_hd__mux2_1
X_0689_ _0261_ _0262_ vssd1 vssd1 vccd1 vccd1 _0263_ sky130_fd_sc_hd__nand2_1
XFILLER_7_252 vssd1 vssd1 vccd1 vccd1 sky130_fd_sc_hd__fill_2
X_0612_ MATMULT_INST.uart_rcv.tim.clk_cnt\[0\] _0202_ vssd1 vssd1 vccd1 vccd1 _0204_
+ sky130_fd_sc_hd__nor2_1
X_0474_ net110 _0084_ _0086_ MATMULT_INST.uart_rcv.control.packet_done vssd1 vssd1
+ vccd1 vccd1 MATMULT_INST.uart_rcv.tim.bit_count.next_cnt_out\[3\] sky130_fd_sc_hd__a211oi_1
X_0543_ MATMULT_INST.uart_tx.clk_cnt\[7\] _0140_ MATMULT_INST.uart_tx.clk_cnt\[8\]
+ vssd1 vssd1 vccd1 vccd1 _0143_ sky130_fd_sc_hd__a21oi_1
XFILLER_38_167 vssd1 vssd1 vccd1 vccd1 sky130_fd_sc_hd__fill_1
X_1026_ clknet_3_4__leaf_clk _0049_ net32 vssd1 vssd1 vccd1 vccd1 MATMULT_INST.prod_adder.gen_for_loop\[5\].adder_n.b
+ sky130_fd_sc_hd__dfstp_1
XFILLER_30_27 vssd1 vssd1 vccd1 vccd1 sky130_fd_sc_hd__fill_1
XFILLER_29_123 vssd1 vssd1 vccd1 vccd1 sky130_fd_sc_hd__fill_1
XFILLER_35_115 vssd1 vssd1 vccd1 vccd1 sky130_fd_sc_hd__fill_1
X_0526_ _0070_ _0130_ vssd1 vssd1 vccd1 vccd1 _0132_ sky130_fd_sc_hd__nand2_1
X_0457_ MATMULT_INST.uart_tx.clk_cnt\[2\] vssd1 vssd1 vccd1 vccd1 _0070_ sky130_fd_sc_hd__inv_2
X_1009_ clknet_3_3__leaf_clk MATMULT_INST.uart_rcv.tim.clock_count.next_cnt_out\[7\]
+ net30 vssd1 vssd1 vccd1 vccd1 MATMULT_INST.uart_rcv.tim.clk_cnt\[7\] sky130_fd_sc_hd__dfrtp_1
XFILLER_34_192 vssd1 vssd1 vccd1 vccd1 sky130_fd_sc_hd__fill_4
XFILLER_25_49 vssd1 vssd1 vccd1 vccd1 sky130_fd_sc_hd__fill_1
XANTENNA_clkbuf_3_5__f_clk_A clknet_0_clk vssd1 vssd1 vccd1 vccd1 sky130_fd_sc_hd__diode_2
XFILLER_1_225 vccd1 vssd1 vccd1 vssd1 sky130_ef_sc_hd__decap_40_12
XFILLER_17_104 vssd1 vssd1 vccd1 vccd1 sky130_fd_sc_hd__fill_1
XFILLER_25_181 vssd1 vssd1 vccd1 vccd1 sky130_fd_sc_hd__fill_2
XTAP_TAPCELL_ROW_18_165 vssd1 vccd1 sky130_fd_sc_hd__tapvpwrvgnd_1
XFILLER_31_151 vccd1 vssd1 vccd1 vssd1 sky130_ef_sc_hd__decap_40_12
X_0509_ MATMULT_INST.uart_tx.clk_cnt\[1\] net11 vssd1 vssd1 vccd1 vccd1 _0117_ sky130_fd_sc_hd__xor2_1
XFILLER_36_59 vssd1 vssd1 vccd1 vccd1 sky130_fd_sc_hd__fill_2
XFILLER_36_26 vssd1 vssd1 vccd1 vccd1 sky130_fd_sc_hd__fill_2
XFILLER_22_195 vssd1 vssd1 vccd1 vccd1 sky130_fd_sc_hd__fill_1
XFILLER_9_100 vccd1 vssd1 vccd1 vssd1 sky130_ef_sc_hd__decap_40_12
XFILLER_9_166 vssd1 vssd1 vccd1 vccd1 sky130_fd_sc_hd__fill_2
XFILLER_13_184 vssd1 vssd1 vccd1 vccd1 sky130_fd_sc_hd__fill_4
X_0791_ _0342_ _0345_ vssd1 vssd1 vccd1 vccd1 _0346_ sky130_fd_sc_hd__xnor2_1
X_0860_ MATMULT_INST.cntrl.data_read _0382_ vssd1 vssd1 vccd1 vccd1 _0393_ sky130_fd_sc_hd__nor2_1
X_0989_ clknet_3_1__leaf_clk _0035_ net26 vssd1 vssd1 vccd1 vccd1 MATMULT_INST.parallel_out1\[5\]
+ sky130_fd_sc_hd__dfstp_2
XTAP_TAPCELL_ROW_29_216 vssd1 vccd1 sky130_fd_sc_hd__tapvpwrvgnd_1
XFILLER_6_125 vccd1 vssd1 vccd1 vssd1 sky130_ef_sc_hd__decap_40_12
XFILLER_10_121 vssd1 vssd1 vccd1 vccd1 sky130_fd_sc_hd__fill_2
XTAP_TAPCELL_ROW_12_138 vssd1 vccd1 sky130_fd_sc_hd__tapvpwrvgnd_1
X_0912_ _0434_ _0435_ vssd1 vssd1 vccd1 vccd1 _0436_ sky130_fd_sc_hd__and2_1
X_0774_ net123 _0330_ _0331_ vssd1 vssd1 vccd1 vccd1 _0014_ sky130_fd_sc_hd__a21o_1
X_0843_ MATMULT_INST.cntrl.overrun_error MATMULT_INST.cntrl.framing_error vssd1 vssd1
+ vccd1 vccd1 _0377_ sky130_fd_sc_hd__nor2_1
Xteam_07_47 vssd1 vssd1 vccd1 vccd1 team_07_47/HI gpio_out[6] sky130_fd_sc_hd__conb_1
Xteam_07_69 vssd1 vssd1 vccd1 vccd1 team_07_69/HI gpio_out[30] sky130_fd_sc_hd__conb_1
Xteam_07_58 vssd1 vssd1 vccd1 vccd1 team_07_58/HI gpio_out[19] sky130_fd_sc_hd__conb_1
XPHY_EDGE_ROW_29_Left_68 vssd1 vssd1 vccd1 vccd1 sky130_fd_sc_hd__decap_3
X_0490_ MATMULT_INST.uart_rcv.control.packet_done _0084_ vssd1 vssd1 vccd1 vccd1 _0099_
+ sky130_fd_sc_hd__nor2_1
XFILLER_0_20 vssd1 vssd1 vccd1 vccd1 sky130_fd_sc_hd__fill_4
XFILLER_0_97 vccd1 vssd1 vccd1 vssd1 sky130_ef_sc_hd__decap_40_12
XTAP_TAPCELL_ROW_31_222 vssd1 vccd1 sky130_fd_sc_hd__tapvpwrvgnd_1
X_0826_ MATMULT_INST.parallel_out2\[1\] MATMULT_INST.rx_data\[1\] _0096_ vssd1 vssd1
+ vccd1 vccd1 _0023_ sky130_fd_sc_hd__mux2_1
XFILLER_0_109 vssd1 vssd1 vccd1 vccd1 sky130_fd_sc_hd__fill_2
X_0757_ _0325_ _0312_ _0313_ vssd1 vssd1 vccd1 vccd1 _0326_ sky130_fd_sc_hd__or3b_1
X_0688_ MATMULT_INST.uart_tx.tx_ctrl.state\[0\] MATMULT_INST.uart_tx.tx_ctrl.state\[1\]
+ vssd1 vssd1 vccd1 vccd1 _0262_ sky130_fd_sc_hd__or2_1
XFILLER_8_209 vccd1 vssd1 vccd1 vssd1 sky130_ef_sc_hd__decap_40_12
XFILLER_34_70 vssd1 vssd1 vccd1 vccd1 sky130_fd_sc_hd__fill_2
X_0542_ MATMULT_INST.uart_tx.clk_cnt\[7\] _0140_ _0142_ _0128_ vssd1 vssd1 vccd1 vccd1
+ MATMULT_INST.uart_tx.count.next_cnt_out\[7\] sky130_fd_sc_hd__o211a_1
X_0611_ MATMULT_INST.uart_rcv.control.state\[0\] MATMULT_INST.uart_rcv.control.state\[2\]
+ MATMULT_INST.uart_rcv.tim.clk_cnt\[0\] MATMULT_INST.uart_rcv.control.state\[1\]
+ vssd1 vssd1 vccd1 vccd1 _0203_ sky130_fd_sc_hd__and4bb_2
XFILLER_38_113 vssd1 vssd1 vccd1 vccd1 sky130_fd_sc_hd__fill_4
X_0473_ MATMULT_INST.uart_rcv.tim.bit_cnt\[3\] _0085_ _0084_ vssd1 vssd1 vccd1 vccd1
+ _0086_ sky130_fd_sc_hd__a21oi_1
XFILLER_22_3 vccd1 vssd1 vccd1 vssd1 sky130_ef_sc_hd__decap_40_12
X_1025_ clknet_3_4__leaf_clk _0048_ net31 vssd1 vssd1 vccd1 vccd1 MATMULT_INST.prod_adder.gen_for_loop\[4\].adder_n.b
+ sky130_fd_sc_hd__dfstp_1
XFILLER_14_29 vssd1 vssd1 vccd1 vccd1 sky130_fd_sc_hd__fill_2
X_0809_ _0359_ _0362_ vssd1 vssd1 vccd1 vccd1 _0363_ sky130_fd_sc_hd__nand2_1
XFILLER_29_113 vssd1 vssd1 vccd1 vccd1 sky130_fd_sc_hd__fill_8
XFILLER_35_127 vssd1 vssd1 vccd1 vccd1 sky130_fd_sc_hd__fill_4
XFILLER_6_41 vssd1 vssd1 vccd1 vccd1 sky130_fd_sc_hd__fill_4
X_0525_ _0070_ _0130_ vssd1 vssd1 vccd1 vccd1 _0131_ sky130_fd_sc_hd__nor2_1
X_0456_ net11 vssd1 vssd1 vccd1 vccd1 _0069_ sky130_fd_sc_hd__inv_2
XPHY_EDGE_ROW_16_Left_55 vssd1 vssd1 vccd1 vccd1 sky130_fd_sc_hd__decap_3
X_1008_ clknet_3_2__leaf_clk MATMULT_INST.uart_rcv.tim.clock_count.next_cnt_out\[6\]
+ net29 vssd1 vssd1 vccd1 vccd1 MATMULT_INST.uart_rcv.tim.clk_cnt\[6\] sky130_fd_sc_hd__dfrtp_1
XFILLER_1_237 vccd1 vssd1 vccd1 vssd1 sky130_ef_sc_hd__decap_40_12
XFILLER_17_127 vssd1 vssd1 vccd1 vccd1 sky130_fd_sc_hd__fill_2
XFILLER_16_193 vssd1 vssd1 vccd1 vccd1 sky130_fd_sc_hd__fill_2
XTAP_TAPCELL_ROW_18_166 vssd1 vccd1 sky130_fd_sc_hd__tapvpwrvgnd_1
XFILLER_23_108 vssd1 vssd1 vccd1 vccd1 sky130_fd_sc_hd__fill_2
XFILLER_31_163 vssd1 vssd1 vccd1 vccd1 sky130_fd_sc_hd__fill_2
XFILLER_11_19 vssd1 vssd1 vccd1 vccd1 sky130_fd_sc_hd__fill_2
X_0508_ MATMULT_INST.uart_tx.clk_cnt\[9\] _0074_ _0075_ net5 _0115_ vssd1 vssd1 vccd1
+ vccd1 _0116_ sky130_fd_sc_hd__a221o_1
XFILLER_22_141 vccd1 vssd1 vccd1 vssd1 sky130_ef_sc_hd__decap_40_12
XTAP_TAPCELL_ROW_9_123 vssd1 vccd1 sky130_fd_sc_hd__tapvpwrvgnd_1
XFILLER_13_163 vssd1 vssd1 vccd1 vccd1 sky130_fd_sc_hd__fill_4
XFILLER_9_178 vssd1 vssd1 vccd1 vccd1 sky130_fd_sc_hd__fill_4
XFILLER_13_196 vccd1 vssd1 vccd1 vssd1 sky130_ef_sc_hd__decap_40_12
X_0790_ _0343_ _0344_ vssd1 vssd1 vccd1 vccd1 _0345_ sky130_fd_sc_hd__and2b_1
X_0988_ clknet_3_1__leaf_clk _0034_ net26 vssd1 vssd1 vccd1 vccd1 MATMULT_INST.parallel_out1\[4\]
+ sky130_fd_sc_hd__dfstp_1
XFILLER_22_29 vccd1 vssd1 vccd1 vssd1 sky130_ef_sc_hd__decap_40_12
XANTENNA_input1_A en vssd1 vssd1 vccd1 vccd1 sky130_fd_sc_hd__diode_2
XTAP_TAPCELL_ROW_37_250 vssd1 vccd1 sky130_fd_sc_hd__tapvpwrvgnd_1
XFILLER_6_137 vssd1 vssd1 vccd1 vccd1 sky130_fd_sc_hd__fill_2
XFILLER_6_104 vssd1 vssd1 vccd1 vccd1 sky130_fd_sc_hd__fill_1
XFILLER_10_188 vssd1 vssd1 vccd1 vccd1 sky130_fd_sc_hd__fill_1
XTAP_TAPCELL_ROW_12_139 vssd1 vccd1 sky130_fd_sc_hd__tapvpwrvgnd_1
XTAP_TAPCELL_ROW_20_172 vssd1 vccd1 sky130_fd_sc_hd__tapvpwrvgnd_1
XFILLER_18_211 vssd1 vssd1 vccd1 vccd1 sky130_fd_sc_hd__fill_2
X_0911_ _0430_ _0433_ vssd1 vssd1 vccd1 vccd1 _0435_ sky130_fd_sc_hd__or2_1
X_0842_ _0090_ _0095_ _0375_ vssd1 vssd1 vccd1 vccd1 _0376_ sky130_fd_sc_hd__o21a_1
X_0773_ MATMULT_INST.parallel_out1\[0\] MATMULT_INST.parallel_out1\[4\] _0329_ vssd1
+ vssd1 vccd1 vccd1 _0331_ sky130_fd_sc_hd__and3_1
Xteam_07_48 vssd1 vssd1 vccd1 vccd1 team_07_48/HI gpio_out[7] sky130_fd_sc_hd__conb_1
Xteam_07_59 vssd1 vssd1 vccd1 vccd1 team_07_59/HI gpio_out[20] sky130_fd_sc_hd__conb_1
XFILLER_33_17 vssd1 vssd1 vccd1 vccd1 sky130_fd_sc_hd__fill_2
XFILLER_24_203 vssd1 vssd1 vccd1 vccd1 sky130_fd_sc_hd__fill_2
XANTENNA__1009__RESET_B net30 vssd1 vssd1 vccd1 vccd1 sky130_fd_sc_hd__diode_2
XFILLER_15_225 vssd1 vssd1 vccd1 vccd1 sky130_fd_sc_hd__fill_8
XPHY_EDGE_ROW_4_Left_43 vssd1 vssd1 vccd1 vccd1 sky130_fd_sc_hd__decap_3
XFILLER_15_247 vssd1 vssd1 vccd1 vccd1 sky130_fd_sc_hd__fill_2
XFILLER_2_195 vssd1 vssd1 vccd1 vccd1 sky130_fd_sc_hd__fill_1
XFILLER_0_76 vssd1 vssd1 vccd1 vccd1 sky130_fd_sc_hd__fill_4
X_1041_ clknet_3_3__leaf_clk _0061_ net30 vssd1 vssd1 vccd1 vccd1 MATMULT_INST.rx_data\[7\]
+ sky130_fd_sc_hd__dfstp_1
X_0825_ MATMULT_INST.parallel_out2\[0\] MATMULT_INST.rx_data\[0\] _0096_ vssd1 vssd1
+ vccd1 vccd1 _0022_ sky130_fd_sc_hd__mux2_1
XTAP_TAPCELL_ROW_31_223 vssd1 vccd1 sky130_fd_sc_hd__tapvpwrvgnd_1
X_0756_ _0284_ _0291_ _0261_ vssd1 vssd1 vccd1 vccd1 _0325_ sky130_fd_sc_hd__a21oi_1
X_0687_ MATMULT_INST.uart_tx.tx_ctrl.state\[0\] MATMULT_INST.uart_tx.tx_ctrl.state\[1\]
+ vssd1 vssd1 vccd1 vccd1 _0261_ sky130_fd_sc_hd__nand2_1
XANTENNA__0832__S _0096_ vssd1 vssd1 vccd1 vccd1 sky130_fd_sc_hd__diode_2
XPHY_EDGE_ROW_30_Left_69 vssd1 vssd1 vccd1 vccd1 sky130_fd_sc_hd__decap_3
XFILLER_18_61 vssd1 vssd1 vccd1 vccd1 sky130_fd_sc_hd__fill_2
XFILLER_34_93 vssd1 vssd1 vccd1 vccd1 sky130_fd_sc_hd__fill_1
XFILLER_7_254 vssd1 vssd1 vccd1 vccd1 sky130_fd_sc_hd__fill_1
X_0472_ MATMULT_INST.uart_rcv.tim.bit_cnt\[2\] MATMULT_INST.uart_rcv.tim.bit_cnt\[1\]
+ MATMULT_INST.uart_rcv.tim.bit_cnt\[0\] MATMULT_INST.uart_rcv.shift_strobe vssd1
+ vssd1 vccd1 vccd1 _0085_ sky130_fd_sc_hd__or4bb_1
X_0541_ MATMULT_INST.uart_tx.clk_cnt\[7\] _0140_ vssd1 vssd1 vccd1 vccd1 _0142_ sky130_fd_sc_hd__nand2_1
X_0610_ _0067_ MATMULT_INST.uart_rcv.control.state\[0\] MATMULT_INST.uart_rcv.control.state\[2\]
+ vssd1 vssd1 vccd1 vccd1 _0202_ sky130_fd_sc_hd__nor3_2
XFILLER_38_169 vssd1 vssd1 vccd1 vccd1 sky130_fd_sc_hd__fill_2
X_1024_ clknet_3_4__leaf_clk _0047_ net31 vssd1 vssd1 vccd1 vccd1 MATMULT_INST.prod_adder.gen_for_loop\[3\].adder_n.b
+ sky130_fd_sc_hd__dfstp_1
XFILLER_15_3 vccd1 vssd1 vccd1 vssd1 sky130_ef_sc_hd__decap_40_12
X_0808_ _0360_ _0361_ vssd1 vssd1 vccd1 vccd1 _0362_ sky130_fd_sc_hd__xnor2_1
X_0739_ MATMULT_INST.uart_tx.tx_ctrl.state\[3\] _0101_ _0299_ _0312_ vssd1 vssd1 vccd1
+ vccd1 _0003_ sky130_fd_sc_hd__a211o_1
XFILLER_37_191 vssd1 vssd1 vccd1 vccd1 sky130_fd_sc_hd__fill_1
XANTENNA__0827__S _0096_ vssd1 vssd1 vccd1 vccd1 sky130_fd_sc_hd__diode_2
XFILLER_4_246 vssd1 vssd1 vccd1 vccd1 sky130_fd_sc_hd__fill_2
X_0524_ net22 _0129_ _0130_ vssd1 vssd1 vccd1 vccd1 MATMULT_INST.uart_tx.count.next_cnt_out\[1\]
+ sky130_fd_sc_hd__and3_1
X_0455_ net10 vssd1 vssd1 vccd1 vccd1 _0068_ sky130_fd_sc_hd__inv_2
X_1007_ clknet_3_2__leaf_clk MATMULT_INST.uart_rcv.tim.clock_count.next_cnt_out\[5\]
+ net28 vssd1 vssd1 vccd1 vccd1 MATMULT_INST.uart_rcv.tim.clk_cnt\[5\] sky130_fd_sc_hd__dfrtp_1
XFILLER_26_139 vssd1 vssd1 vccd1 vccd1 sky130_fd_sc_hd__fill_1
XFILLER_1_249 vssd1 vssd1 vccd1 vccd1 sky130_fd_sc_hd__fill_2
XFILLER_25_183 vssd1 vssd1 vccd1 vccd1 sky130_fd_sc_hd__fill_1
XPHY_EDGE_ROW_33_Left_72 vssd1 vssd1 vccd1 vccd1 sky130_fd_sc_hd__decap_3
XFILLER_31_83 vssd1 vssd1 vccd1 vccd1 sky130_fd_sc_hd__fill_8
XTAP_TAPCELL_ROW_18_167 vssd1 vccd1 sky130_fd_sc_hd__tapvpwrvgnd_1
XFILLER_31_142 vssd1 vssd1 vccd1 vccd1 sky130_fd_sc_hd__fill_4
X_0507_ MATMULT_INST.uart_tx.clk_cnt\[4\] net14 vssd1 vssd1 vccd1 vccd1 _0115_ sky130_fd_sc_hd__xor2_1
XANTENNA__0840__S _0092_ vssd1 vssd1 vccd1 vccd1 sky130_fd_sc_hd__diode_2
XFILLER_22_153 vccd1 vssd1 vccd1 vssd1 sky130_ef_sc_hd__decap_40_12
XTAP_TAPCELL_ROW_9_124 vssd1 vccd1 sky130_fd_sc_hd__tapvpwrvgnd_1
XFILLER_13_153 vssd1 vssd1 vccd1 vccd1 sky130_fd_sc_hd__fill_2
XFILLER_36_245 vssd1 vssd1 vccd1 vccd1 sky130_fd_sc_hd__fill_1
X_0987_ clknet_3_1__leaf_clk _0033_ net26 vssd1 vssd1 vccd1 vccd1 MATMULT_INST.parallel_out1\[3\]
+ sky130_fd_sc_hd__dfstp_2
XTAP_TAPCELL_ROW_37_251 vssd1 vccd1 sky130_fd_sc_hd__tapvpwrvgnd_1
XANTENNA__0835__S _0092_ vssd1 vssd1 vccd1 vccd1 sky130_fd_sc_hd__diode_2
XFILLER_6_149 vssd1 vssd1 vccd1 vccd1 sky130_fd_sc_hd__fill_2
XTAP_TAPCELL_ROW_20_173 vssd1 vccd1 sky130_fd_sc_hd__tapvpwrvgnd_1
XFILLER_18_201 vssd1 vssd1 vccd1 vccd1 sky130_fd_sc_hd__fill_2
XFILLER_37_71 vssd1 vssd1 vccd1 vccd1 sky130_fd_sc_hd__fill_1
XPHY_EDGE_ROW_16_Right_16 vssd1 vssd1 vccd1 vccd1 sky130_fd_sc_hd__decap_3
X_0910_ _0430_ _0433_ vssd1 vssd1 vccd1 vccd1 _0434_ sky130_fd_sc_hd__nand2_1
X_0772_ MATMULT_INST.cntrl.state\[1\] _0328_ vssd1 vssd1 vccd1 vccd1 _0330_ sky130_fd_sc_hd__or2_2
X_0841_ MATMULT_INST.cntrl.state\[0\] _0093_ _0094_ vssd1 vssd1 vccd1 vccd1 _0375_
+ sky130_fd_sc_hd__or3b_1
XPHY_EDGE_ROW_25_Right_25 vssd1 vssd1 vccd1 vccd1 sky130_fd_sc_hd__decap_3
Xteam_07_38 vssd1 vssd1 vccd1 vccd1 team_07_38/HI gpio_oeb[16] sky130_fd_sc_hd__conb_1
Xteam_07_49 vssd1 vssd1 vccd1 vccd1 team_07_49/HI gpio_out[8] sky130_fd_sc_hd__conb_1
XPHY_EDGE_ROW_34_Right_34 vssd1 vssd1 vccd1 vccd1 sky130_fd_sc_hd__decap_3
XFILLER_24_226 vssd1 vssd1 vccd1 vccd1 sky130_fd_sc_hd__fill_4
X_1040_ clknet_3_3__leaf_clk _0060_ net28 vssd1 vssd1 vccd1 vccd1 MATMULT_INST.rx_data\[6\]
+ sky130_fd_sc_hd__dfstp_1
XFILLER_0_55 vssd1 vssd1 vccd1 vccd1 sky130_fd_sc_hd__fill_1
XTAP_TAPCELL_ROW_31_224 vssd1 vccd1 sky130_fd_sc_hd__tapvpwrvgnd_1
X_0755_ _0263_ _0321_ vssd1 vssd1 vccd1 vccd1 _0001_ sky130_fd_sc_hd__nor2_1
X_0824_ _0373_ _0374_ MATMULT_INST.prod_adder.gen_for_loop\[7\].adder_n.a _0329_ vssd1
+ vssd1 vccd1 vccd1 _0021_ sky130_fd_sc_hd__o2bb2a_1
X_0686_ MATMULT_INST.uart_rcv.control.state\[1\] net113 _0257_ _0260_ vssd1 vssd1
+ vccd1 vccd1 MATMULT_INST.uart_rcv.control.next_state\[2\] sky130_fd_sc_hd__o31ai_1
XFILLER_20_251 vssd1 vssd1 vccd1 vccd1 sky130_fd_sc_hd__fill_1
Xclkbuf_3_0__f_clk clknet_0_clk vssd1 vssd1 vccd1 vccd1 clknet_3_0__leaf_clk sky130_fd_sc_hd__clkbuf_16
XFILLER_34_72 vssd1 vssd1 vccd1 vccd1 sky130_fd_sc_hd__fill_1
XFILLER_34_83 vssd1 vssd1 vccd1 vccd1 sky130_fd_sc_hd__fill_1
X_0471_ MATMULT_INST.uart_rcv.tim.bit_cnt\[2\] _0083_ vssd1 vssd1 vccd1 vccd1 _0084_
+ sky130_fd_sc_hd__and2_1
X_0540_ _0140_ _0141_ net22 vssd1 vssd1 vccd1 vccd1 MATMULT_INST.uart_tx.count.next_cnt_out\[6\]
+ sky130_fd_sc_hd__and3b_1
XFILLER_38_159 vssd1 vssd1 vccd1 vccd1 sky130_fd_sc_hd__fill_8
XFILLER_38_126 vssd1 vssd1 vccd1 vccd1 sky130_fd_sc_hd__fill_1
X_1023_ clknet_3_4__leaf_clk _0046_ net31 vssd1 vssd1 vccd1 vccd1 MATMULT_INST.prod_adder.gen_for_loop\[2\].adder_n.b
+ sky130_fd_sc_hd__dfstp_1
XANTENNA__0933__S _0447_ vssd1 vssd1 vccd1 vccd1 sky130_fd_sc_hd__diode_2
X_0738_ _0286_ _0261_ vssd1 vssd1 vccd1 vccd1 _0312_ sky130_fd_sc_hd__and2b_1
X_0807_ _0348_ _0350_ _0351_ vssd1 vssd1 vccd1 vccd1 _0361_ sky130_fd_sc_hd__a21o_1
X_0669_ _0235_ _0246_ _0236_ _0240_ vssd1 vssd1 vccd1 vccd1 _0247_ sky130_fd_sc_hd__and4bb_1
XPHY_EDGE_ROW_2_Right_2 vssd1 vssd1 vccd1 vccd1 sky130_fd_sc_hd__decap_3
XFILLER_35_118 vssd1 vssd1 vccd1 vccd1 sky130_fd_sc_hd__fill_2
XFILLER_6_87 vssd1 vssd1 vccd1 vccd1 sky130_fd_sc_hd__fill_4
X_0523_ MATMULT_INST.uart_tx.clk_cnt\[0\] MATMULT_INST.uart_tx.clk_cnt\[1\] vssd1
+ vssd1 vccd1 vccd1 _0130_ sky130_fd_sc_hd__nand2_1
X_0454_ MATMULT_INST.uart_rcv.control.state\[1\] vssd1 vssd1 vccd1 vccd1 _0067_ sky130_fd_sc_hd__inv_2
X_1006_ clknet_3_2__leaf_clk MATMULT_INST.uart_rcv.tim.clock_count.next_cnt_out\[4\]
+ net29 vssd1 vssd1 vccd1 vccd1 MATMULT_INST.uart_rcv.tim.clk_cnt\[4\] sky130_fd_sc_hd__dfrtp_1
XFILLER_34_151 vssd1 vssd1 vccd1 vccd1 sky130_fd_sc_hd__fill_1
XFILLER_26_107 vssd1 vssd1 vccd1 vccd1 sky130_fd_sc_hd__fill_4
XFILLER_1_217 vssd1 vssd1 vccd1 vccd1 sky130_fd_sc_hd__fill_4
XFILLER_17_129 vssd1 vssd1 vccd1 vccd1 sky130_fd_sc_hd__fill_1
XANTENNA__0838__S _0092_ vssd1 vssd1 vccd1 vccd1 sky130_fd_sc_hd__diode_2
XFILLER_15_63 vssd1 vssd1 vccd1 vccd1 sky130_fd_sc_hd__fill_1
XFILLER_15_85 vssd1 vssd1 vccd1 vccd1 sky130_fd_sc_hd__fill_2
XFILLER_16_195 vssd1 vssd1 vccd1 vccd1 sky130_fd_sc_hd__fill_1
X_0506_ MATMULT_INST.uart_tx.clk_cnt\[7\] net17 vssd1 vssd1 vccd1 vccd1 _0114_ sky130_fd_sc_hd__nand2b_1
XFILLER_22_165 vccd1 vssd1 vccd1 vssd1 sky130_ef_sc_hd__decap_40_12
XFILLER_7_6 vccd1 vssd1 vccd1 vssd1 sky130_ef_sc_hd__decap_40_12
XTAP_TAPCELL_ROW_9_125 vssd1 vccd1 sky130_fd_sc_hd__tapvpwrvgnd_1
XFILLER_3_77 vssd1 vssd1 vccd1 vccd1 sky130_fd_sc_hd__fill_1
XFILLER_3_55 vssd1 vssd1 vccd1 vccd1 sky130_fd_sc_hd__fill_1
X_0986_ clknet_3_1__leaf_clk _0032_ net26 vssd1 vssd1 vccd1 vccd1 MATMULT_INST.parallel_out1\[2\]
+ sky130_fd_sc_hd__dfstp_1
XTAP_TAPCELL_ROW_37_252 vssd1 vccd1 sky130_fd_sc_hd__tapvpwrvgnd_1
XFILLER_27_213 vssd1 vssd1 vccd1 vccd1 sky130_fd_sc_hd__fill_2
XFILLER_27_246 vssd1 vssd1 vccd1 vccd1 sky130_fd_sc_hd__fill_1
XFILLER_10_113 vssd1 vssd1 vccd1 vccd1 sky130_fd_sc_hd__fill_1
XFILLER_6_139 vssd1 vssd1 vccd1 vccd1 sky130_fd_sc_hd__fill_1
XTAP_TAPCELL_ROW_20_174 vssd1 vccd1 sky130_fd_sc_hd__tapvpwrvgnd_1
XANTENNA__0761__S net24 vssd1 vssd1 vccd1 vccd1 sky130_fd_sc_hd__diode_2
X_0840_ MATMULT_INST.parallel_out1\[7\] MATMULT_INST.rx_data\[7\] _0092_ vssd1 vssd1
+ vccd1 vccd1 _0037_ sky130_fd_sc_hd__mux2_1
X_0771_ MATMULT_INST.cntrl.state\[1\] _0328_ vssd1 vssd1 vccd1 vccd1 _0329_ sky130_fd_sc_hd__nor2_1
Xteam_07_39 vssd1 vssd1 vccd1 vccd1 team_07_39/HI gpio_oeb[17] sky130_fd_sc_hd__conb_1
XANTENNA__0936__S _0447_ vssd1 vssd1 vccd1 vccd1 sky130_fd_sc_hd__diode_2
XFILLER_33_19 vssd1 vssd1 vccd1 vccd1 sky130_fd_sc_hd__fill_1
X_0969_ clknet_3_4__leaf_clk _0015_ net31 vssd1 vssd1 vccd1 vccd1 MATMULT_INST.prod_adder.gen_for_loop\[1\].adder_n.a
+ sky130_fd_sc_hd__dfstp_1
XFILLER_15_249 vssd1 vssd1 vccd1 vccd1 sky130_fd_sc_hd__fill_1
XFILLER_2_197 vccd1 vssd1 vccd1 vssd1 sky130_ef_sc_hd__decap_40_12
XFILLER_0_34 vssd1 vssd1 vccd1 vccd1 sky130_fd_sc_hd__fill_4
XTAP_TAPCELL_ROW_31_225 vssd1 vccd1 sky130_fd_sc_hd__tapvpwrvgnd_1
X_0754_ net115 _0321_ _0324_ vssd1 vssd1 vccd1 vccd1 _0000_ sky130_fd_sc_hd__nor3_1
X_0823_ _0372_ _0373_ _0374_ _0330_ net112 vssd1 vssd1 vccd1 vccd1 _0020_ sky130_fd_sc_hd__a32o_1
X_0685_ _0067_ _0256_ vssd1 vssd1 vccd1 vccd1 _0260_ sky130_fd_sc_hd__or2_1
XFILLER_34_40 vssd1 vssd1 vccd1 vccd1 sky130_fd_sc_hd__fill_1
XFILLER_18_96 vssd1 vssd1 vccd1 vccd1 sky130_fd_sc_hd__fill_1
X_0470_ MATMULT_INST.uart_rcv.tim.bit_cnt\[1\] MATMULT_INST.uart_rcv.tim.bit_cnt\[0\]
+ net24 vssd1 vssd1 vccd1 vccd1 _0083_ sky130_fd_sc_hd__and3_1
X_1022_ clknet_3_4__leaf_clk _0045_ net31 vssd1 vssd1 vccd1 vccd1 MATMULT_INST.prod_adder.gen_for_loop\[1\].adder_n.b
+ sky130_fd_sc_hd__dfstp_1
X_0668_ net14 _0213_ _0241_ _0242_ _0245_ vssd1 vssd1 vccd1 vccd1 _0246_ sky130_fd_sc_hd__a2111o_1
X_0737_ MATMULT_INST.uart_tx.tx_ctrl.state\[2\] MATMULT_INST.uart_tx.tx_ctrl.state\[3\]
+ _0263_ vssd1 vssd1 vccd1 vccd1 _0311_ sky130_fd_sc_hd__or3_1
X_0806_ MATMULT_INST.parallel_out1\[5\] MATMULT_INST.parallel_out1\[2\] _0344_ _0343_
+ vssd1 vssd1 vccd1 vccd1 _0360_ sky130_fd_sc_hd__a31o_1
X_0599_ net14 MATMULT_INST.uart_rcv.tim.clk_cnt\[4\] vssd1 vssd1 vccd1 vccd1 _0191_
+ sky130_fd_sc_hd__xnor2_1
XFILLER_4_248 vssd1 vssd1 vccd1 vccd1 sky130_fd_sc_hd__fill_1
XFILLER_29_40 vccd1 vssd1 vccd1 vssd1 sky130_ef_sc_hd__decap_40_12
XFILLER_28_182 vssd1 vssd1 vccd1 vccd1 sky130_fd_sc_hd__fill_2
XFILLER_29_95 vssd1 vssd1 vccd1 vccd1 sky130_fd_sc_hd__fill_2
X_0522_ MATMULT_INST.uart_tx.clk_cnt\[0\] MATMULT_INST.uart_tx.clk_cnt\[1\] vssd1
+ vssd1 vccd1 vccd1 _0129_ sky130_fd_sc_hd__or2_1
X_0453_ MATMULT_INST.cntrl.state\[2\] vssd1 vssd1 vccd1 vccd1 _0066_ sky130_fd_sc_hd__inv_2
XFILLER_26_119 vssd1 vssd1 vccd1 vccd1 sky130_fd_sc_hd__fill_2
XFILLER_34_141 vssd1 vssd1 vccd1 vccd1 sky130_fd_sc_hd__fill_8
X_1005_ clknet_3_2__leaf_clk MATMULT_INST.uart_rcv.tim.clock_count.next_cnt_out\[3\]
+ net28 vssd1 vssd1 vccd1 vccd1 MATMULT_INST.uart_rcv.tim.clk_cnt\[3\] sky130_fd_sc_hd__dfrtp_1
XFILLER_25_130 vssd1 vssd1 vccd1 vccd1 sky130_fd_sc_hd__fill_1
XANTENNA__0764__S net24 vssd1 vssd1 vccd1 vccd1 sky130_fd_sc_hd__diode_2
XFILLER_16_185 vssd1 vssd1 vccd1 vccd1 sky130_fd_sc_hd__fill_8
XFILLER_31_111 vssd1 vssd1 vccd1 vccd1 sky130_fd_sc_hd__fill_1
X_0505_ net3 MATMULT_INST.uart_tx.clk_cnt\[8\] vssd1 vssd1 vccd1 vccd1 _0113_ sky130_fd_sc_hd__and2b_1
.ends
